* lvds_rx_x3.spice -- the LVS reference of the macro (gf180mcuD device names, pin order = Verilog ports), a copy of
* netlist/lvds_rx_lvs_ref.spice (sha256 e87902ae5471274bb1c62f05e42fc5ebb865eaa982bf160ad5a97e9635c3dd99), which the delivered layout matched in strict Netgen LVS (T10/T11).
* lvds_rx_lvs_ref.spice -- LVS reference netlist of lvds_rx_x3 (hierarchical), gf180mcuD device names, total w with nf (Magic/Netgen style).
* GENERATED by netlist/gen_lvs_ref.py from netlist/lvds_circuit.py + layout/device_table.json -- do not edit by hand.
* flags: nmos_pair=1 dump_devices=1 extra_gain_stage=0 bias_constgm=0 failsafe=0 on_die_term=0
* Dummy devices (end fingers, guard/tap) are NOT here: the layout tasks (T8-T10) add them explicitly (Netgen merges parallel fingers, so dummies must be listed).
* Diodes use the PDK device names; the Vref cap is an nfet_03v3 with D = S = bulk = VSS (the way the layout draws it; the sim netlist keeps cap_nmos_03v3).

.subckt lvds_bias VDD VSS EN VBN VBP VB2 VREF
XMEN_P enb EN VDD VDD pfet_03v3 w=2.5u l=0.28u
XMEN_N enb EN VSS VSS nfet_03v3 w=1u l=0.28u
XMSW nrb enb VDD VDD pfet_03v3 w=40u nf=8 l=0.5u
XRRB nrb VBN VSS ppolyf_u_1k r_width=2u r_length=89.562u
XMBN VBN VBN VSS VSS nfet_03v3 w=12.5u nf=5 l=1u
XMPD_N VBN enb VSS VSS nfet_03v3 w=2u l=0.5u
XMBS VBP VBN VSS VSS nfet_03v3 w=12.5u nf=5 l=1u
XMBP VBP VBP VDD VDD pfet_03v3 w=55u nf=11 l=1u
XMPU_P VBP EN VDD VDD pfet_03v3 w=2u l=0.5u
XMB2P VB2 VBP VDD VDD pfet_03v3 w=20u nf=4 l=1u
XMB2 VB2 VB2 vf VSS nfet_03v3 w=7.91u l=0.5u
XRRF vf VSS VSS ppolyf_u_1k r_width=2u r_length=46.313u
XMPD_2 VB2 enb VSS VSS nfet_03v3 w=2u l=0.5u
XRRDT VDD VREF VSS ppolyf_u_1k r_width=2u r_length=84.531u
XRRDB VREF nmid VSS ppolyf_u_1k r_width=2u r_length=77.547u
XMVS nmid EN VSS VSS nfet_03v3 w=10u nf=2 l=0.5u
XCVREF VSS VREF VSS VSS nfet_03v3 w=20u l=25.13u
.ends lvds_bias

.subckt lvds_esd2 A B VDD VSS
XRESD A B VDD ppolyf_u r_width=5u r_length=1.8u
DDESD_H B VDD diode_pd2nw_03v3 area=40p pj=26u
DDESD_L VSS B diode_nd2ps_03v3 area=40p pj=26u
.ends lvds_esd2

.subckt lvds_pre VDD VSS INP INN VBN VBP VB2 VREF OA OB
XRLA VDD OA VSS ppolyf_u_1k r_width=2u r_length=18.395u
XRLB VDD OB VSS ppolyf_u_1k r_width=2u r_length=18.395u
XMPT tp VBP VDD VDD pfet_03v3 w=110u nf=22 l=1u
XMP1A fa INP tp tp pfet_03v3 w=105.6u nf=22 l=0.4u
XMP1B fb INN tp tp pfet_03v3 w=105.6u nf=22 l=0.4u
XMPDA fa VREF tp tp pfet_03v3 w=105.6u nf=22 l=0.4u
XMPDB fb VREF tp tp pfet_03v3 w=105.6u nf=22 l=0.4u
XM3A fa VBN VSS VSS nfet_03v3 w=30u nf=12 l=1u
XM3B fb VBN VSS VSS nfet_03v3 w=30u nf=12 l=1u
XM5A OA VB2 fa VSS nfet_03v3 w=31.64u nf=7 l=0.5u
XM5B OB VB2 fb VSS nfet_03v3 w=31.64u nf=7 l=0.5u
XMNT tn VBN VSS VSS nfet_03v3 w=25u nf=10 l=1u
XMN1A OA INP tn VSS nfet_03v3 w=47.5u nf=10 l=0.5u
XMN1B OB INN tn VSS nfet_03v3 w=47.5u nf=10 l=0.5u
XMNDA OA VREF tn VSS nfet_03v3 w=47.5u nf=10 l=0.5u
XMNDB OB VREF tn VSS nfet_03v3 w=47.5u nf=10 l=0.5u
.ends lvds_pre

.subckt lvds_hyst VDD VSS OA OB VBN EN D2A D2B
XMT2 ts VBN VSS VSS nfet_03v3 w=30u nf=12 l=1u
XMS1 D2A OA sa VSS nfet_03v3 w=8.74u nf=2 l=0.5u
XMS2 D2B OB sb VSS nfet_03v3 w=8.74u nf=2 l=0.5u
XRS1 sa ts VSS ppolyf_u_1k r_width=5u r_length=1.637u
XRS2 sb ts VSS ppolyf_u_1k r_width=5u r_length=1.637u
XMLD1 D2A D2A VDD VDD pfet_03v3 w=7.4u nf=4 l=0.28u
XMLD2 D2B D2B VDD VDD pfet_03v3 w=7.4u nf=4 l=0.28u
XMLC1 D2A D2B VDD VDD pfet_03v3 w=11.1u nf=6 l=0.28u
XMLC2 D2B D2A VDD VDD pfet_03v3 w=11.1u nf=6 l=0.28u
XMPU1 D2A EN VDD VDD pfet_03v3 w=2u l=0.5u
XMPU2 D2B EN VDD VDD pfet_03v3 w=2u l=0.5u
.ends lvds_hyst

.subckt lvds_out VDD VSS D2A D2B EN OUT
XMP3A n3a D2A VDD VDD pfet_03v3 w=14.8u nf=8 l=0.28u
XMP3B d3 D2B VDD VDD pfet_03v3 w=14.8u nf=8 l=0.28u
XMN3A n3a n3a VSS VSS nfet_03v3 w=4.66u l=0.28u
XMN3B d3 n3a VSS VSS nfet_03v3 w=4.66u l=0.28u
XMNANDP1 nd d3 VDD VDD pfet_03v3 w=3u l=0.28u
XMNANDP2 nd EN VDD VDD pfet_03v3 w=3u l=0.28u
XMNANDN1 nd d3 nm VSS nfet_03v3 w=2u l=0.28u
XMNANDN2 nm EN VSS VSS nfet_03v3 w=2u l=0.28u
XMINV1P i1 nd VDD VDD pfet_03v3 w=3.7u l=0.28u
XMINV1N i1 nd VSS VSS nfet_03v3 w=1.5u l=0.28u
XMINV2P i2 i1 VDD VDD pfet_03v3 w=7.5u nf=2 l=0.28u
XMINV2N i2 i1 VSS VSS nfet_03v3 w=3u l=0.28u
XMINV3P OUT i2 VDD VDD pfet_03v3 w=20u nf=4 l=0.28u
XMINV3N OUT i2 VSS VSS nfet_03v3 w=8u nf=2 l=0.28u
.ends lvds_out

.subckt lvds_lane VDD VSS INP INN EN VBN VBP VB2 VREF OUT
XESDP INP gp VDD VSS lvds_esd2
XESDN INN gn VDD VSS lvds_esd2
XPRE VDD VSS gp gn VBN VBP VB2 VREF oa ob lvds_pre
XHYST VDD VSS oa ob VBN EN d2a d2b lvds_hyst
XOUT VDD VSS d2a d2b EN OUT lvds_out
.ends lvds_lane

.subckt lvds_rx_x3 VDD VSS RX0_P RX0_N RX1_P RX1_N RX2_P RX2_N EN RX0_O RX1_O RX2_O
XBIAS VDD VSS EN vbn vbp vb2 vref lvds_bias
XL0 VDD VSS RX0_P RX0_N EN vbn vbp vb2 vref RX0_O lvds_lane
XL1 VDD VSS RX1_P RX1_N EN vbn vbp vb2 vref RX1_O lvds_lane
XL2 VDD VSS RX2_P RX2_N EN vbn vbp vb2 vref RX2_O lvds_lane
.ends lvds_rx_x3
