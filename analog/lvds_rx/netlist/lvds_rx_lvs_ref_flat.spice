* lvds_rx_lvs_ref.spice -- LVS reference netlist of lvds_rx_x3 (flat), gf180mcuD device names, total w with nf (Magic/Netgen style).
* GENERATED by netlist/gen_lvs_ref.py from netlist/lvds_circuit.py + layout/device_table.json -- do not edit by hand.
* flags: nmos_pair=1 dump_devices=1 extra_gain_stage=0 bias_constgm=0 failsafe=0 on_die_term=0
* Dummy devices (end fingers, guard/tap) are NOT here: the layout tasks (T8-T10) add them explicitly (Netgen merges parallel fingers, so dummies must be listed).
* Diodes use the PDK device names; the Vref cap is an nfet_03v3 with D = S = bulk = VSS (the way the layout draws it; the sim netlist keeps cap_nmos_03v3).

.subckt lvds_rx_x3 VDD VSS RX0_P RX0_N RX1_P RX1_N RX2_P RX2_N EN RX0_O RX1_O RX2_O
XXBIAS.MEN_P xbias.enb EN VDD VDD pfet_03v3 w=2.5u l=0.28u
XXBIAS.MEN_N xbias.enb EN VSS VSS nfet_03v3 w=1u l=0.28u
XXBIAS.MSW xbias.nrb xbias.enb VDD VDD pfet_03v3 w=40u nf=8 l=0.5u
XXBIAS.RRB xbias.nrb vbn VSS ppolyf_u_1k r_width=2u r_length=89.562u
XXBIAS.MBN vbn vbn VSS VSS nfet_03v3 w=12.5u nf=5 l=1u
XXBIAS.MPD_N vbn xbias.enb VSS VSS nfet_03v3 w=2u l=0.5u
XXBIAS.MBS vbp vbn VSS VSS nfet_03v3 w=12.5u nf=5 l=1u
XXBIAS.MBP vbp vbp VDD VDD pfet_03v3 w=55u nf=11 l=1u
XXBIAS.MPU_P vbp EN VDD VDD pfet_03v3 w=2u l=0.5u
XXBIAS.MB2P vb2 vbp VDD VDD pfet_03v3 w=20u nf=4 l=1u
XXBIAS.MB2 vb2 vb2 xbias.vf VSS nfet_03v3 w=7.91u l=0.5u
XXBIAS.RRF xbias.vf VSS VSS ppolyf_u_1k r_width=2u r_length=46.313u
XXBIAS.MPD_2 vb2 xbias.enb VSS VSS nfet_03v3 w=2u l=0.5u
XXBIAS.RRDT VDD vref VSS ppolyf_u_1k r_width=2u r_length=84.531u
XXBIAS.RRDB vref xbias.nmid VSS ppolyf_u_1k r_width=2u r_length=77.547u
XXBIAS.MVS xbias.nmid EN VSS VSS nfet_03v3 w=10u nf=2 l=0.5u
XXBIAS.CVREF VSS vref VSS VSS nfet_03v3 w=20u l=25.13u
XXL0.XESDP.RESD RX0_P xl0.gp VDD ppolyf_u r_width=5u r_length=1.8u
DXL0.XESDP.DESD_H xl0.gp VDD diode_pd2nw_03v3 area=40p pj=26u
DXL0.XESDP.DESD_L VSS xl0.gp diode_nd2ps_03v3 area=40p pj=26u
XXL0.XESDN.RESD RX0_N xl0.gn VDD ppolyf_u r_width=5u r_length=1.8u
DXL0.XESDN.DESD_H xl0.gn VDD diode_pd2nw_03v3 area=40p pj=26u
DXL0.XESDN.DESD_L VSS xl0.gn diode_nd2ps_03v3 area=40p pj=26u
XXL0.XPRE.RLA VDD xl0.oa VSS ppolyf_u_1k r_width=2u r_length=18.395u
XXL0.XPRE.RLB VDD xl0.ob VSS ppolyf_u_1k r_width=2u r_length=18.395u
XXL0.XPRE.MPT xl0.xpre.tp vbp VDD VDD pfet_03v3 w=110u nf=22 l=1u
XXL0.XPRE.MP1A xl0.xpre.fa xl0.gp xl0.xpre.tp xl0.xpre.tp pfet_03v3 w=105.6u nf=22 l=0.4u
XXL0.XPRE.MP1B xl0.xpre.fb xl0.gn xl0.xpre.tp xl0.xpre.tp pfet_03v3 w=105.6u nf=22 l=0.4u
XXL0.XPRE.MPDA xl0.xpre.fa vref xl0.xpre.tp xl0.xpre.tp pfet_03v3 w=105.6u nf=22 l=0.4u
XXL0.XPRE.MPDB xl0.xpre.fb vref xl0.xpre.tp xl0.xpre.tp pfet_03v3 w=105.6u nf=22 l=0.4u
XXL0.XPRE.M3A xl0.xpre.fa vbn VSS VSS nfet_03v3 w=30u nf=12 l=1u
XXL0.XPRE.M3B xl0.xpre.fb vbn VSS VSS nfet_03v3 w=30u nf=12 l=1u
XXL0.XPRE.M5A xl0.oa vb2 xl0.xpre.fa VSS nfet_03v3 w=31.64u nf=7 l=0.5u
XXL0.XPRE.M5B xl0.ob vb2 xl0.xpre.fb VSS nfet_03v3 w=31.64u nf=7 l=0.5u
XXL0.XPRE.MNT xl0.xpre.tn vbn VSS VSS nfet_03v3 w=25u nf=10 l=1u
XXL0.XPRE.MN1A xl0.oa xl0.gp xl0.xpre.tn VSS nfet_03v3 w=47.5u nf=10 l=0.5u
XXL0.XPRE.MN1B xl0.ob xl0.gn xl0.xpre.tn VSS nfet_03v3 w=47.5u nf=10 l=0.5u
XXL0.XPRE.MNDA xl0.oa vref xl0.xpre.tn VSS nfet_03v3 w=47.5u nf=10 l=0.5u
XXL0.XPRE.MNDB xl0.ob vref xl0.xpre.tn VSS nfet_03v3 w=47.5u nf=10 l=0.5u
XXL0.XHYST.MT2 xl0.xhyst.ts vbn VSS VSS nfet_03v3 w=30u nf=12 l=1u
XXL0.XHYST.MS1 xl0.d2a xl0.oa xl0.xhyst.sa VSS nfet_03v3 w=8.74u nf=2 l=0.5u
XXL0.XHYST.MS2 xl0.d2b xl0.ob xl0.xhyst.sb VSS nfet_03v3 w=8.74u nf=2 l=0.5u
XXL0.XHYST.RS1 xl0.xhyst.sa xl0.xhyst.ts VSS ppolyf_u_1k r_width=5u r_length=1.637u
XXL0.XHYST.RS2 xl0.xhyst.sb xl0.xhyst.ts VSS ppolyf_u_1k r_width=5u r_length=1.637u
XXL0.XHYST.MLD1 xl0.d2a xl0.d2a VDD VDD pfet_03v3 w=7.4u nf=4 l=0.28u
XXL0.XHYST.MLD2 xl0.d2b xl0.d2b VDD VDD pfet_03v3 w=7.4u nf=4 l=0.28u
XXL0.XHYST.MLC1 xl0.d2a xl0.d2b VDD VDD pfet_03v3 w=11.1u nf=6 l=0.28u
XXL0.XHYST.MLC2 xl0.d2b xl0.d2a VDD VDD pfet_03v3 w=11.1u nf=6 l=0.28u
XXL0.XHYST.MPU1 xl0.d2a EN VDD VDD pfet_03v3 w=2u l=0.5u
XXL0.XHYST.MPU2 xl0.d2b EN VDD VDD pfet_03v3 w=2u l=0.5u
XXL0.XOUT.MP3A xl0.xout.n3a xl0.d2a VDD VDD pfet_03v3 w=14.8u nf=8 l=0.28u
XXL0.XOUT.MP3B xl0.xout.d3 xl0.d2b VDD VDD pfet_03v3 w=14.8u nf=8 l=0.28u
XXL0.XOUT.MN3A xl0.xout.n3a xl0.xout.n3a VSS VSS nfet_03v3 w=4.66u l=0.28u
XXL0.XOUT.MN3B xl0.xout.d3 xl0.xout.n3a VSS VSS nfet_03v3 w=4.66u l=0.28u
XXL0.XOUT.MNANDP1 xl0.xout.nd xl0.xout.d3 VDD VDD pfet_03v3 w=3u l=0.28u
XXL0.XOUT.MNANDP2 xl0.xout.nd EN VDD VDD pfet_03v3 w=3u l=0.28u
XXL0.XOUT.MNANDN1 xl0.xout.nd xl0.xout.d3 xl0.xout.nm VSS nfet_03v3 w=2u l=0.28u
XXL0.XOUT.MNANDN2 xl0.xout.nm EN VSS VSS nfet_03v3 w=2u l=0.28u
XXL0.XOUT.MINV1P xl0.xout.i1 xl0.xout.nd VDD VDD pfet_03v3 w=3.7u l=0.28u
XXL0.XOUT.MINV1N xl0.xout.i1 xl0.xout.nd VSS VSS nfet_03v3 w=1.5u l=0.28u
XXL0.XOUT.MINV2P xl0.xout.i2 xl0.xout.i1 VDD VDD pfet_03v3 w=7.5u nf=2 l=0.28u
XXL0.XOUT.MINV2N xl0.xout.i2 xl0.xout.i1 VSS VSS nfet_03v3 w=3u l=0.28u
XXL0.XOUT.MINV3P RX0_O xl0.xout.i2 VDD VDD pfet_03v3 w=20u nf=4 l=0.28u
XXL0.XOUT.MINV3N RX0_O xl0.xout.i2 VSS VSS nfet_03v3 w=8u nf=2 l=0.28u
XXL1.XESDP.RESD RX1_P xl1.gp VDD ppolyf_u r_width=5u r_length=1.8u
DXL1.XESDP.DESD_H xl1.gp VDD diode_pd2nw_03v3 area=40p pj=26u
DXL1.XESDP.DESD_L VSS xl1.gp diode_nd2ps_03v3 area=40p pj=26u
XXL1.XESDN.RESD RX1_N xl1.gn VDD ppolyf_u r_width=5u r_length=1.8u
DXL1.XESDN.DESD_H xl1.gn VDD diode_pd2nw_03v3 area=40p pj=26u
DXL1.XESDN.DESD_L VSS xl1.gn diode_nd2ps_03v3 area=40p pj=26u
XXL1.XPRE.RLA VDD xl1.oa VSS ppolyf_u_1k r_width=2u r_length=18.395u
XXL1.XPRE.RLB VDD xl1.ob VSS ppolyf_u_1k r_width=2u r_length=18.395u
XXL1.XPRE.MPT xl1.xpre.tp vbp VDD VDD pfet_03v3 w=110u nf=22 l=1u
XXL1.XPRE.MP1A xl1.xpre.fa xl1.gp xl1.xpre.tp xl1.xpre.tp pfet_03v3 w=105.6u nf=22 l=0.4u
XXL1.XPRE.MP1B xl1.xpre.fb xl1.gn xl1.xpre.tp xl1.xpre.tp pfet_03v3 w=105.6u nf=22 l=0.4u
XXL1.XPRE.MPDA xl1.xpre.fa vref xl1.xpre.tp xl1.xpre.tp pfet_03v3 w=105.6u nf=22 l=0.4u
XXL1.XPRE.MPDB xl1.xpre.fb vref xl1.xpre.tp xl1.xpre.tp pfet_03v3 w=105.6u nf=22 l=0.4u
XXL1.XPRE.M3A xl1.xpre.fa vbn VSS VSS nfet_03v3 w=30u nf=12 l=1u
XXL1.XPRE.M3B xl1.xpre.fb vbn VSS VSS nfet_03v3 w=30u nf=12 l=1u
XXL1.XPRE.M5A xl1.oa vb2 xl1.xpre.fa VSS nfet_03v3 w=31.64u nf=7 l=0.5u
XXL1.XPRE.M5B xl1.ob vb2 xl1.xpre.fb VSS nfet_03v3 w=31.64u nf=7 l=0.5u
XXL1.XPRE.MNT xl1.xpre.tn vbn VSS VSS nfet_03v3 w=25u nf=10 l=1u
XXL1.XPRE.MN1A xl1.oa xl1.gp xl1.xpre.tn VSS nfet_03v3 w=47.5u nf=10 l=0.5u
XXL1.XPRE.MN1B xl1.ob xl1.gn xl1.xpre.tn VSS nfet_03v3 w=47.5u nf=10 l=0.5u
XXL1.XPRE.MNDA xl1.oa vref xl1.xpre.tn VSS nfet_03v3 w=47.5u nf=10 l=0.5u
XXL1.XPRE.MNDB xl1.ob vref xl1.xpre.tn VSS nfet_03v3 w=47.5u nf=10 l=0.5u
XXL1.XHYST.MT2 xl1.xhyst.ts vbn VSS VSS nfet_03v3 w=30u nf=12 l=1u
XXL1.XHYST.MS1 xl1.d2a xl1.oa xl1.xhyst.sa VSS nfet_03v3 w=8.74u nf=2 l=0.5u
XXL1.XHYST.MS2 xl1.d2b xl1.ob xl1.xhyst.sb VSS nfet_03v3 w=8.74u nf=2 l=0.5u
XXL1.XHYST.RS1 xl1.xhyst.sa xl1.xhyst.ts VSS ppolyf_u_1k r_width=5u r_length=1.637u
XXL1.XHYST.RS2 xl1.xhyst.sb xl1.xhyst.ts VSS ppolyf_u_1k r_width=5u r_length=1.637u
XXL1.XHYST.MLD1 xl1.d2a xl1.d2a VDD VDD pfet_03v3 w=7.4u nf=4 l=0.28u
XXL1.XHYST.MLD2 xl1.d2b xl1.d2b VDD VDD pfet_03v3 w=7.4u nf=4 l=0.28u
XXL1.XHYST.MLC1 xl1.d2a xl1.d2b VDD VDD pfet_03v3 w=11.1u nf=6 l=0.28u
XXL1.XHYST.MLC2 xl1.d2b xl1.d2a VDD VDD pfet_03v3 w=11.1u nf=6 l=0.28u
XXL1.XHYST.MPU1 xl1.d2a EN VDD VDD pfet_03v3 w=2u l=0.5u
XXL1.XHYST.MPU2 xl1.d2b EN VDD VDD pfet_03v3 w=2u l=0.5u
XXL1.XOUT.MP3A xl1.xout.n3a xl1.d2a VDD VDD pfet_03v3 w=14.8u nf=8 l=0.28u
XXL1.XOUT.MP3B xl1.xout.d3 xl1.d2b VDD VDD pfet_03v3 w=14.8u nf=8 l=0.28u
XXL1.XOUT.MN3A xl1.xout.n3a xl1.xout.n3a VSS VSS nfet_03v3 w=4.66u l=0.28u
XXL1.XOUT.MN3B xl1.xout.d3 xl1.xout.n3a VSS VSS nfet_03v3 w=4.66u l=0.28u
XXL1.XOUT.MNANDP1 xl1.xout.nd xl1.xout.d3 VDD VDD pfet_03v3 w=3u l=0.28u
XXL1.XOUT.MNANDP2 xl1.xout.nd EN VDD VDD pfet_03v3 w=3u l=0.28u
XXL1.XOUT.MNANDN1 xl1.xout.nd xl1.xout.d3 xl1.xout.nm VSS nfet_03v3 w=2u l=0.28u
XXL1.XOUT.MNANDN2 xl1.xout.nm EN VSS VSS nfet_03v3 w=2u l=0.28u
XXL1.XOUT.MINV1P xl1.xout.i1 xl1.xout.nd VDD VDD pfet_03v3 w=3.7u l=0.28u
XXL1.XOUT.MINV1N xl1.xout.i1 xl1.xout.nd VSS VSS nfet_03v3 w=1.5u l=0.28u
XXL1.XOUT.MINV2P xl1.xout.i2 xl1.xout.i1 VDD VDD pfet_03v3 w=7.5u nf=2 l=0.28u
XXL1.XOUT.MINV2N xl1.xout.i2 xl1.xout.i1 VSS VSS nfet_03v3 w=3u l=0.28u
XXL1.XOUT.MINV3P RX1_O xl1.xout.i2 VDD VDD pfet_03v3 w=20u nf=4 l=0.28u
XXL1.XOUT.MINV3N RX1_O xl1.xout.i2 VSS VSS nfet_03v3 w=8u nf=2 l=0.28u
XXL2.XESDP.RESD RX2_P xl2.gp VDD ppolyf_u r_width=5u r_length=1.8u
DXL2.XESDP.DESD_H xl2.gp VDD diode_pd2nw_03v3 area=40p pj=26u
DXL2.XESDP.DESD_L VSS xl2.gp diode_nd2ps_03v3 area=40p pj=26u
XXL2.XESDN.RESD RX2_N xl2.gn VDD ppolyf_u r_width=5u r_length=1.8u
DXL2.XESDN.DESD_H xl2.gn VDD diode_pd2nw_03v3 area=40p pj=26u
DXL2.XESDN.DESD_L VSS xl2.gn diode_nd2ps_03v3 area=40p pj=26u
XXL2.XPRE.RLA VDD xl2.oa VSS ppolyf_u_1k r_width=2u r_length=18.395u
XXL2.XPRE.RLB VDD xl2.ob VSS ppolyf_u_1k r_width=2u r_length=18.395u
XXL2.XPRE.MPT xl2.xpre.tp vbp VDD VDD pfet_03v3 w=110u nf=22 l=1u
XXL2.XPRE.MP1A xl2.xpre.fa xl2.gp xl2.xpre.tp xl2.xpre.tp pfet_03v3 w=105.6u nf=22 l=0.4u
XXL2.XPRE.MP1B xl2.xpre.fb xl2.gn xl2.xpre.tp xl2.xpre.tp pfet_03v3 w=105.6u nf=22 l=0.4u
XXL2.XPRE.MPDA xl2.xpre.fa vref xl2.xpre.tp xl2.xpre.tp pfet_03v3 w=105.6u nf=22 l=0.4u
XXL2.XPRE.MPDB xl2.xpre.fb vref xl2.xpre.tp xl2.xpre.tp pfet_03v3 w=105.6u nf=22 l=0.4u
XXL2.XPRE.M3A xl2.xpre.fa vbn VSS VSS nfet_03v3 w=30u nf=12 l=1u
XXL2.XPRE.M3B xl2.xpre.fb vbn VSS VSS nfet_03v3 w=30u nf=12 l=1u
XXL2.XPRE.M5A xl2.oa vb2 xl2.xpre.fa VSS nfet_03v3 w=31.64u nf=7 l=0.5u
XXL2.XPRE.M5B xl2.ob vb2 xl2.xpre.fb VSS nfet_03v3 w=31.64u nf=7 l=0.5u
XXL2.XPRE.MNT xl2.xpre.tn vbn VSS VSS nfet_03v3 w=25u nf=10 l=1u
XXL2.XPRE.MN1A xl2.oa xl2.gp xl2.xpre.tn VSS nfet_03v3 w=47.5u nf=10 l=0.5u
XXL2.XPRE.MN1B xl2.ob xl2.gn xl2.xpre.tn VSS nfet_03v3 w=47.5u nf=10 l=0.5u
XXL2.XPRE.MNDA xl2.oa vref xl2.xpre.tn VSS nfet_03v3 w=47.5u nf=10 l=0.5u
XXL2.XPRE.MNDB xl2.ob vref xl2.xpre.tn VSS nfet_03v3 w=47.5u nf=10 l=0.5u
XXL2.XHYST.MT2 xl2.xhyst.ts vbn VSS VSS nfet_03v3 w=30u nf=12 l=1u
XXL2.XHYST.MS1 xl2.d2a xl2.oa xl2.xhyst.sa VSS nfet_03v3 w=8.74u nf=2 l=0.5u
XXL2.XHYST.MS2 xl2.d2b xl2.ob xl2.xhyst.sb VSS nfet_03v3 w=8.74u nf=2 l=0.5u
XXL2.XHYST.RS1 xl2.xhyst.sa xl2.xhyst.ts VSS ppolyf_u_1k r_width=5u r_length=1.637u
XXL2.XHYST.RS2 xl2.xhyst.sb xl2.xhyst.ts VSS ppolyf_u_1k r_width=5u r_length=1.637u
XXL2.XHYST.MLD1 xl2.d2a xl2.d2a VDD VDD pfet_03v3 w=7.4u nf=4 l=0.28u
XXL2.XHYST.MLD2 xl2.d2b xl2.d2b VDD VDD pfet_03v3 w=7.4u nf=4 l=0.28u
XXL2.XHYST.MLC1 xl2.d2a xl2.d2b VDD VDD pfet_03v3 w=11.1u nf=6 l=0.28u
XXL2.XHYST.MLC2 xl2.d2b xl2.d2a VDD VDD pfet_03v3 w=11.1u nf=6 l=0.28u
XXL2.XHYST.MPU1 xl2.d2a EN VDD VDD pfet_03v3 w=2u l=0.5u
XXL2.XHYST.MPU2 xl2.d2b EN VDD VDD pfet_03v3 w=2u l=0.5u
XXL2.XOUT.MP3A xl2.xout.n3a xl2.d2a VDD VDD pfet_03v3 w=14.8u nf=8 l=0.28u
XXL2.XOUT.MP3B xl2.xout.d3 xl2.d2b VDD VDD pfet_03v3 w=14.8u nf=8 l=0.28u
XXL2.XOUT.MN3A xl2.xout.n3a xl2.xout.n3a VSS VSS nfet_03v3 w=4.66u l=0.28u
XXL2.XOUT.MN3B xl2.xout.d3 xl2.xout.n3a VSS VSS nfet_03v3 w=4.66u l=0.28u
XXL2.XOUT.MNANDP1 xl2.xout.nd xl2.xout.d3 VDD VDD pfet_03v3 w=3u l=0.28u
XXL2.XOUT.MNANDP2 xl2.xout.nd EN VDD VDD pfet_03v3 w=3u l=0.28u
XXL2.XOUT.MNANDN1 xl2.xout.nd xl2.xout.d3 xl2.xout.nm VSS nfet_03v3 w=2u l=0.28u
XXL2.XOUT.MNANDN2 xl2.xout.nm EN VSS VSS nfet_03v3 w=2u l=0.28u
XXL2.XOUT.MINV1P xl2.xout.i1 xl2.xout.nd VDD VDD pfet_03v3 w=3.7u l=0.28u
XXL2.XOUT.MINV1N xl2.xout.i1 xl2.xout.nd VSS VSS nfet_03v3 w=1.5u l=0.28u
XXL2.XOUT.MINV2P xl2.xout.i2 xl2.xout.i1 VDD VDD pfet_03v3 w=7.5u nf=2 l=0.28u
XXL2.XOUT.MINV2N xl2.xout.i2 xl2.xout.i1 VSS VSS nfet_03v3 w=3u l=0.28u
XXL2.XOUT.MINV3P RX2_O xl2.xout.i2 VDD VDD pfet_03v3 w=20u nf=4 l=0.28u
XXL2.XOUT.MINV3N RX2_O xl2.xout.i2 VSS VSS nfet_03v3 w=8u nf=2 l=0.28u
.ends lvds_rx_x3
