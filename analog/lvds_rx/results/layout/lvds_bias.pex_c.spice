* lvds_bias: parasitic C on all nets (coupling and to substrate, cthresh 0)
* GENERATED by layout/macro/run_macro.py (T10) from a GDS with sha256 f987143e7df435a94103da28642f30e302a3f65e7be0a58e1566a452c4ca446f -- do not edit by hand.
* Ports in the order of subckt lvds_bias of netlist/lvds_rx_lvs_ref.spice (Magic's own order was: EN VBN VB2 VREF VBP VDD VSS).
* NGSPICE file created from lvds_bias.ext - technology: gf180mcuD

.subckt lvds_bias VDD VSS EN VBN VBP VB2 VREF
X0 VBP VDD VDD VDD pfet_03v3 ad=0.52p pd=2.52u as=0.88p ps=4.88u w=2u l=0.5u
X1 nrb.0 enb.0 VDD VDD pfet_03v3 ad=1.3p pd=5.52u as=1.3p ps=5.52u w=5u l=0.5u
X2 VSS VSS VBP VSS nfet_03v3 ad=1.1p pd=5.88u as=0.65p ps=3.02u w=2.5u l=1u
X3 VBP VBP VDD VDD pfet_03v3 ad=1.3p pd=5.52u as=1.3p ps=5.52u w=5u l=1u
X4 VBP VBP VDD VDD pfet_03v3 ad=1.3p pd=5.52u as=1.3p ps=5.52u w=5u l=1u
X5 VREF rdb_m1.0 VSS ppolyf_u_1k r_width=2u r_length=19.26u
X6 VB2 VBP VDD VDD pfet_03v3 ad=1.3p pd=5.52u as=1.3p ps=5.52u w=5u l=1u
X7 VSS enb.0 VB2 VSS nfet_03v3 ad=0.52p pd=2.52u as=0.52p ps=2.52u w=2u l=0.5u
X8 nmid.0 EN VSS VSS nfet_03v3 ad=1.3p pd=5.52u as=1.3p ps=5.52u w=5u l=0.5u
X9 VSS VSS VSS ppolyf_u_1k r_width=2u r_length=21.01u
X10 VBN VBN VSS VSS nfet_03v3 ad=0.65p pd=3.02u as=0.65p ps=3.02u w=2.5u l=1u
X11 VDD VBP VBP VDD pfet_03v3 ad=1.3p pd=5.52u as=1.3p ps=5.52u w=5u l=1u
X12 nrb.0 enb.0 VDD VDD pfet_03v3 ad=1.3p pd=5.52u as=1.3p ps=5.52u w=5u l=0.5u
X13 VSS VBN VBP VSS nfet_03v3 ad=0.65p pd=3.02u as=0.65p ps=3.02u w=2.5u l=1u
X14 VDD rdt_m1.0 VSS ppolyf_u_1k r_width=2u r_length=21.01u
X15 VREF rdt_m3.0 VSS ppolyf_u_1k r_width=2u r_length=21.01u
X16 nrb.0 VDD VDD VDD pfet_03v3 ad=1.3p pd=5.52u as=2.2p ps=10.88u w=5u l=0.5u
X17 VSS EN enb.0 VSS nfet_03v3 ad=0.44p pd=2.88u as=0.44p ps=2.88u w=1u l=0.28u
X18 VSS VBN VBN VSS nfet_03v3 ad=0.65p pd=3.02u as=0.65p ps=3.02u w=2.5u l=1u
X19 VDD VDD VDD VDD pfet_03v3 ad=0.52p pd=2.52u as=46.3p ps=0.2086m w=2u l=0.5u
X20 nrb.0 enb.0 VDD VDD pfet_03v3 ad=1.3p pd=5.52u as=1.3p ps=5.52u w=5u l=0.5u
X21 VSS VSS VSS ppolyf_u_1k r_width=2u r_length=23.07u
X22 VSS VSS VSS ppolyf_u_1k r_width=2u r_length=21.01u
X23 vf.0 VB2 VB2 VSS nfet_03v3 ad=2.0566p pd=8.43u as=2.0566p ps=8.43u w=7.91u l=0.5u
X24 VSS VSS VSS VSS nfet_03v3 ad=0.52p pd=2.52u as=46.3008p ps=0.2224m w=2u l=0.5u
X25 nmid.0 rdb_m3.0 VSS ppolyf_u_1k r_width=2u r_length=19.26u
X26 rf_m1.0 VSS VSS ppolyf_u_1k r_width=2u r_length=23.07u
X27 VDD VBP VBP VDD pfet_03v3 ad=1.3p pd=5.52u as=1.3p ps=5.52u w=5u l=1u
X28 VBP VDD VDD VDD pfet_03v3 ad=1.3p pd=5.52u as=2.2p ps=10.88u w=5u l=1u
X29 VB2 VBP VDD VDD pfet_03v3 ad=1.3p pd=5.52u as=1.3p ps=5.52u w=5u l=1u
X30 rdb_m2.0 rdb_m3.0 VSS ppolyf_u_1k r_width=2u r_length=19.26u
X31 rf_m1.0 vf.0 VSS ppolyf_u_1k r_width=2u r_length=23.07u
X32 VSS VREF VSS VSS nfet_03v3 ad=8.8p pd=40.88u as=0 ps=0 w=20u l=25.13u
X33 nrb.0 enb.0 VDD VDD pfet_03v3 ad=1.3p pd=5.52u as=1.3p ps=5.52u w=5u l=0.5u
X34 VSS VBN VBN VSS nfet_03v3 ad=0.65p pd=3.02u as=0.65p ps=3.02u w=2.5u l=1u
X35 VBN VSS VSS VSS nfet_03v3 ad=0.65p pd=3.02u as=1.1p ps=5.88u w=2.5u l=1u
X36 VDD enb.0 nrb.0 VDD pfet_03v3 ad=1.3p pd=5.52u as=1.3p ps=5.52u w=5u l=0.5u
X37 VSS VBN VBP VSS nfet_03v3 ad=0.65p pd=3.02u as=0.65p ps=3.02u w=2.5u l=1u
X38 VBN VSS VSS VSS nfet_03v3 ad=0.52p pd=2.52u as=0.88p ps=4.88u w=2u l=0.5u
X39 rdt_m2.0 rdt_m1.0 VSS ppolyf_u_1k r_width=2u r_length=21.01u
X40 VDD enb.0 nrb.0 VDD pfet_03v3 ad=1.3p pd=5.52u as=1.3p ps=5.52u w=5u l=0.5u
X41 rb_m3.0 rb_m2.0 VSS ppolyf_u_1k r_width=2u r_length=22.27u
X42 VDD VBP VBP VDD pfet_03v3 ad=1.3p pd=5.52u as=1.3p ps=5.52u w=5u l=1u
X43 VDD VDD VDD VDD pfet_03v3 ad=0.65p pd=3.02u as=0 ps=0 w=2.5u l=0.28u
X44 VDD VBP VBP VDD pfet_03v3 ad=1.3p pd=5.52u as=1.3p ps=5.52u w=5u l=1u
X45 VDD VBP VBP VDD pfet_03v3 ad=1.3p pd=5.52u as=1.3p ps=5.52u w=5u l=1u
X46 VDD VBP VB2 VDD pfet_03v3 ad=1.3p pd=5.52u as=1.3p ps=5.52u w=5u l=1u
X47 VSS EN nmid.0 VSS nfet_03v3 ad=1.3p pd=5.52u as=1.3p ps=5.52u w=5u l=0.5u
X48 VB2 VSS VSS VSS nfet_03v3 ad=2.0566p pd=8.43u as=3.4804p ps=16.7u w=7.91u l=0.5u
X49 VBP VBN VSS VSS nfet_03v3 ad=0.65p pd=3.02u as=0.65p ps=3.02u w=2.5u l=1u
X50 VBP VBP VDD VDD pfet_03v3 ad=1.3p pd=5.52u as=1.3p ps=5.52u w=5u l=1u
X51 VSS enb.0 VBN VSS nfet_03v3 ad=0.52p pd=2.52u as=0.52p ps=2.52u w=2u l=0.5u
X52 rdb_m2.0 rdb_m1.0 VSS ppolyf_u_1k r_width=2u r_length=19.26u
X53 VDD enb.0 nrb.0 VDD pfet_03v3 ad=1.3p pd=5.52u as=1.3p ps=5.52u w=5u l=0.5u
X54 rb_m3.0 VBN VSS ppolyf_u_1k r_width=2u r_length=22.27u
X55 VDD VDD nrb.0 VDD pfet_03v3 ad=2.2p pd=10.88u as=1.3p ps=5.52u w=5u l=0.5u
X56 VSS VBN VBN VSS nfet_03v3 ad=0.65p pd=3.02u as=0.65p ps=3.02u w=2.5u l=1u
X57 VBP VBN VSS VSS nfet_03v3 ad=0.65p pd=3.02u as=0.65p ps=3.02u w=2.5u l=1u
X58 VSS VSS VSS VSS nfet_03v3 ad=0.52p pd=2.52u as=0 ps=0 w=2u l=0.5u
X59 VDD EN VBP VDD pfet_03v3 ad=0.52p pd=2.52u as=0.52p ps=2.52u w=2u l=0.5u
X60 VSS VSS vf.0 VSS nfet_03v3 ad=3.4804p pd=16.7u as=2.0566p ps=8.43u w=7.91u l=0.5u
X61 VBN VBN VSS VSS nfet_03v3 ad=0.65p pd=3.02u as=0.65p ps=3.02u w=2.5u l=1u
X62 VDD VBP VBP VDD pfet_03v3 ad=1.3p pd=5.52u as=1.3p ps=5.52u w=5u l=1u
X63 VDD EN enb.0 VDD pfet_03v3 ad=0.65p pd=3.02u as=0.65p ps=3.02u w=2.5u l=0.28u
X64 rb_m1.0 rb_m2.0 VSS ppolyf_u_1k r_width=2u r_length=22.27u
X65 VBP VBP VDD VDD pfet_03v3 ad=1.3p pd=5.52u as=1.3p ps=5.52u w=5u l=1u
X66 VDD VDD VDD VDD pfet_03v3 ad=1.3p pd=5.52u as=0 ps=0 w=5u l=1u
X67 VSS VSS nmid.0 VSS nfet_03v3 ad=2.2p pd=10.88u as=1.3p ps=5.52u w=5u l=0.5u
X68 rdt_m2.0 rdt_m3.0 VSS ppolyf_u_1k r_width=2u r_length=21.01u
X69 VBP VBP VDD VDD pfet_03v3 ad=1.3p pd=5.52u as=1.3p ps=5.52u w=5u l=1u
X70 VDD VBP VB2 VDD pfet_03v3 ad=1.3p pd=5.52u as=1.3p ps=5.52u w=5u l=1u
X71 nmid.0 VSS VSS VSS nfet_03v3 ad=1.3p pd=5.52u as=2.2p ps=10.88u w=5u l=0.5u
X72 enb.0 VDD VDD VDD pfet_03v3 ad=0.65p pd=3.02u as=1.1p ps=5.88u w=2.5u l=0.28u
X73 VDD enb.0 nrb.0 VDD pfet_03v3 ad=1.3p pd=5.52u as=1.3p ps=5.52u w=5u l=0.5u
X74 rb_m1.0 nrb.0 VSS ppolyf_u_1k r_width=2u r_length=22.27u
X75 VB2 VSS VSS VSS nfet_03v3 ad=0.52p pd=2.52u as=0.88p ps=4.88u w=2u l=0.5u
X76 VBP VBN VSS VSS nfet_03v3 ad=0.65p pd=3.02u as=0.65p ps=3.02u w=2.5u l=1u
X77 VSS VSS VSS ppolyf_u_1k r_width=2u r_length=22.27u
C0 VB2 VBP 5.49406f
C1 rdt_m2.0 VREF 0.00293f
C2 nmid.0 rdb_m2.0 0.04228f
C3 nmid.0 VBN 0.11617f
C4 VDD vf.0 0.00294f
C5 rdt_m3.0 rdb_m1.0 0.22342f
C6 nmid.0 enb.0 0.71708f
C7 VBN EN 0.42317f
C8 EN enb.0 4.07467f
C9 rdt_m1.0 enb.0 0.0052f
C10 VBN rb_m2.0 0.03909f
C11 nmid.0 VBP 0.03404f
C12 VBP EN 0.30881f
C13 VB2 VREF 0.61553f
C14 VBN enb.0 0.30834f
C15 VBP VBN 7.55653f
C16 VBP enb.0 1.14704f
C17 nmid.0 VREF 0.97574f
C18 VB2 vf.0 0.92426f
C19 VREF rdb_m2.0 0.32236f
C20 VBN VREF 0.08546f
C21 VREF enb.0 0.19826f
C22 rdb_m3.0 rdt_m1.0 0.41833f
C23 nrb.0 VDD 5.10108f
C24 vf.0 EN 0.02265f
C25 VBP VREF 0.06866f
C26 vf.0 rb_m2.0 0.08519f
C27 rb_m3.0 rf_m1.0 0.04347f
C28 VBN vf.0 1.55879f
C29 rb_m1.0 EN 0.00905f
C30 vf.0 enb.0 1.18587f
C31 VBP vf.0 0.19894f
C32 rb_m1.0 enb.0 0
C33 VB2 nrb.0 0.03524f
C34 rb_m1.0 VBP 0
C35 nrb.0 EN 0.24322f
C36 rdt_m2.0 VDD 0.00209f
C37 nrb.0 rb_m2.0 0.03837f
C38 rdt_m3.0 rdt_m1.0 0.08167f
C39 nrb.0 VBN 0.04433f
C40 nrb.0 enb.0 0.83214f
C41 nrb.0 VBP 0.36239f
C42 VB2 VDD 6.36236f
C43 rb_m1.0 rb_m3.0 0.06955f
C44 nmid.0 VDD 0.17489f
C45 VDD EN 3.65306f
C46 rdt_m2.0 nmid.0 0.00432f
C47 VDD rdb_m2.0 0.00594f
C48 VDD VBN 3.33118f
C49 VDD enb.0 6.07954f
C50 nrb.0 vf.0 0.61512f
C51 VDD VBP 19.3494f
C52 rdt_m2.0 rdb_m2.0 0.37f
C53 VB2 nmid.0 0.91956f
C54 VB2 EN 2.209f
C55 VDD VREF 3.0865f
C56 VB2 VBN 0.22178f
C57 VB2 enb.0 2.1266f
C58 nmid.0 EN 0.59891f
C59 EN VSS 6.07921f
C60 VREF VSS 17.7947f
C61 VBN VSS 16.0669f
C62 VB2 VSS 8.37781f
C63 VBP VSS 8.58467f
C64 VDD VSS 80.3344f
C65 vf.0 VSS 3.00974f
C66 rb_m3.0 VSS 1.32997f
C67 rb_m2.0 VSS 1.18202f
C68 rb_m1.0 VSS 1.29823f
C69 rf_m1.0 VSS 1.40226f
C70 nrb.0 VSS 1.8844f
C71 rdb_m1.0 VSS 1.12023f
C72 rdt_m3.0 VSS 1.81265f
C73 rdb_m2.0 VSS 1.69441f
C74 rdb_m3.0 VSS 1.13703f
C75 rdt_m1.0 VSS 1.66241f
C76 rdt_m2.0 VSS 1.18196f
C77 nmid.0 VSS 4.17576f
C78 enb.0 VSS 8.45617f
.ends lvds_bias
