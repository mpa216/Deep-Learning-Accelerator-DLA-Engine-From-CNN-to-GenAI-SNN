* lvds_bias: parasitic C on all nets (coupling and to substrate, cthresh 0)
* GENERATED by layout/macro/run_macro.py (T10) from a GDS with sha256 138fad3bdf40bf766c92c38d885d53887c33eccab2c2a2e6204d930bb80b0d21 -- do not edit by hand.
* Ports in the order of subckt lvds_bias of netlist/lvds_rx_lvs_ref.spice (Magic's own order was: EN VBN VB2 VREF VBP VDD VSS).
* NGSPICE file created from lvds_bias.ext - technology: gf180mcuD

.subckt lvds_bias VDD VSS EN VBN VBP VB2 VREF
X0 VDD VBP VBP VDD pfet_03v3 ad=1.3p pd=5.52u as=1.3p ps=5.52u w=5u l=1u
X1 VREF rdt_m3.0 VSS ppolyf_u_1k r_width=2u r_length=21.01u
X2 VBP VDD VDD VDD pfet_03v3 ad=0.52p pd=2.52u as=0.88p ps=4.88u w=2u l=0.5u
X3 nrb.0 enb.0 VDD VDD pfet_03v3 ad=1.3p pd=5.52u as=1.3p ps=5.52u w=5u l=0.5u
X4 VSS VSS VBP VSS nfet_03v3 ad=1.1p pd=5.88u as=0.65p ps=3.02u w=2.5u l=1u
X5 VSS VSS VSS ppolyf_u_1k r_width=2u r_length=21.01u
X6 VSS VSS VSS ppolyf_u_1k r_width=2u r_length=23.07u
X7 VSS VSS VSS VSS nfet_03v3 ad=0.52p pd=2.52u as=46.3008p ps=0.2224m w=2u l=0.5u
X8 nmid.0 rdb_m3.0 VSS ppolyf_u_1k r_width=2u r_length=19.26u
X9 VBN VBN VSS VSS nfet_03v3 ad=0.65p pd=3.02u as=0.65p ps=3.02u w=2.5u l=1u
X10 rdb_m2.0 rdb_m3.0 VSS ppolyf_u_1k r_width=2u r_length=19.26u
X11 nrb.0 enb.0 VDD VDD pfet_03v3 ad=1.3p pd=5.52u as=1.3p ps=5.52u w=5u l=0.5u
X12 rf_m1.0 VSS VSS ppolyf_u_1k r_width=2u r_length=23.07u
X13 VSS VBN VBP VSS nfet_03v3 ad=0.65p pd=3.02u as=0.65p ps=3.02u w=2.5u l=1u
X14 VDD VBP VBP VDD pfet_03v3 ad=1.3p pd=5.52u as=1.3p ps=5.52u w=5u l=1u
X15 nrb.0 VDD VDD VDD pfet_03v3 ad=1.3p pd=5.52u as=2.2p ps=10.88u w=5u l=0.5u
X16 VSS EN enb.0 VSS nfet_03v3 ad=0.44p pd=2.88u as=0.44p ps=2.88u w=1u l=0.28u
X17 VSS VBN VBN VSS nfet_03v3 ad=0.65p pd=3.02u as=0.65p ps=3.02u w=2.5u l=1u
X18 VBP VDD VDD VDD pfet_03v3 ad=1.3p pd=5.52u as=2.2p ps=10.88u w=5u l=1u
X19 VB2 VBP VDD VDD pfet_03v3 ad=1.3p pd=5.52u as=1.3p ps=5.52u w=5u l=1u
X20 VDD VDD VDD VDD pfet_03v3 ad=0.52p pd=2.52u as=46.3p ps=0.2086m w=2u l=0.5u
X21 nrb.0 enb.0 VDD VDD pfet_03v3 ad=1.3p pd=5.52u as=1.3p ps=5.52u w=5u l=0.5u
X22 rf_m1.0 vf.0 VSS ppolyf_u_1k r_width=2u r_length=23.07u
X23 VSS VREF VSS VSS nfet_03v3 ad=8.8p pd=40.88u as=0 ps=0 w=20u l=25.13u
X24 vf.0 VB2 VB2 VSS nfet_03v3 ad=2.0566p pd=8.43u as=2.0566p ps=8.43u w=7.91u l=0.5u
X25 VBN VSS VSS VSS nfet_03v3 ad=0.52p pd=2.52u as=0.88p ps=4.88u w=2u l=0.5u
X26 rdt_m2.0 rdt_m1.0 VSS ppolyf_u_1k r_width=2u r_length=21.01u
X27 rb_m3.0 rb_m2.0 VSS ppolyf_u_1k r_width=2u r_length=22.27u
X28 VDD VBP VBP VDD pfet_03v3 ad=1.3p pd=5.52u as=1.3p ps=5.52u w=5u l=1u
X29 nrb.0 enb.0 VDD VDD pfet_03v3 ad=1.3p pd=5.52u as=1.3p ps=5.52u w=5u l=0.5u
X30 VSS VBN VBN VSS nfet_03v3 ad=0.65p pd=3.02u as=0.65p ps=3.02u w=2.5u l=1u
X31 VDD VBP VBP VDD pfet_03v3 ad=1.3p pd=5.52u as=1.3p ps=5.52u w=5u l=1u
X32 VDD VBP VBP VDD pfet_03v3 ad=1.3p pd=5.52u as=1.3p ps=5.52u w=5u l=1u
X33 VSS EN nmid.0 VSS nfet_03v3 ad=1.3p pd=5.52u as=1.3p ps=5.52u w=5u l=0.5u
X34 VBN VSS VSS VSS nfet_03v3 ad=0.65p pd=3.02u as=1.1p ps=5.88u w=2.5u l=1u
X35 VSS enb.0 VBN VSS nfet_03v3 ad=0.52p pd=2.52u as=0.52p ps=2.52u w=2u l=0.5u
X36 rdb_m2.0 rdb_m1.0 VSS ppolyf_u_1k r_width=2u r_length=19.26u
X37 VDD enb.0 nrb.0 VDD pfet_03v3 ad=1.3p pd=5.52u as=1.3p ps=5.52u w=5u l=0.5u
X38 VSS VBN VBP VSS nfet_03v3 ad=0.65p pd=3.02u as=0.65p ps=3.02u w=2.5u l=1u
X39 VDD VBP VB2 VDD pfet_03v3 ad=1.3p pd=5.52u as=1.3p ps=5.52u w=5u l=1u
X40 VDD enb.0 nrb.0 VDD pfet_03v3 ad=1.3p pd=5.52u as=1.3p ps=5.52u w=5u l=0.5u
X41 VBP VBP VDD VDD pfet_03v3 ad=1.3p pd=5.52u as=1.3p ps=5.52u w=5u l=1u
X42 rb_m3.0 VBN VSS ppolyf_u_1k r_width=2u r_length=22.27u
X43 VDD VDD VDD VDD pfet_03v3 ad=0.65p pd=3.02u as=0 ps=0 w=2.5u l=0.28u
X44 VSS VSS VSS VSS nfet_03v3 ad=0.52p pd=2.52u as=0 ps=0 w=2u l=0.5u
X45 VB2 VSS VSS VSS nfet_03v3 ad=2.0566p pd=8.43u as=3.4804p ps=16.7u w=7.91u l=0.5u
X46 VBP VBN VSS VSS nfet_03v3 ad=0.65p pd=3.02u as=0.65p ps=3.02u w=2.5u l=1u
X47 VSS VSS nmid.0 VSS nfet_03v3 ad=2.2p pd=10.88u as=1.3p ps=5.52u w=5u l=0.5u
X48 VDD VBP VBP VDD pfet_03v3 ad=1.3p pd=5.52u as=1.3p ps=5.52u w=5u l=1u
X49 nmid.0 VSS VSS VSS nfet_03v3 ad=1.3p pd=5.52u as=2.2p ps=10.88u w=5u l=0.5u
X50 rdt_m2.0 rdt_m3.0 VSS ppolyf_u_1k r_width=2u r_length=21.01u
X51 VDD enb.0 nrb.0 VDD pfet_03v3 ad=1.3p pd=5.52u as=1.3p ps=5.52u w=5u l=0.5u
X52 rb_m1.0 rb_m2.0 VSS ppolyf_u_1k r_width=2u r_length=22.27u
X53 VBP VBP VDD VDD pfet_03v3 ad=1.3p pd=5.52u as=1.3p ps=5.52u w=5u l=1u
X54 VDD VDD VDD VDD pfet_03v3 ad=1.3p pd=5.52u as=0 ps=0 w=5u l=1u
X55 VDD VDD nrb.0 VDD pfet_03v3 ad=2.2p pd=10.88u as=1.3p ps=5.52u w=5u l=0.5u
X56 VSS VBN VBN VSS nfet_03v3 ad=0.65p pd=3.02u as=0.65p ps=3.02u w=2.5u l=1u
X57 VBP VBN VSS VSS nfet_03v3 ad=0.65p pd=3.02u as=0.65p ps=3.02u w=2.5u l=1u
X58 VBP VBP VDD VDD pfet_03v3 ad=1.3p pd=5.52u as=1.3p ps=5.52u w=5u l=1u
X59 VDD VBP VB2 VDD pfet_03v3 ad=1.3p pd=5.52u as=1.3p ps=5.52u w=5u l=1u
X60 VDD EN VBP VDD pfet_03v3 ad=0.52p pd=2.52u as=0.52p ps=2.52u w=2u l=0.5u
X61 VSS VSS vf.0 VSS nfet_03v3 ad=3.4804p pd=16.7u as=2.0566p ps=8.43u w=7.91u l=0.5u
X62 rb_m1.0 nrb.0 VSS ppolyf_u_1k r_width=2u r_length=22.27u
X63 VB2 VSS VSS VSS nfet_03v3 ad=0.52p pd=2.52u as=0.88p ps=4.88u w=2u l=0.5u
X64 VBN VBN VSS VSS nfet_03v3 ad=0.65p pd=3.02u as=0.65p ps=3.02u w=2.5u l=1u
X65 VSS VSS VSS ppolyf_u_1k r_width=2u r_length=22.27u
X66 VDD EN enb.0 VDD pfet_03v3 ad=0.65p pd=3.02u as=0.65p ps=3.02u w=2.5u l=0.28u
X67 VREF rdb_m1.0 VSS ppolyf_u_1k r_width=2u r_length=19.26u
X68 VBP VBP VDD VDD pfet_03v3 ad=1.3p pd=5.52u as=1.3p ps=5.52u w=5u l=1u
X69 VBP VBP VDD VDD pfet_03v3 ad=1.3p pd=5.52u as=1.3p ps=5.52u w=5u l=1u
X70 nmid.0 EN VSS VSS nfet_03v3 ad=1.3p pd=5.52u as=1.3p ps=5.52u w=5u l=0.5u
X71 enb.0 VDD VDD VDD pfet_03v3 ad=0.65p pd=3.02u as=1.1p ps=5.88u w=2.5u l=0.28u
X72 VDD enb.0 nrb.0 VDD pfet_03v3 ad=1.3p pd=5.52u as=1.3p ps=5.52u w=5u l=0.5u
X73 VSS VSS VSS ppolyf_u_1k r_width=2u r_length=21.01u
X74 VBP VBN VSS VSS nfet_03v3 ad=0.65p pd=3.02u as=0.65p ps=3.02u w=2.5u l=1u
X75 VB2 VBP VDD VDD pfet_03v3 ad=1.3p pd=5.52u as=1.3p ps=5.52u w=5u l=1u
X76 VSS enb.0 VB2 VSS nfet_03v3 ad=0.52p pd=2.52u as=0.52p ps=2.52u w=2u l=0.5u
X77 VDD rdt_m1.0 VSS ppolyf_u_1k r_width=2u r_length=21.01u
C0 VDD VREF 1.71905f
C1 VB2 VBN 0.25785f
C2 VB2 enb.0 2.12636f
C3 nmid.0 EN 0.59891f
C4 VB2 VBP 5.46578f
C5 rdt_m2.0 VREF 0.00234f
C6 vf.0 EN 0.02265f
C7 nmid.0 rdb_m2.0 0.04228f
C8 nmid.0 VBN 0.11617f
C9 rdt_m3.0 rdb_m1.0 0.22342f
C10 nmid.0 enb.0 0.71708f
C11 VBN EN 0.42114f
C12 EN enb.0 4.04436f
C13 rdt_m1.0 enb.0 0.0052f
C14 vf.0 VBN 1.54524f
C15 nmid.0 VBP 0.03404f
C16 vf.0 enb.0 1.18587f
C17 VBP EN 0.30684f
C18 VB2 VREF 0.62142f
C19 VBN enb.0 0.2848f
C20 vf.0 VBP 0.3587f
C21 VBP VBN 7.61409f
C22 VBP enb.0 1.1468f
C23 nmid.0 VREF 0
C24 VREF rdb_m2.0 0.09091f
C25 VBN VREF 0.23654f
C26 VREF enb.0 0.14548f
C27 rdb_m3.0 rdt_m1.0 0.41833f
C28 nrb.0 VDD 5.10108f
C29 VBP VREF 0.0747f
C30 rb_m2.0 vf.0 0.08519f
C31 rb_m3.0 rf_m1.0 0.04347f
C32 rb_m2.0 VBN 0.03954f
C33 rb_m3.0 rb_m1.0 0.06955f
C34 VB2 nrb.0 0.03936f
C35 rb_m1.0 EN 0.00476f
C36 nrb.0 EN 0.24322f
C37 rdt_m2.0 VDD 0.00209f
C38 nrb.0 vf.0 0.76263f
C39 rdt_m3.0 rdt_m1.0 0.08167f
C40 nrb.0 VBN 0.04436f
C41 rb_m1.0 enb.0 0
C42 nrb.0 enb.0 0.83214f
C43 VBP rb_m1.0 0.0038f
C44 nrb.0 VBP 0.36246f
C45 VB2 VDD 6.22905f
C46 nmid.0 VDD 0.89627f
C47 VDD EN 3.6169f
C48 VDD vf.0 0.00294f
C49 rdt_m2.0 nmid.0 0.00432f
C50 VDD rdb_m2.0 0.00594f
C51 VDD VBN 3.33637f
C52 VDD enb.0 6.17842f
C53 rb_m2.0 nrb.0 0.03837f
C54 VDD VBP 19.3599f
C55 rdt_m2.0 rdb_m2.0 0.37f
C56 VB2 nmid.0 0.91956f
C57 VB2 EN 2.2084f
C58 VB2 vf.0 0.92899f
C59 EN VSS 6.13386f
C60 VREF VSS 18.7003f
C61 VBN VSS 15.8794f
C62 VB2 VSS 8.27107f
C63 VBP VSS 8.35702f
C64 VDD VSS 80.0931f
C65 rb_m3.0 VSS 1.32997f
C66 rb_m2.0 VSS 1.18198f
C67 rb_m1.0 VSS 1.29868f
C68 rf_m1.0 VSS 1.40226f
C69 vf.0 VSS 3.02831f
C70 nrb.0 VSS 1.98311f
C71 rdb_m1.0 VSS 1.12023f
C72 rdt_m3.0 VSS 1.81265f
C73 rdb_m2.0 VSS 1.89154f
C74 rdb_m3.0 VSS 1.13703f
C75 rdt_m1.0 VSS 1.66241f
C76 rdt_m2.0 VSS 1.18196f
C77 nmid.0 VSS 4.29373f
C78 enb.0 VSS 8.34629f
.ends lvds_bias
