* lvds_lane: parasitic C on all nets (coupling and to substrate, cthresh 0)
* GENERATED by layout/macro/run_macro.py (T10) from a GDS with sha256 76388d798e912e38ec1a8b2ec6028ab2e4ddf5ef093cc082a891e6fab623c3f2 -- do not edit by hand.
* Ports in the order of subckt lvds_lane of netlist/lvds_rx_lvs_ref.spice (Magic's own order was: INP INN OUT EN VBN VB2 VREF VBP VDD VSS).
* NGSPICE file created from lvds_lane.ext - technology: gf180mcuD

.subckt lvds_lane VDD VSS INP INN EN VBN VBP VB2 VREF OUT
X0 tp.0 gn.0 fb.0 tp.0 pfet_03v3 ad=1.248p pd=5.32u as=1.248p ps=5.32u w=4.8u l=0.4u
X1 ob.0 VREF tn.0 VSS nfet_03v3 ad=1.235p pd=5.27u as=1.235p ps=5.27u w=4.75u l=0.5u
X2 oa.0 VREF tn.0 VSS nfet_03v3 ad=1.235p pd=5.27u as=1.235p ps=5.27u w=4.75u l=0.5u
X3 tp.0 VREF fb.0 tp.0 pfet_03v3 ad=1.248p pd=5.32u as=2.112p ps=10.48u w=4.8u l=0.4u
X4 fb.0 gn.0 tp.0 tp.0 pfet_03v3 ad=1.248p pd=5.32u as=1.248p ps=5.32u w=4.8u l=0.4u
X5 oa.0 VREF tn.0 VSS nfet_03v3 ad=1.235p pd=5.27u as=1.235p ps=5.27u w=4.75u l=0.5u
X6 ob.0 VREF tn.0 VSS nfet_03v3 ad=1.235p pd=5.27u as=1.235p ps=5.27u w=4.75u l=0.5u
X7 tn.0 VBN VSS VSS nfet_03v3 ad=0.65p pd=3.02u as=0.65p ps=3.02u w=2.5u l=1u
X8 tp.0 VREF fa.0 tp.0 pfet_03v3 ad=1.248p pd=5.32u as=1.248p ps=5.32u w=4.8u l=0.4u
X9 ts.0 VBN VSS VSS nfet_03v3 ad=0.65p pd=3.02u as=0.65p ps=3.02u w=2.5u l=1u
X10 tp.0 VREF fa.0 tp.0 pfet_03v3 ad=1.248p pd=5.32u as=1.248p ps=5.32u w=4.8u l=0.4u
X11 n3a.0 d2a.0 VDD VDD pfet_03v3 ad=0.52p pd=2.52u as=0.52p ps=2.52u w=2u l=0.4u
X12 d2b.0 d2b.0 VDD VDD pfet_03v3 ad=0.52p pd=2.52u as=0.52p ps=2.52u w=2u l=0.4u
X13 VDD d2b.0 d3.0 VDD pfet_03v3 ad=0.52p pd=2.52u as=0.52p ps=2.52u w=2u l=0.4u
X14 fb.0 VREF tp.0 tp.0 pfet_03v3 ad=1.248p pd=5.32u as=1.248p ps=5.32u w=4.8u l=0.4u
X15 VSS VBN fb.0 VSS nfet_03v3 ad=0.65p pd=3.02u as=0.65p ps=3.02u w=2.5u l=1u
X16 VSS VBN ts.0 VSS nfet_03v3 ad=0.65p pd=3.02u as=0.65p ps=3.02u w=2.5u l=1u
X17 tp.0 gn.0 fb.0 tp.0 pfet_03v3 ad=1.248p pd=5.32u as=1.248p ps=5.32u w=4.8u l=0.4u
X18 VSS VBN tn.0 VSS nfet_03v3 ad=0.65p pd=3.02u as=0.65p ps=3.02u w=2.5u l=1u
X19 tn.0 gp.0 oa.0 VSS nfet_03v3 ad=1.235p pd=5.27u as=1.235p ps=5.27u w=4.75u l=0.5u
X20 VDD VDD d2b.0 VDD pfet_03v3 ad=0.88p pd=4.88u as=0.52p ps=2.52u w=2u l=0.4u
X21 gp.0 INP VDD ppolyf_u r_width=5u r_length=1.8u
X22 tp.0 VREF fb.0 tp.0 pfet_03v3 ad=1.248p pd=5.32u as=1.248p ps=5.32u w=4.8u l=0.4u
X23 ob.0 rlb_m1.0 VSS ppolyf_u_1k r_width=2u r_length=9.11u
X24 fa.0 VB2 oa.0 VSS nfet_03v3 ad=1.1752p pd=5.04u as=1.1752p ps=5.04u w=4.52u l=0.5u
X25 ob.0 VB2 fb.0 VSS nfet_03v3 ad=1.1752p pd=5.04u as=1.1752p ps=5.04u w=4.52u l=0.5u
X26 VDD EN d2b.0 VDD pfet_03v3 ad=0.52p pd=2.52u as=0.52p ps=2.52u w=2u l=0.5u
X27 VDD VBP tp.0 VDD pfet_03v3 ad=1.3p pd=5.52u as=1.3p ps=5.52u w=5u l=1u
X28 fa.0 VB2 oa.0 VSS nfet_03v3 ad=1.1752p pd=5.04u as=1.1752p ps=5.04u w=4.52u l=0.5u
X29 ob.0 VB2 fb.0 VSS nfet_03v3 ad=1.1752p pd=5.04u as=1.1752p ps=5.04u w=4.52u l=0.5u
X30 tn.0 gn.0 ob.0 VSS nfet_03v3 ad=1.235p pd=5.27u as=1.235p ps=5.27u w=4.75u l=0.5u
X31 VDD i1.0 i2.0 VDD pfet_03v3 ad=0.975p pd=4.27u as=0.975p ps=4.27u w=3.75u l=0.28u
X32 VDD EN d2a.0 VDD pfet_03v3 ad=0.52p pd=2.52u as=0.52p ps=2.52u w=2u l=0.5u
X33 tp.0 VREF fa.0 tp.0 pfet_03v3 ad=1.248p pd=5.32u as=1.248p ps=5.32u w=4.8u l=0.4u
X34 ob.0 VSS VSS VSS nfet_03v3 ad=1.1752p pd=5.04u as=1.9888p ps=9.92u w=4.52u l=0.5u
X35 tn.0 gp.0 oa.0 VSS nfet_03v3 ad=1.235p pd=5.27u as=1.235p ps=5.27u w=4.75u l=0.5u
X36 VDD nd.0 i1.0 VDD pfet_03v3 ad=0.962p pd=4.22u as=0.962p ps=4.22u w=3.7u l=0.28u
X37 tp.0 VBP VDD VDD pfet_03v3 ad=1.3p pd=5.52u as=1.3p ps=5.52u w=5u l=1u
X38 n3a.0 VDD VDD VDD pfet_03v3 ad=0.52p pd=2.52u as=0.88p ps=4.88u w=2u l=0.4u
X39 VDD rla_m1.0 VSS ppolyf_u_1k r_width=2u r_length=9.11u
X40 fa.0 VBN VSS VSS nfet_03v3 ad=0.65p pd=3.02u as=0.65p ps=3.02u w=2.5u l=1u
X41 fb.0 VBN VSS VSS nfet_03v3 ad=0.65p pd=3.02u as=0.65p ps=3.02u w=2.5u l=1u
X42 d2b.0 d2b.0 VDD VDD pfet_03v3 ad=0.52p pd=2.52u as=0.52p ps=2.52u w=2u l=0.4u
X43 VDD d2b.0 d3.0 VDD pfet_03v3 ad=0.52p pd=2.52u as=0.52p ps=2.52u w=2u l=0.4u
X44 ts.0 sa.0 VSS ppolyf_u_1k r_width=2u r_length=8.86u
X45 tp.0 gp.0 fa.0 tp.0 pfet_03v3 ad=1.248p pd=5.32u as=1.248p ps=5.32u w=4.8u l=0.4u
X46 i2.0 VDD VDD VDD pfet_03v3 ad=0.975p pd=4.27u as=1.65p ps=8.38u w=3.75u l=0.28u
X47 VDD d2a.0 d2a.0 VDD pfet_03v3 ad=0.52p pd=2.52u as=0.52p ps=2.52u w=2u l=0.4u
X48 d3.0 d2b.0 VDD VDD pfet_03v3 ad=0.52p pd=2.52u as=0.52p ps=2.52u w=2u l=0.4u
X49 oa.0 VREF tn.0 VSS nfet_03v3 ad=1.235p pd=5.27u as=1.235p ps=5.27u w=4.75u l=0.5u
X50 VSS i2.0 OUT VSS nfet_03v3 ad=1.04p pd=4.52u as=1.04p ps=4.52u w=4u l=0.28u
X51 VDD VDD VDD VDD pfet_03v3 ad=0.962p pd=4.22u as=84.03p ps=0.39294m w=3.7u l=0.28u
X52 fb.0 VREF tp.0 tp.0 pfet_03v3 ad=1.248p pd=5.32u as=1.248p ps=5.32u w=4.8u l=0.4u
X53 VSS VBN fb.0 VSS nfet_03v3 ad=0.65p pd=3.02u as=0.65p ps=3.02u w=2.5u l=1u
X54 OUT i2.0 VDD VDD pfet_03v3 ad=1.3p pd=5.52u as=1.3p ps=5.52u w=5u l=0.28u
X55 VDD VDD tp.0 VDD pfet_03v3 ad=2.2p pd=10.88u as=1.3p ps=5.52u w=5u l=1u
X56 tp.0 VREF fa.0 tp.0 pfet_03v3 ad=1.248p pd=5.32u as=1.248p ps=5.32u w=4.8u l=0.4u
X57 ts.0 sb.0 VSS ppolyf_u_1k r_width=2u r_length=8.86u
X58 VSS VSS VSS ppolyf_u_1k r_width=2u r_length=9.11u
X59 tp.0 VREF fa.0 tp.0 pfet_03v3 ad=1.248p pd=5.32u as=1.248p ps=5.32u w=4.8u l=0.4u
X60 tn.0 VREF ob.0 VSS nfet_03v3 ad=1.235p pd=5.27u as=1.235p ps=5.27u w=4.75u l=0.5u
X61 tp.0 VBP VDD VDD pfet_03v3 ad=1.3p pd=5.52u as=1.3p ps=5.52u w=5u l=1u
X62 tp.0 gp.0 fa.0 tp.0 pfet_03v3 ad=1.248p pd=5.32u as=1.248p ps=5.32u w=4.8u l=0.4u
X63 fa.0 VREF tp.0 tp.0 pfet_03v3 ad=1.248p pd=5.32u as=1.248p ps=5.32u w=4.8u l=0.4u
X64 OUT VSS VSS VSS nfet_03v3 ad=1.04p pd=4.52u as=1.76p ps=8.88u w=4u l=0.28u
X65 tn.0 gp.0 oa.0 VSS nfet_03v3 ad=1.235p pd=5.27u as=1.235p ps=5.27u w=4.75u l=0.5u
X66 VSS VSS VSS VSS nfet_03v3 ad=0.78p pd=3.52u as=65.6748p ps=0.3227m w=3u l=0.28u
X67 VDD i2.0 OUT VDD pfet_03v3 ad=1.3p pd=5.52u as=1.3p ps=5.52u w=5u l=0.28u
X68 VSS VSS fa.0 VSS nfet_03v3 ad=1.1p pd=5.88u as=0.65p ps=3.02u w=2.5u l=1u
X69 VDD d2b.0 d2a.0 VDD pfet_03v3 ad=0.52p pd=2.52u as=0.52p ps=2.52u w=2u l=0.4u
X70 VSS VSS fb.0 VSS nfet_03v3 ad=1.9888p pd=9.92u as=1.1752p ps=5.04u w=4.52u l=0.5u
X71 nm.0 d3.0 nd.0 VSS nfet_03v3 ad=0.52p pd=2.52u as=0.52p ps=2.52u w=2u l=0.28u
X72 VDD VBP tp.0 VDD pfet_03v3 ad=1.3p pd=5.52u as=1.3p ps=5.52u w=5u l=1u
X73 tp.0 gn.0 fb.0 tp.0 pfet_03v3 ad=1.248p pd=5.32u as=1.248p ps=5.32u w=4.8u l=0.4u
X74 fa.0 gp.0 tp.0 tp.0 pfet_03v3 ad=1.248p pd=5.32u as=1.248p ps=5.32u w=4.8u l=0.4u
X75 tp.0 gn.0 fb.0 tp.0 pfet_03v3 ad=1.248p pd=5.32u as=1.248p ps=5.32u w=4.8u l=0.4u
X76 d2a.0 d2a.0 VDD VDD pfet_03v3 ad=0.52p pd=2.52u as=0.52p ps=2.52u w=2u l=0.4u
X77 tp.0 VBP VDD VDD pfet_03v3 ad=1.3p pd=5.52u as=1.3p ps=5.52u w=5u l=1u
X78 fb.0 gn.0 tp.0 tp.0 pfet_03v3 ad=1.248p pd=5.32u as=1.248p ps=5.32u w=4.8u l=0.4u
X79 n3a.0 d2a.0 VDD VDD pfet_03v3 ad=0.52p pd=2.52u as=0.52p ps=2.52u w=2u l=0.4u
X80 VSS VBN tn.0 VSS nfet_03v3 ad=0.65p pd=3.02u as=0.65p ps=3.02u w=2.5u l=1u
X81 ob.0 VREF tn.0 VSS nfet_03v3 ad=2.09p pd=10.38u as=1.235p ps=5.27u w=4.75u l=0.5u
X82 VSS VSS ts.0 VSS nfet_03v3 ad=1.1p pd=5.88u as=0.65p ps=3.02u w=2.5u l=1u
X83 VSS VSS d3.0 VSS nfet_03v3 ad=1.1396p pd=6.06u as=0.6734p ps=3.11u w=2.59u l=0.28u
X84 VDD rlb_m1.0 VSS ppolyf_u_1k r_width=2u r_length=9.11u
X85 fa.0 VREF tp.0 tp.0 pfet_03v3 ad=1.248p pd=5.32u as=1.248p ps=5.32u w=4.8u l=0.4u
X86 fa.0 gp.0 tp.0 tp.0 pfet_03v3 ad=1.248p pd=5.32u as=1.248p ps=5.32u w=4.8u l=0.4u
X87 fb.0 VREF tp.0 tp.0 pfet_03v3 ad=2.112p pd=10.48u as=1.248p ps=5.32u w=4.8u l=0.4u
X88 fa.0 VBN VSS VSS nfet_03v3 ad=0.65p pd=3.02u as=0.65p ps=3.02u w=2.5u l=1u
X89 tn.0 gp.0 oa.0 VSS nfet_03v3 ad=1.235p pd=5.27u as=1.235p ps=5.27u w=4.75u l=0.5u
X90 VDD VDD n3a.0 VDD pfet_03v3 ad=0.88p pd=4.88u as=0.52p ps=2.52u w=2u l=0.4u
X91 VDD VBP tp.0 VDD pfet_03v3 ad=1.3p pd=5.52u as=1.3p ps=5.52u w=5u l=1u
X92 d2a.0 VSS VSS VSS nfet_03v3 ad=1.0036p pd=4.38u as=1.6984p ps=8.6u w=3.86u l=0.5u
X93 nd.0 VDD VDD VDD pfet_03v3 ad=0.78p pd=3.52u as=1.32p ps=6.88u w=3u l=0.28u
X94 VSS VSS sb.0 VSS nfet_03v3 ad=1.6984p pd=8.6u as=1.0036p ps=4.38u w=3.86u l=0.5u
X95 fa.0 gp.0 tp.0 tp.0 pfet_03v3 ad=1.248p pd=5.32u as=1.248p ps=5.32u w=4.8u l=0.4u
X96 fb.0 gn.0 tp.0 tp.0 pfet_03v3 ad=1.248p pd=5.32u as=1.248p ps=5.32u w=4.8u l=0.4u
X97 tn.0 VSS VSS VSS nfet_03v3 ad=0.65p pd=3.02u as=1.1p ps=5.88u w=2.5u l=1u
X98 d2b.0 ob.0 sb.0 VSS nfet_03v3 ad=1.0036p pd=4.38u as=1.0036p ps=4.38u w=3.86u l=0.5u
X99 tn.0 VREF oa.0 VSS nfet_03v3 ad=1.235p pd=5.27u as=1.235p ps=5.27u w=4.75u l=0.5u
X100 d2a.0 oa.0 sa.0 VSS nfet_03v3 ad=1.0036p pd=4.38u as=1.0036p ps=4.38u w=3.86u l=0.5u
X101 fb.0 VREF tp.0 tp.0 pfet_03v3 ad=1.248p pd=5.32u as=1.248p ps=5.32u w=4.8u l=0.4u
X102 tn.0 gn.0 ob.0 VSS nfet_03v3 ad=1.235p pd=5.27u as=1.235p ps=5.27u w=4.75u l=0.5u
X103 tn.0 gn.0 ob.0 VSS nfet_03v3 ad=1.235p pd=5.27u as=1.235p ps=5.27u w=4.75u l=0.5u
X104 VSS VSS VSS ppolyf_u_1k r_width=2u r_length=8.86u
X105 tp.0 VREF fa.0 tp.0 pfet_03v3 ad=1.248p pd=5.32u as=1.248p ps=5.32u w=4.8u l=0.4u
X106 fa.0 VREF tp.0 tp.0 pfet_03v3 ad=1.248p pd=5.32u as=1.248p ps=5.32u w=4.8u l=0.4u
D0 gn.0 VDD diode_pd2nw_03v3 pj=26u area=40p
X107 fb.0 gn.0 tp.0 tp.0 pfet_03v3 ad=1.248p pd=5.32u as=1.248p ps=5.32u w=4.8u l=0.4u
X108 tn.0 gp.0 oa.0 VSS nfet_03v3 ad=1.235p pd=5.27u as=1.235p ps=5.27u w=4.75u l=0.5u
X109 fa.0 gp.0 tp.0 tp.0 pfet_03v3 ad=1.248p pd=5.32u as=1.248p ps=5.32u w=4.8u l=0.4u
X110 fb.0 VBN VSS VSS nfet_03v3 ad=0.65p pd=3.02u as=0.65p ps=3.02u w=2.5u l=1u
X111 tn.0 VBN VSS VSS nfet_03v3 ad=0.65p pd=3.02u as=0.65p ps=3.02u w=2.5u l=1u
X112 fb.0 VBN VSS VSS nfet_03v3 ad=0.65p pd=3.02u as=0.65p ps=3.02u w=2.5u l=1u
X113 ts.0 VBN VSS VSS nfet_03v3 ad=0.65p pd=3.02u as=0.65p ps=3.02u w=2.5u l=1u
D1 VSS gn.0 diode_nd2ps_03v3 pj=26u area=40p
X114 tp.0 gn.0 fb.0 tp.0 pfet_03v3 ad=1.248p pd=5.32u as=1.248p ps=5.32u w=4.8u l=0.4u
X115 oa.0 VB2 fa.0 VSS nfet_03v3 ad=1.1752p pd=5.04u as=1.1752p ps=5.04u w=4.52u l=0.5u
X116 VDD d2a.0 d2b.0 VDD pfet_03v3 ad=0.52p pd=2.52u as=0.52p ps=2.52u w=2u l=0.4u
X117 VDD VDD VDD VDD pfet_03v3 ad=0.52p pd=2.52u as=0 ps=0 w=2u l=0.5u
X118 VSS VBN fa.0 VSS nfet_03v3 ad=0.65p pd=3.02u as=0.65p ps=3.02u w=2.5u l=1u
X119 VSS VBN fa.0 VSS nfet_03v3 ad=0.65p pd=3.02u as=0.65p ps=3.02u w=2.5u l=1u
X120 n3a.0 d2a.0 VDD VDD pfet_03v3 ad=0.52p pd=2.52u as=0.52p ps=2.52u w=2u l=0.4u
X121 tp.0 gp.0 fa.0 tp.0 pfet_03v3 ad=1.248p pd=5.32u as=1.248p ps=5.32u w=4.8u l=0.4u
X122 tp.0 gp.0 fa.0 tp.0 pfet_03v3 ad=1.248p pd=5.32u as=1.248p ps=5.32u w=4.8u l=0.4u
X123 fb.0 gn.0 tp.0 tp.0 pfet_03v3 ad=1.248p pd=5.32u as=1.248p ps=5.32u w=4.8u l=0.4u
X124 oa.0 rla_m1.0 VSS ppolyf_u_1k r_width=2u r_length=9.11u
X125 fa.0 VSS VSS VSS nfet_03v3 ad=0.65p pd=3.02u as=1.1p ps=5.88u w=2.5u l=1u
X126 tn.0 VREF ob.0 VSS nfet_03v3 ad=1.235p pd=5.27u as=1.235p ps=5.27u w=4.75u l=0.5u
X127 tp.0 VBP VDD VDD pfet_03v3 ad=1.3p pd=5.52u as=1.3p ps=5.52u w=5u l=1u
X128 VSS VBN fb.0 VSS nfet_03v3 ad=0.65p pd=3.02u as=0.65p ps=3.02u w=2.5u l=1u
X129 VDD VBP tp.0 VDD pfet_03v3 ad=1.3p pd=5.52u as=1.3p ps=5.52u w=5u l=1u
X130 VDD VBP tp.0 VDD pfet_03v3 ad=1.3p pd=5.52u as=1.3p ps=5.52u w=5u l=1u
X131 fa.0 VREF tp.0 tp.0 pfet_03v3 ad=1.248p pd=5.32u as=1.248p ps=5.32u w=4.8u l=0.4u
X132 tp.0 VREF fb.0 tp.0 pfet_03v3 ad=1.248p pd=5.32u as=1.248p ps=5.32u w=4.8u l=0.4u
X133 gn.0 INN VDD ppolyf_u r_width=5u r_length=1.8u
X134 fa.0 VREF tp.0 tp.0 pfet_03v3 ad=1.248p pd=5.32u as=1.248p ps=5.32u w=4.8u l=0.4u
X135 tp.0 VBP VDD VDD pfet_03v3 ad=1.3p pd=5.52u as=1.3p ps=5.52u w=5u l=1u
X136 tp.0 gp.0 fa.0 tp.0 pfet_03v3 ad=1.248p pd=5.32u as=1.248p ps=5.32u w=4.8u l=0.4u
X137 tp.0 VDD VDD VDD pfet_03v3 ad=1.3p pd=5.52u as=2.2p ps=10.88u w=5u l=1u
X138 fb.0 VREF tp.0 tp.0 pfet_03v3 ad=1.248p pd=5.32u as=1.248p ps=5.32u w=4.8u l=0.4u
X139 fa.0 VREF tp.0 tp.0 pfet_03v3 ad=1.248p pd=5.32u as=1.248p ps=5.32u w=4.8u l=0.4u
X140 oa.0 VB2 fa.0 VSS nfet_03v3 ad=1.1752p pd=5.04u as=1.1752p ps=5.04u w=4.52u l=0.5u
X141 sb.0 ob.0 d2b.0 VSS nfet_03v3 ad=1.0036p pd=4.38u as=1.0036p ps=4.38u w=3.86u l=0.5u
X142 VDD VBP tp.0 VDD pfet_03v3 ad=1.3p pd=5.52u as=1.3p ps=5.52u w=5u l=1u
X143 VSS VSS fa.0 VSS nfet_03v3 ad=1.9888p pd=9.92u as=1.1752p ps=5.04u w=4.52u l=0.5u
X144 VDD d2b.0 d2b.0 VDD pfet_03v3 ad=0.52p pd=2.52u as=0.52p ps=2.52u w=2u l=0.4u
X145 d3.0 d2b.0 VDD VDD pfet_03v3 ad=0.52p pd=2.52u as=0.52p ps=2.52u w=2u l=0.4u
X146 tp.0 VREF fb.0 tp.0 pfet_03v3 ad=1.248p pd=5.32u as=1.248p ps=5.32u w=4.8u l=0.4u
X147 fb.0 VB2 ob.0 VSS nfet_03v3 ad=1.1752p pd=5.04u as=1.1752p ps=5.04u w=4.52u l=0.5u
X148 tn.0 VBN VSS VSS nfet_03v3 ad=0.65p pd=3.02u as=0.65p ps=3.02u w=2.5u l=1u
X149 ob.0 gn.0 tn.0 VSS nfet_03v3 ad=1.235p pd=5.27u as=1.235p ps=5.27u w=4.75u l=0.5u
D2 VSS gp.0 diode_nd2ps_03v3 pj=26u area=40p
X150 OUT VDD VDD VDD pfet_03v3 ad=1.3p pd=5.52u as=2.2p ps=10.88u w=5u l=0.28u
X151 VDD d2a.0 n3a.0 VDD pfet_03v3 ad=0.52p pd=2.52u as=0.52p ps=2.52u w=2u l=0.4u
X152 fa.0 gp.0 tp.0 tp.0 pfet_03v3 ad=1.248p pd=5.32u as=1.248p ps=5.32u w=4.8u l=0.4u
X153 tp.0 gp.0 fa.0 tp.0 pfet_03v3 ad=1.248p pd=5.32u as=1.248p ps=5.32u w=4.8u l=0.4u
X154 fb.0 VREF tp.0 tp.0 pfet_03v3 ad=1.248p pd=5.32u as=1.248p ps=5.32u w=4.8u l=0.4u
X155 VSS VBN tn.0 VSS nfet_03v3 ad=0.65p pd=3.02u as=0.65p ps=3.02u w=2.5u l=1u
X156 VSS i1.0 i2.0 VSS nfet_03v3 ad=0.78p pd=3.52u as=0.78p ps=3.52u w=3u l=0.28u
X157 VSS nd.0 i1.0 VSS nfet_03v3 ad=0.39p pd=2.02u as=0.39p ps=2.02u w=1.5u l=0.28u
X158 VSS EN nm.0 VSS nfet_03v3 ad=0.52p pd=2.52u as=0.52p ps=2.52u w=2u l=0.28u
D3 gp.0 VDD diode_pd2nw_03v3 pj=26u area=40p
X159 fa.0 VBN VSS VSS nfet_03v3 ad=0.65p pd=3.02u as=0.65p ps=3.02u w=2.5u l=1u
X160 tn.0 VREF ob.0 VSS nfet_03v3 ad=1.235p pd=5.27u as=2.09p ps=10.38u w=4.75u l=0.5u
X161 tn.0 VREF oa.0 VSS nfet_03v3 ad=1.235p pd=5.27u as=1.235p ps=5.27u w=4.75u l=0.5u
X162 nd.0 VSS VSS VSS nfet_03v3 ad=0.52p pd=2.52u as=0.88p ps=4.88u w=2u l=0.28u
X163 tn.0 gn.0 ob.0 VSS nfet_03v3 ad=1.235p pd=5.27u as=1.235p ps=5.27u w=4.75u l=0.5u
X164 tn.0 VREF ob.0 VSS nfet_03v3 ad=1.235p pd=5.27u as=1.235p ps=5.27u w=4.75u l=0.5u
X165 tp.0 gp.0 fa.0 tp.0 pfet_03v3 ad=1.248p pd=5.32u as=1.248p ps=5.32u w=4.8u l=0.4u
X166 ts.0 VSS VSS VSS nfet_03v3 ad=0.65p pd=3.02u as=1.1p ps=5.88u w=2.5u l=1u
X167 tp.0 gn.0 fb.0 tp.0 pfet_03v3 ad=1.248p pd=5.32u as=1.248p ps=5.32u w=4.8u l=0.4u
X168 VSS VBN fa.0 VSS nfet_03v3 ad=0.65p pd=3.02u as=0.65p ps=3.02u w=2.5u l=1u
X169 tn.0 VBN VSS VSS nfet_03v3 ad=0.65p pd=3.02u as=0.65p ps=3.02u w=2.5u l=1u
X170 d2a.0 d2a.0 VDD VDD pfet_03v3 ad=0.52p pd=2.52u as=0.52p ps=2.52u w=2u l=0.4u
X171 tp.0 VREF fb.0 tp.0 pfet_03v3 ad=1.248p pd=5.32u as=1.248p ps=5.32u w=4.8u l=0.4u
X172 VDD VDD OUT VDD pfet_03v3 ad=2.2p pd=10.88u as=1.3p ps=5.52u w=5u l=0.28u
X173 i2.0 VSS VSS VSS nfet_03v3 ad=0.78p pd=3.52u as=1.32p ps=6.88u w=3u l=0.28u
X174 VSS VSS VSS VSS nfet_03v3 ad=0.52p pd=2.52u as=0 ps=0 w=2u l=0.28u
X175 tp.0 VREF fb.0 tp.0 pfet_03v3 ad=1.248p pd=5.32u as=1.248p ps=5.32u w=4.8u l=0.4u
X176 i1.0 VSS VSS VSS nfet_03v3 ad=0.39p pd=2.02u as=0.66p ps=3.88u w=1.5u l=0.28u
X177 VSS VBN tn.0 VSS nfet_03v3 ad=0.65p pd=3.02u as=0.65p ps=3.02u w=2.5u l=1u
X178 oa.0 VREF tn.0 VSS nfet_03v3 ad=1.235p pd=5.27u as=1.235p ps=5.27u w=4.75u l=0.5u
X179 d2a.0 d2b.0 VDD VDD pfet_03v3 ad=0.52p pd=2.52u as=0.52p ps=2.52u w=2u l=0.4u
X180 tp.0 VBP VDD VDD pfet_03v3 ad=1.3p pd=5.52u as=1.3p ps=5.52u w=5u l=1u
X181 tp.0 VREF fa.0 tp.0 pfet_03v3 ad=1.248p pd=5.32u as=1.248p ps=5.32u w=4.8u l=0.4u
X182 VSS VBN ts.0 VSS nfet_03v3 ad=0.65p pd=3.02u as=0.65p ps=3.02u w=2.5u l=1u
X183 oa.0 VSS VSS VSS nfet_03v3 ad=1.1752p pd=5.04u as=1.9888p ps=9.92u w=4.52u l=0.5u
X184 VDD d3.0 nd.0 VDD pfet_03v3 ad=0.78p pd=3.52u as=0.78p ps=3.52u w=3u l=0.28u
X185 VDD d2b.0 d2a.0 VDD pfet_03v3 ad=0.52p pd=2.52u as=0.52p ps=2.52u w=2u l=0.4u
X186 fb.0 VREF tp.0 tp.0 pfet_03v3 ad=1.248p pd=5.32u as=1.248p ps=5.32u w=4.8u l=0.4u
X187 tp.0 VREF fa.0 tp.0 pfet_03v3 ad=1.248p pd=5.32u as=1.248p ps=5.32u w=4.8u l=0.4u
X188 fa.0 VBN VSS VSS nfet_03v3 ad=0.65p pd=3.02u as=0.65p ps=3.02u w=2.5u l=1u
X189 OUT i2.0 VDD VDD pfet_03v3 ad=1.3p pd=5.52u as=1.3p ps=5.52u w=5u l=0.28u
X190 VDD VDD VDD VDD pfet_03v3 ad=0.52p pd=2.52u as=0 ps=0 w=2u l=0.5u
X191 tp.0 gn.0 fb.0 tp.0 pfet_03v3 ad=1.248p pd=5.32u as=1.248p ps=5.32u w=4.8u l=0.4u
X192 fa.0 VREF tp.0 tp.0 pfet_03v3 ad=1.248p pd=5.32u as=1.248p ps=5.32u w=4.8u l=0.4u
X193 oa.0 VB2 fa.0 VSS nfet_03v3 ad=1.1752p pd=5.04u as=1.1752p ps=5.04u w=4.52u l=0.5u
X194 fb.0 VB2 ob.0 VSS nfet_03v3 ad=1.1752p pd=5.04u as=1.1752p ps=5.04u w=4.52u l=0.5u
X195 d2a.0 VDD VDD VDD pfet_03v3 ad=0.52p pd=2.52u as=0.88p ps=4.88u w=2u l=0.5u
X196 fb.0 gn.0 tp.0 tp.0 pfet_03v3 ad=1.248p pd=5.32u as=1.248p ps=5.32u w=4.8u l=0.4u
X197 VSS VBN fa.0 VSS nfet_03v3 ad=0.65p pd=3.02u as=0.65p ps=3.02u w=2.5u l=1u
X198 fb.0 VB2 ob.0 VSS nfet_03v3 ad=1.1752p pd=5.04u as=1.1752p ps=5.04u w=4.52u l=0.5u
X199 VDD d2b.0 d3.0 VDD pfet_03v3 ad=0.52p pd=2.52u as=0.52p ps=2.52u w=2u l=0.4u
X200 tp.0 VREF fb.0 tp.0 pfet_03v3 ad=1.248p pd=5.32u as=1.248p ps=5.32u w=4.8u l=0.4u
X201 d3.0 d2b.0 VDD VDD pfet_03v3 ad=0.52p pd=2.52u as=0.52p ps=2.52u w=2u l=0.4u
X202 nd.0 EN VDD VDD pfet_03v3 ad=0.78p pd=3.52u as=0.78p ps=3.52u w=3u l=0.28u
X203 fa.0 VREF tp.0 tp.0 pfet_03v3 ad=1.248p pd=5.32u as=1.248p ps=5.32u w=4.8u l=0.4u
X204 fb.0 VREF tp.0 tp.0 pfet_03v3 ad=1.248p pd=5.32u as=1.248p ps=5.32u w=4.8u l=0.4u
X205 tn.0 VREF oa.0 VSS nfet_03v3 ad=1.235p pd=5.27u as=1.235p ps=5.27u w=4.75u l=0.5u
X206 fa.0 gp.0 tp.0 tp.0 pfet_03v3 ad=1.248p pd=5.32u as=1.248p ps=5.32u w=4.8u l=0.4u
X207 fa.0 VBN VSS VSS nfet_03v3 ad=0.65p pd=3.02u as=0.65p ps=3.02u w=2.5u l=1u
X208 tn.0 VREF oa.0 VSS nfet_03v3 ad=1.235p pd=5.27u as=1.235p ps=5.27u w=4.75u l=0.5u
X209 tp.0 VBP VDD VDD pfet_03v3 ad=1.3p pd=5.52u as=1.3p ps=5.52u w=5u l=1u
X210 fb.0 gn.0 tp.0 tp.0 pfet_03v3 ad=1.248p pd=5.32u as=1.248p ps=5.32u w=4.8u l=0.4u
X211 tn.0 VREF ob.0 VSS nfet_03v3 ad=1.235p pd=5.27u as=1.235p ps=5.27u w=4.75u l=0.5u
X212 VDD d2b.0 d2b.0 VDD pfet_03v3 ad=0.52p pd=2.52u as=0.52p ps=2.52u w=2u l=0.4u
X213 tn.0 gn.0 ob.0 VSS nfet_03v3 ad=1.235p pd=5.27u as=1.235p ps=5.27u w=4.75u l=0.5u
X214 n3a.0 VSS VSS VSS nfet_03v3 ad=0.6734p pd=3.11u as=1.1396p ps=6.06u w=2.59u l=0.28u
X215 VSS VBN fb.0 VSS nfet_03v3 ad=0.65p pd=3.02u as=0.65p ps=3.02u w=2.5u l=1u
X216 ob.0 VREF tn.0 VSS nfet_03v3 ad=1.235p pd=5.27u as=1.235p ps=5.27u w=4.75u l=0.5u
X217 oa.0 gp.0 tn.0 VSS nfet_03v3 ad=1.235p pd=5.27u as=1.235p ps=5.27u w=4.75u l=0.5u
X218 d3.0 d2b.0 VDD VDD pfet_03v3 ad=0.52p pd=2.52u as=0.52p ps=2.52u w=2u l=0.4u
X219 tp.0 VREF fa.0 tp.0 pfet_03v3 ad=1.248p pd=5.32u as=1.248p ps=5.32u w=4.8u l=0.4u
X220 fb.0 VREF tp.0 tp.0 pfet_03v3 ad=1.248p pd=5.32u as=1.248p ps=5.32u w=4.8u l=0.4u
X221 ob.0 gn.0 tn.0 VSS nfet_03v3 ad=1.235p pd=5.27u as=1.235p ps=5.27u w=4.75u l=0.5u
X222 VDD d2a.0 n3a.0 VDD pfet_03v3 ad=0.52p pd=2.52u as=0.52p ps=2.52u w=2u l=0.4u
X223 VSS n3a.0 n3a.0 VSS nfet_03v3 ad=0.6734p pd=3.11u as=0.6734p ps=3.11u w=2.59u l=0.28u
X224 fb.0 gn.0 tp.0 tp.0 pfet_03v3 ad=1.248p pd=5.32u as=1.248p ps=5.32u w=4.8u l=0.4u
X225 fb.0 VBN VSS VSS nfet_03v3 ad=0.65p pd=3.02u as=0.65p ps=3.02u w=2.5u l=1u
X226 oa.0 gp.0 tn.0 VSS nfet_03v3 ad=1.235p pd=5.27u as=1.235p ps=5.27u w=4.75u l=0.5u
X227 d2a.0 d2b.0 VDD VDD pfet_03v3 ad=0.52p pd=2.52u as=0.52p ps=2.52u w=2u l=0.4u
X228 VDD VBP tp.0 VDD pfet_03v3 ad=1.3p pd=5.52u as=1.3p ps=5.52u w=5u l=1u
X229 VDD VBP tp.0 VDD pfet_03v3 ad=1.3p pd=5.52u as=1.3p ps=5.52u w=5u l=1u
X230 ob.0 gn.0 tn.0 VSS nfet_03v3 ad=1.235p pd=5.27u as=1.235p ps=5.27u w=4.75u l=0.5u
X231 d2b.0 VSS VSS VSS nfet_03v3 ad=1.0036p pd=4.38u as=1.6984p ps=8.6u w=3.86u l=0.5u
X232 fb.0 VB2 ob.0 VSS nfet_03v3 ad=1.1752p pd=5.04u as=1.1752p ps=5.04u w=4.52u l=0.5u
X233 oa.0 gp.0 tn.0 VSS nfet_03v3 ad=1.235p pd=5.27u as=1.235p ps=5.27u w=4.75u l=0.5u
X234 VSS VSS sa.0 VSS nfet_03v3 ad=1.6984p pd=8.6u as=1.0036p ps=4.38u w=3.86u l=0.5u
X235 fb.0 gn.0 tp.0 tp.0 pfet_03v3 ad=1.248p pd=5.32u as=1.248p ps=5.32u w=4.8u l=0.4u
X236 fa.0 gp.0 tp.0 tp.0 pfet_03v3 ad=1.248p pd=5.32u as=1.248p ps=5.32u w=4.8u l=0.4u
X237 tp.0 VREF fa.0 tp.0 pfet_03v3 ad=1.248p pd=5.32u as=1.248p ps=5.32u w=4.8u l=0.4u
X238 tp.0 VREF fb.0 tp.0 pfet_03v3 ad=1.248p pd=5.32u as=1.248p ps=5.32u w=4.8u l=0.4u
X239 tp.0 VBP VDD VDD pfet_03v3 ad=1.3p pd=5.52u as=1.3p ps=5.52u w=5u l=1u
X240 tp.0 gn.0 fb.0 tp.0 pfet_03v3 ad=1.248p pd=5.32u as=1.248p ps=5.32u w=4.8u l=0.4u
X241 tp.0 gn.0 fb.0 tp.0 pfet_03v3 ad=1.248p pd=5.32u as=1.248p ps=5.32u w=4.8u l=0.4u
X242 VSS VBN ts.0 VSS nfet_03v3 ad=0.65p pd=3.02u as=0.65p ps=3.02u w=2.5u l=1u
X243 VSS VBN tn.0 VSS nfet_03v3 ad=0.65p pd=3.02u as=0.65p ps=3.02u w=2.5u l=1u
X244 tn.0 VREF oa.0 VSS nfet_03v3 ad=1.235p pd=5.27u as=1.235p ps=5.27u w=4.75u l=0.5u
X245 fa.0 gp.0 tp.0 tp.0 pfet_03v3 ad=1.248p pd=5.32u as=1.248p ps=5.32u w=4.8u l=0.4u
X246 VDD VDD i2.0 VDD pfet_03v3 ad=1.65p pd=8.38u as=0.975p ps=4.27u w=3.75u l=0.28u
X247 VDD d2a.0 n3a.0 VDD pfet_03v3 ad=0.52p pd=2.52u as=0.52p ps=2.52u w=2u l=0.4u
X248 VDD d2a.0 d2b.0 VDD pfet_03v3 ad=0.52p pd=2.52u as=0.52p ps=2.52u w=2u l=0.4u
X249 tp.0 gp.0 fa.0 tp.0 pfet_03v3 ad=1.248p pd=5.32u as=1.248p ps=5.32u w=4.8u l=0.4u
X250 VDD d2b.0 d2a.0 VDD pfet_03v3 ad=0.52p pd=2.52u as=0.52p ps=2.52u w=2u l=0.4u
X251 VSS VSS VSS VSS nfet_03v3 ad=0.39p pd=2.02u as=0 ps=0 w=1.5u l=0.28u
X252 sb.0 ob.0 d2b.0 VSS nfet_03v3 ad=1.0036p pd=4.38u as=1.0036p ps=4.38u w=3.86u l=0.5u
X253 fb.0 gn.0 tp.0 tp.0 pfet_03v3 ad=1.248p pd=5.32u as=1.248p ps=5.32u w=4.8u l=0.4u
X254 VSS VSS tn.0 VSS nfet_03v3 ad=1.1p pd=5.88u as=0.65p ps=3.02u w=2.5u l=1u
X255 ob.0 VREF tn.0 VSS nfet_03v3 ad=1.235p pd=5.27u as=1.235p ps=5.27u w=4.75u l=0.5u
X256 sa.0 oa.0 d2a.0 VSS nfet_03v3 ad=1.0036p pd=4.38u as=1.0036p ps=4.38u w=3.86u l=0.5u
X257 tp.0 gn.0 fb.0 tp.0 pfet_03v3 ad=1.248p pd=5.32u as=1.248p ps=5.32u w=4.8u l=0.4u
X258 fa.0 gp.0 tp.0 tp.0 pfet_03v3 ad=1.248p pd=5.32u as=1.248p ps=5.32u w=4.8u l=0.4u
X259 VSS VBN fb.0 VSS nfet_03v3 ad=0.65p pd=3.02u as=0.65p ps=3.02u w=2.5u l=1u
X260 ob.0 gn.0 tn.0 VSS nfet_03v3 ad=1.235p pd=5.27u as=1.235p ps=5.27u w=4.75u l=0.5u
X261 i2.0 i1.0 VDD VDD pfet_03v3 ad=0.975p pd=4.27u as=0.975p ps=4.27u w=3.75u l=0.28u
X262 sa.0 oa.0 d2a.0 VSS nfet_03v3 ad=1.0036p pd=4.38u as=1.0036p ps=4.38u w=3.86u l=0.5u
X263 VDD d2a.0 n3a.0 VDD pfet_03v3 ad=0.52p pd=2.52u as=0.52p ps=2.52u w=2u l=0.4u
X264 fb.0 VBN VSS VSS nfet_03v3 ad=0.65p pd=3.02u as=0.65p ps=3.02u w=2.5u l=1u
X265 fa.0 VBN VSS VSS nfet_03v3 ad=0.65p pd=3.02u as=0.65p ps=3.02u w=2.5u l=1u
X266 i1.0 VDD VDD VDD pfet_03v3 ad=0.962p pd=4.22u as=1.628p ps=8.28u w=3.7u l=0.28u
X267 n3a.0 d2a.0 VDD VDD pfet_03v3 ad=0.52p pd=2.52u as=0.52p ps=2.52u w=2u l=0.4u
X268 tn.0 VBN VSS VSS nfet_03v3 ad=0.65p pd=3.02u as=0.65p ps=3.02u w=2.5u l=1u
X269 VSS VBN fa.0 VSS nfet_03v3 ad=0.65p pd=3.02u as=0.65p ps=3.02u w=2.5u l=1u
X270 tp.0 VREF fa.0 tp.0 pfet_03v3 ad=1.248p pd=5.32u as=1.248p ps=5.32u w=4.8u l=0.4u
X271 fb.0 gn.0 tp.0 tp.0 pfet_03v3 ad=1.248p pd=5.32u as=1.248p ps=5.32u w=4.8u l=0.4u
X272 fa.0 gp.0 tp.0 tp.0 pfet_03v3 ad=1.248p pd=5.32u as=1.248p ps=5.32u w=4.8u l=0.4u
X273 OUT i2.0 VSS VSS nfet_03v3 ad=1.04p pd=4.52u as=1.04p ps=4.52u w=4u l=0.28u
X274 VDD VBP tp.0 VDD pfet_03v3 ad=1.3p pd=5.52u as=1.3p ps=5.52u w=5u l=1u
X275 VSS VBN fa.0 VSS nfet_03v3 ad=0.65p pd=3.02u as=0.65p ps=3.02u w=2.5u l=1u
X276 tp.0 gn.0 fb.0 tp.0 pfet_03v3 ad=1.248p pd=5.32u as=1.248p ps=5.32u w=4.8u l=0.4u
X277 fa.0 gp.0 tp.0 tp.0 pfet_03v3 ad=1.248p pd=5.32u as=1.248p ps=5.32u w=4.8u l=0.4u
X278 VDD i2.0 OUT VDD pfet_03v3 ad=1.3p pd=5.52u as=1.3p ps=5.52u w=5u l=0.28u
X279 d2b.0 d2a.0 VDD VDD pfet_03v3 ad=0.52p pd=2.52u as=0.52p ps=2.52u w=2u l=0.4u
X280 tp.0 VREF fb.0 tp.0 pfet_03v3 ad=1.248p pd=5.32u as=1.248p ps=5.32u w=4.8u l=0.4u
X281 fb.0 VBN VSS VSS nfet_03v3 ad=0.65p pd=3.02u as=0.65p ps=3.02u w=2.5u l=1u
X282 VDD d2a.0 d2a.0 VDD pfet_03v3 ad=0.52p pd=2.52u as=0.52p ps=2.52u w=2u l=0.4u
X283 VSS VSS VSS ppolyf_u_1k r_width=2u r_length=9.11u
X284 fa.0 VREF tp.0 tp.0 pfet_03v3 ad=1.248p pd=5.32u as=1.248p ps=5.32u w=4.8u l=0.4u
X285 ob.0 gn.0 tn.0 VSS nfet_03v3 ad=1.235p pd=5.27u as=1.235p ps=5.27u w=4.75u l=0.5u
X286 oa.0 gp.0 tn.0 VSS nfet_03v3 ad=1.235p pd=5.27u as=1.235p ps=5.27u w=4.75u l=0.5u
X287 VSS VSS OUT VSS nfet_03v3 ad=1.76p pd=8.88u as=1.04p ps=4.52u w=4u l=0.28u
X288 VDD VDD nd.0 VDD pfet_03v3 ad=1.32p pd=6.88u as=0.78p ps=3.52u w=3u l=0.28u
X289 tp.0 gp.0 fa.0 tp.0 pfet_03v3 ad=1.248p pd=5.32u as=1.248p ps=5.32u w=4.8u l=0.4u
X290 VDD VBP tp.0 VDD pfet_03v3 ad=1.3p pd=5.52u as=1.3p ps=5.52u w=5u l=1u
X291 tp.0 gp.0 fa.0 tp.0 pfet_03v3 ad=1.248p pd=5.32u as=1.248p ps=5.32u w=4.8u l=0.4u
X292 d2a.0 VDD VDD VDD pfet_03v3 ad=0.52p pd=2.52u as=0.88p ps=4.88u w=2u l=0.4u
X293 VDD d2b.0 d3.0 VDD pfet_03v3 ad=0.52p pd=2.52u as=0.52p ps=2.52u w=2u l=0.4u
X294 VDD VBP tp.0 VDD pfet_03v3 ad=1.3p pd=5.52u as=1.3p ps=5.52u w=5u l=1u
X295 d2b.0 d2a.0 VDD VDD pfet_03v3 ad=0.52p pd=2.52u as=0.52p ps=2.52u w=2u l=0.4u
X296 fb.0 VREF tp.0 tp.0 pfet_03v3 ad=1.248p pd=5.32u as=1.248p ps=5.32u w=4.8u l=0.4u
X297 oa.0 gp.0 tn.0 VSS nfet_03v3 ad=1.235p pd=5.27u as=1.235p ps=5.27u w=4.75u l=0.5u
X298 tp.0 VBP VDD VDD pfet_03v3 ad=1.3p pd=5.52u as=1.3p ps=5.52u w=5u l=1u
X299 tp.0 VBP VDD VDD pfet_03v3 ad=1.3p pd=5.52u as=1.3p ps=5.52u w=5u l=1u
X300 fa.0 VB2 oa.0 VSS nfet_03v3 ad=1.1752p pd=5.04u as=1.1752p ps=5.04u w=4.52u l=0.5u
X301 tp.0 gp.0 fa.0 tp.0 pfet_03v3 ad=1.248p pd=5.32u as=1.248p ps=5.32u w=4.8u l=0.4u
X302 fa.0 VB2 oa.0 VSS nfet_03v3 ad=1.1752p pd=5.04u as=1.1752p ps=5.04u w=4.52u l=0.5u
X303 ob.0 VB2 fb.0 VSS nfet_03v3 ad=1.1752p pd=5.04u as=1.1752p ps=5.04u w=4.52u l=0.5u
X304 d2b.0 d2a.0 VDD VDD pfet_03v3 ad=0.52p pd=2.52u as=0.52p ps=2.52u w=2u l=0.4u
X305 VSS VBN fb.0 VSS nfet_03v3 ad=0.65p pd=3.02u as=0.65p ps=3.02u w=2.5u l=1u
X306 ts.0 VBN VSS VSS nfet_03v3 ad=0.65p pd=3.02u as=0.65p ps=3.02u w=2.5u l=1u
X307 d3.0 n3a.0 VSS VSS nfet_03v3 ad=0.6734p pd=3.11u as=0.6734p ps=3.11u w=2.59u l=0.28u
X308 tp.0 VBP VDD VDD pfet_03v3 ad=1.3p pd=5.52u as=1.3p ps=5.52u w=5u l=1u
X309 fa.0 VREF tp.0 tp.0 pfet_03v3 ad=1.248p pd=5.32u as=1.248p ps=5.32u w=4.8u l=0.4u
X310 VSS VSS VSS ppolyf_u_1k r_width=2u r_length=8.86u
X311 fb.0 VREF tp.0 tp.0 pfet_03v3 ad=1.248p pd=5.32u as=1.248p ps=5.32u w=4.8u l=0.4u
X312 tp.0 VREF fb.0 tp.0 pfet_03v3 ad=1.248p pd=5.32u as=1.248p ps=5.32u w=4.8u l=0.4u
X313 tp.0 VREF fb.0 tp.0 pfet_03v3 ad=1.248p pd=5.32u as=1.248p ps=5.32u w=4.8u l=0.4u
X314 fa.0 VREF tp.0 tp.0 pfet_03v3 ad=1.248p pd=5.32u as=1.248p ps=5.32u w=4.8u l=0.4u
X315 oa.0 VREF tn.0 VSS nfet_03v3 ad=1.235p pd=5.27u as=1.235p ps=5.27u w=4.75u l=0.5u
X316 d2b.0 VDD VDD VDD pfet_03v3 ad=0.52p pd=2.52u as=0.88p ps=4.88u w=2u l=0.5u
C0 rla_m1.0 d2a.0 0.00155f
C1 INP VBP 0.03875f
C2 ob.0 sb.0 0.28465f
C3 ts.0 VREF 0.00271f
C4 d2b.0 sa.0 0.20733f
C5 ob.0 oa.0 0.59251f
C6 VB2 fb.0 2.14447f
C7 tp.0 VBP 3.37779f
C8 d3.0 d2a.0 2.65586f
C9 d2a.0 VDD 13.0234f
C10 rlb_m1.0 sa.0 0
C11 VBN VB2 0.12676f
C12 VB2 tp.0 0.05309f
C13 VBN fb.0 1.48704f
C14 VBN tn.0 0.82513f
C15 tp.0 fb.0 25.7437f
C16 VDD ts.0 0.55022f
C17 ob.0 VREF 2.70252f
C18 ob.0 gp.0 0.3633f
C19 d2a.0 sa.0 1.70252f
C20 EN nd.0 0.90578f
C21 VB2 oa.0 0.57905f
C22 i1.0 nd.0 0.21598f
C23 ob.0 VDD 1.9912f
C24 oa.0 tn.0 9.87797f
C25 INN VDD 2.56298f
C26 VBN oa.0 0.33374f
C27 VBP gp.0 0.26446f
C28 d2b.0 d2a.0 2.80463f
C29 ob.0 fa.0 0
C30 VB2 VREF 6.32706f
C31 VB2 gp.0 0.05601f
C32 ob.0 sa.0 0.01084f
C33 EN i1.0 0.26447f
C34 INP gp.0 0.14621f
C35 fb.0 VREF 2.88984f
C36 fb.0 gp.0 0.86843f
C37 tn.0 VREF 1.62411f
C38 tn.0 gp.0 1.20627f
C39 VBN VREF 0.90664f
C40 VBP VDD 28.4203f
C41 VBN gp.0 0.14191f
C42 tp.0 VREF 14.925f
C43 tp.0 gp.0 12.8757f
C44 VB2 VDD 0.12285f
C45 d3.0 nd.0 0.22426f
C46 nd.0 VDD 2.72518f
C47 INP VDD 2.26778f
C48 ob.0 gn.0 1.03804f
C49 nd.0 nm.0 0.2193f
C50 tn.0 VDD 0.19528f
C51 EN n3a.0 0.07539f
C52 gn.0 INN 0.14621f
C53 VBN VDD 0.13732f
C54 ob.0 d2b.0 0.20289f
C55 tp.0 VDD 11.3411f
C56 VB2 fa.0 1.75715f
C57 EN i2.0 0.31483f
C58 oa.0 VREF 2.14744f
C59 oa.0 gp.0 1.25114f
C60 fb.0 fa.0 0.80129f
C61 EN d3.0 0.54374f
C62 EN VDD 17.3635f
C63 VBN fa.0 2.39287f
C64 EN nm.0 0.02238f
C65 i1.0 i2.0 0.28557f
C66 tp.0 fa.0 25.3704f
C67 VBP gn.0 0.26446f
C68 EN OUT 0.00492f
C69 i1.0 VDD 2.62227f
C70 oa.0 VDD 1.59618f
C71 VB2 gn.0 0.05558f
C72 gp.0 VREF 1.91483f
C73 fb.0 gn.0 2.59553f
C74 tn.0 gn.0 0.99696f
C75 OUT i1.0 0
C76 VBN gn.0 0.11482f
C77 sb.0 sa.0 0.77697f
C78 tp.0 gn.0 13.4594f
C79 fa.0 oa.0 2.90441f
C80 sa.0 oa.0 0.20057f
C81 VDD VREF 0.13393f
C82 gp.0 VDD 4.53691f
C83 d3.0 n3a.0 0.59994f
C84 VDD n3a.0 5.30403f
C85 i2.0 VDD 4.2835f
C86 EN d2b.0 0.43087f
C87 fa.0 VREF 2.64932f
C88 fa.0 gp.0 2.44274f
C89 oa.0 gn.0 0.30476f
C90 d3.0 VDD 4.25479f
C91 d3.0 nm.0 0.01765f
C92 OUT i2.0 0.50501f
C93 rla_m1.0 sa.0 0.30587f
C94 d2b.0 sb.0 0.85915f
C95 OUT VDD 3.99882f
C96 VBN ts.0 0.52623f
C97 sa.0 VDD 0.00564f
C98 gn.0 VREF 2.33633f
C99 gn.0 gp.0 2.07546f
C100 EN d2a.0 0.18482f
C101 VBP INN 0.03712f
C102 VB2 ob.0 0.57476f
C103 d2b.0 n3a.0 0.50895f
C104 d2a.0 oa.0 0.23141f
C105 ob.0 fb.0 2.81909f
C106 d2b.0 rla_m1.0 0.00475f
C107 ob.0 tn.0 9.55392f
C108 gn.0 VDD 4.52025f
C109 VBN ob.0 0.19136f
C110 rlb_m1.0 rla_m1.0 0.39394f
C111 d3.0 d2b.0 0.35626f
C112 d2b.0 VDD 12.259f
C113 fa.0 gn.0 0.67123f
C114 d2a.0 n3a.0 0.37969f
C115 OUT VSS 5.22859f
C116 EN VSS 6.10061f
C117 VBN VSS 45.7239f
C118 VB2 VSS 9.2495f
C119 VREF VSS 12.3208f
C120 INN VSS 1.65907f
C121 VBP VSS 2.82194f
C122 INP VSS 1.94577f
C123 VDD VSS 0.21389p
C124 i2.0 VSS 4.24296f
C125 i1.0 VSS 3.72118f
C126 nm.0 VSS 0.31567f
C127 nd.0 VSS 3.35102f
C128 d3.0 VSS 5.75604f
C129 n3a.0 VSS 3.16279f
C130 sb.0 VSS 2.75864f
C131 d2b.0 VSS 4.72656f
C132 rlb_m1.0 VSS 1.11225f
C133 rla_m1.0 VSS 1.48073f
C134 sa.0 VSS 4.78816f
C135 d2a.0 VSS 3.05391f
C136 ts.0 VSS 5.5117f
C137 tn.0 VSS 4.38043f
C138 ob.0 VSS 7.30967f
C139 oa.0 VSS 7.54445f
C140 fa.0 VSS 9.0556f
C141 fb.0 VSS 7.93573f
C142 gn.0 VSS 13.9171f
C143 gp.0 VSS 14.0995f
C144 tp.0 VSS 0.1029p
.ends lvds_lane
