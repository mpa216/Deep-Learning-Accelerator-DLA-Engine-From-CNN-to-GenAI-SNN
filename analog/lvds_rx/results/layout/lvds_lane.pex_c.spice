* lvds_lane: parasitic C on all nets (coupling and to substrate, cthresh 0)
* GENERATED by layout/macro/run_macro.py (T10) from a GDS with sha256 44d8eaaa1b5fef2401515b3783b3092630e478448fff74602c9fc000cf7570bc -- do not edit by hand.
* Ports in the order of subckt lvds_lane of netlist/lvds_rx_lvs_ref.spice (Magic's own order was: INP INN OUT EN VBN VB2 VREF VBP VDD VSS).
* NGSPICE file created from lvds_lane.ext - technology: gf180mcuD

.subckt lvds_lane VDD VSS INP INN EN VBN VBP VB2 VREF OUT
X0 VSS VBN fb.0 VSS nfet_03v3 ad=0.65p pd=3.02u as=0.65p ps=3.02u w=2.5u l=1u
X1 tn.0 gn.0 ob.0 VSS nfet_03v3 ad=1.235p pd=5.27u as=1.235p ps=5.27u w=4.75u l=0.5u
X2 d2a.0 oa.0 sa.0 VSS nfet_03v3 ad=1.1362p pd=4.89u as=1.1362p ps=4.89u w=4.37u l=0.5u
X3 VDD VBP tp.0 VDD pfet_03v3 ad=1.3p pd=5.52u as=1.3p ps=5.52u w=5u l=1u
X4 fb.0 VREF tp.0 tp.0 pfet_03v3 ad=1.248p pd=5.32u as=1.248p ps=5.32u w=4.8u l=0.4u
X5 tn.0 gp.0 oa.0 VSS nfet_03v3 ad=1.235p pd=5.27u as=1.235p ps=5.27u w=4.75u l=0.5u
X6 tp.0 gn.0 fb.0 tp.0 pfet_03v3 ad=1.248p pd=5.32u as=1.248p ps=5.32u w=4.8u l=0.4u
X7 fb.0 VBN VSS VSS nfet_03v3 ad=0.65p pd=3.02u as=0.65p ps=3.02u w=2.5u l=1u
X8 fa.0 VBN VSS VSS nfet_03v3 ad=0.65p pd=3.02u as=0.65p ps=3.02u w=2.5u l=1u
X9 tp.0 VREF fb.0 tp.0 pfet_03v3 ad=1.248p pd=5.32u as=1.248p ps=5.32u w=4.8u l=0.4u
X10 tn.0 VBN VSS VSS nfet_03v3 ad=0.65p pd=3.02u as=0.65p ps=3.02u w=2.5u l=1u
X11 d3.0 d2b.0 VDD VDD pfet_03v3 ad=0.481p pd=2.37u as=0.481p ps=2.37u w=1.85u l=0.28u
X12 VSS VSS VSS ppolyf_u_1k r_width=2u r_length=9.11u
X13 fa.0 VB2 oa.0 VSS nfet_03v3 ad=1.1752p pd=5.04u as=1.1752p ps=5.04u w=4.52u l=0.5u
X14 VSS VBN fa.0 VSS nfet_03v3 ad=0.65p pd=3.02u as=0.65p ps=3.02u w=2.5u l=1u
X15 ob.0 VB2 fb.0 VSS nfet_03v3 ad=1.1752p pd=5.04u as=1.1752p ps=5.04u w=4.52u l=0.5u
X16 oa.0 VREF tn.0 VSS nfet_03v3 ad=1.235p pd=5.27u as=1.235p ps=5.27u w=4.75u l=0.5u
X17 fa.0 VB2 oa.0 VSS nfet_03v3 ad=1.1752p pd=5.04u as=1.1752p ps=5.04u w=4.52u l=0.5u
X18 VSS VBN fa.0 VSS nfet_03v3 ad=0.65p pd=3.02u as=0.65p ps=3.02u w=2.5u l=1u
X19 ob.0 VB2 fb.0 VSS nfet_03v3 ad=1.1752p pd=5.04u as=1.1752p ps=5.04u w=4.52u l=0.5u
X20 VDD VBP tp.0 VDD pfet_03v3 ad=1.3p pd=5.52u as=1.3p ps=5.52u w=5u l=1u
X21 ob.0 VSS VSS VSS nfet_03v3 ad=1.1752p pd=5.04u as=1.9888p ps=9.92u w=4.52u l=0.5u
X22 VDD VBP tp.0 VDD pfet_03v3 ad=1.3p pd=5.52u as=1.3p ps=5.52u w=5u l=1u
X23 tp.0 VREF fa.0 tp.0 pfet_03v3 ad=1.248p pd=5.32u as=1.248p ps=5.32u w=4.8u l=0.4u
X24 tp.0 VBP VDD VDD pfet_03v3 ad=1.3p pd=5.52u as=1.3p ps=5.52u w=5u l=1u
X25 fb.0 VBN VSS VSS nfet_03v3 ad=0.65p pd=3.02u as=0.65p ps=3.02u w=2.5u l=1u
X26 tn.0 VREF ob.0 VSS nfet_03v3 ad=1.235p pd=5.27u as=1.235p ps=5.27u w=4.75u l=0.5u
X27 tp.0 VBP VDD VDD pfet_03v3 ad=1.3p pd=5.52u as=1.3p ps=5.52u w=5u l=1u
X28 tp.0 gp.0 fa.0 tp.0 pfet_03v3 ad=1.248p pd=5.32u as=1.248p ps=5.32u w=4.8u l=0.4u
X29 VDD i1.0 i2.0 VDD pfet_03v3 ad=0.975p pd=4.27u as=0.975p ps=4.27u w=3.75u l=0.28u
X30 tn.0 gp.0 oa.0 VSS nfet_03v3 ad=1.235p pd=5.27u as=1.235p ps=5.27u w=4.75u l=0.5u
X31 d2a.0 d2b.0 VDD VDD pfet_03v3 ad=0.481p pd=2.37u as=0.481p ps=2.37u w=1.85u l=0.28u
X32 fb.0 VREF tp.0 tp.0 pfet_03v3 ad=1.248p pd=5.32u as=1.248p ps=5.32u w=4.8u l=0.4u
X33 VSS VSS ts.0 VSS nfet_03v3 ad=1.1p pd=5.88u as=0.65p ps=3.02u w=2.5u l=1u
X34 VDD nd.0 i1.0 VDD pfet_03v3 ad=0.962p pd=4.22u as=0.962p ps=4.22u w=3.7u l=0.28u
X35 tp.0 VREF fa.0 tp.0 pfet_03v3 ad=1.248p pd=5.32u as=1.248p ps=5.32u w=4.8u l=0.4u
X36 VSS VSS VSS ppolyf_u_1k r_width=5u r_length=1.64u
X37 tp.0 VREF fa.0 tp.0 pfet_03v3 ad=1.248p pd=5.32u as=1.248p ps=5.32u w=4.8u l=0.4u
X38 i2.0 VDD VDD VDD pfet_03v3 ad=0.975p pd=4.27u as=1.65p ps=8.38u w=3.75u l=0.28u
X39 tp.0 VBP VDD VDD pfet_03v3 ad=1.3p pd=5.52u as=1.3p ps=5.52u w=5u l=1u
X40 tp.0 gp.0 fa.0 tp.0 pfet_03v3 ad=1.248p pd=5.32u as=1.248p ps=5.32u w=4.8u l=0.4u
X41 VSS i2.0 OUT VSS nfet_03v3 ad=1.04p pd=4.52u as=1.04p ps=4.52u w=4u l=0.28u
X42 VDD VDD VDD VDD pfet_03v3 ad=0.962p pd=4.22u as=84.364p ps=0.39612m w=3.7u l=0.28u
X43 VDD d2b.0 d2a.0 VDD pfet_03v3 ad=0.481p pd=2.37u as=0.481p ps=2.37u w=1.85u l=0.28u
X44 fa.0 VREF tp.0 tp.0 pfet_03v3 ad=1.248p pd=5.32u as=1.248p ps=5.32u w=4.8u l=0.4u
X45 OUT i2.0 VDD VDD pfet_03v3 ad=1.3p pd=5.52u as=1.3p ps=5.52u w=5u l=0.28u
X46 ob.0 VREF tn.0 VSS nfet_03v3 ad=2.09p pd=10.38u as=1.235p ps=5.27u w=4.75u l=0.5u
X47 VSS VSS fb.0 VSS nfet_03v3 ad=1.9888p pd=9.92u as=1.1752p ps=5.04u w=4.52u l=0.5u
X48 tp.0 gn.0 fb.0 tp.0 pfet_03v3 ad=1.248p pd=5.32u as=1.248p ps=5.32u w=4.8u l=0.4u
X49 tp.0 gn.0 fb.0 tp.0 pfet_03v3 ad=1.248p pd=5.32u as=1.248p ps=5.32u w=4.8u l=0.4u
X50 VSS VBN fb.0 VSS nfet_03v3 ad=0.65p pd=3.02u as=0.65p ps=3.02u w=2.5u l=1u
X51 tn.0 gp.0 oa.0 VSS nfet_03v3 ad=1.235p pd=5.27u as=1.235p ps=5.27u w=4.75u l=0.5u
X52 ts.0 VBN VSS VSS nfet_03v3 ad=0.65p pd=3.02u as=0.65p ps=3.02u w=2.5u l=1u
X53 OUT VSS VSS VSS nfet_03v3 ad=1.04p pd=4.52u as=1.76p ps=8.88u w=4u l=0.28u
X54 fa.0 gp.0 tp.0 tp.0 pfet_03v3 ad=1.248p pd=5.32u as=1.248p ps=5.32u w=4.8u l=0.4u
X55 VSS VSS VSS VSS nfet_03v3 ad=0.78p pd=3.52u as=73.3704p ps=0.35732m w=3u l=0.28u
X56 VDD i2.0 OUT VDD pfet_03v3 ad=1.3p pd=5.52u as=1.3p ps=5.52u w=5u l=0.28u
X57 d2a.0 d2b.0 VDD VDD pfet_03v3 ad=0.481p pd=2.37u as=0.481p ps=2.37u w=1.85u l=0.28u
X58 fb.0 gn.0 tp.0 tp.0 pfet_03v3 ad=1.248p pd=5.32u as=1.248p ps=5.32u w=4.8u l=0.4u
X59 tn.0 VREF oa.0 VSS nfet_03v3 ad=1.235p pd=5.27u as=1.235p ps=5.27u w=4.75u l=0.5u
X60 nm.0 d3.0 nd.0 VSS nfet_03v3 ad=0.52p pd=2.52u as=0.52p ps=2.52u w=2u l=0.28u
X61 VDD d2b.0 d2b.0 VDD pfet_03v3 ad=0.481p pd=2.37u as=0.481p ps=2.37u w=1.85u l=0.28u
X62 VDD d2b.0 d3.0 VDD pfet_03v3 ad=0.481p pd=2.37u as=0.481p ps=2.37u w=1.85u l=0.28u
X63 tn.0 gn.0 ob.0 VSS nfet_03v3 ad=1.235p pd=5.27u as=1.235p ps=5.27u w=4.75u l=0.5u
X64 tn.0 gn.0 ob.0 VSS nfet_03v3 ad=1.235p pd=5.27u as=1.235p ps=5.27u w=4.75u l=0.5u
X65 VSS VBN ts.0 VSS nfet_03v3 ad=0.65p pd=3.02u as=0.65p ps=3.02u w=2.5u l=1u
X66 gp.0 INP VDD ppolyf_u r_width=5u r_length=1.8u
X67 tn.0 VBN VSS VSS nfet_03v3 ad=0.65p pd=3.02u as=0.65p ps=3.02u w=2.5u l=1u
X68 tn.0 gp.0 oa.0 VSS nfet_03v3 ad=1.235p pd=5.27u as=1.235p ps=5.27u w=4.75u l=0.5u
X69 ob.0 rlb_m1.0 VSS ppolyf_u_1k r_width=2u r_length=9.11u
D0 gn.0 VDD diode_pd2nw_03v3 pj=26u area=40p
X70 fa.0 VREF tp.0 tp.0 pfet_03v3 ad=1.248p pd=5.32u as=1.248p ps=5.32u w=4.8u l=0.4u
X71 fa.0 gp.0 tp.0 tp.0 pfet_03v3 ad=1.248p pd=5.32u as=1.248p ps=5.32u w=4.8u l=0.4u
X72 fb.0 VREF tp.0 tp.0 pfet_03v3 ad=2.112p pd=10.48u as=1.248p ps=5.32u w=4.8u l=0.4u
X73 ts.0 VBN VSS VSS nfet_03v3 ad=0.65p pd=3.02u as=0.65p ps=3.02u w=2.5u l=1u
X74 VDD VBP tp.0 VDD pfet_03v3 ad=1.3p pd=5.52u as=1.3p ps=5.52u w=5u l=1u
X75 fa.0 gp.0 tp.0 tp.0 pfet_03v3 ad=1.248p pd=5.32u as=1.248p ps=5.32u w=4.8u l=0.4u
X76 fb.0 gn.0 tp.0 tp.0 pfet_03v3 ad=1.248p pd=5.32u as=1.248p ps=5.32u w=4.8u l=0.4u
X77 VSS VBN fb.0 VSS nfet_03v3 ad=0.65p pd=3.02u as=0.65p ps=3.02u w=2.5u l=1u
X78 n3a.0 d2a.0 VDD VDD pfet_03v3 ad=0.481p pd=2.37u as=0.481p ps=2.37u w=1.85u l=0.28u
D1 VSS gn.0 diode_nd2ps_03v3 pj=26u area=40p
X79 VSS VBN ts.0 VSS nfet_03v3 ad=0.65p pd=3.02u as=0.65p ps=3.02u w=2.5u l=1u
X80 d3.0 d2b.0 VDD VDD pfet_03v3 ad=0.481p pd=2.37u as=0.481p ps=2.37u w=1.85u l=0.28u
X81 fb.0 VREF tp.0 tp.0 pfet_03v3 ad=1.248p pd=5.32u as=1.248p ps=5.32u w=4.8u l=0.4u
X82 VSS VBN tn.0 VSS nfet_03v3 ad=0.65p pd=3.02u as=0.65p ps=3.02u w=2.5u l=1u
X83 VSS VBN ts.0 VSS nfet_03v3 ad=0.65p pd=3.02u as=0.65p ps=3.02u w=2.5u l=1u
X84 tp.0 VBP VDD VDD pfet_03v3 ad=1.3p pd=5.52u as=1.3p ps=5.52u w=5u l=1u
X85 tp.0 VREF fa.0 tp.0 pfet_03v3 ad=1.248p pd=5.32u as=1.248p ps=5.32u w=4.8u l=0.4u
X86 fa.0 VREF tp.0 tp.0 pfet_03v3 ad=1.248p pd=5.32u as=1.248p ps=5.32u w=4.8u l=0.4u
X87 VDD rla_m1.0 VSS ppolyf_u_1k r_width=2u r_length=9.11u
X88 nd.0 VDD VDD VDD pfet_03v3 ad=0.78p pd=3.52u as=1.32p ps=6.88u w=3u l=0.28u
X89 fb.0 gn.0 tp.0 tp.0 pfet_03v3 ad=1.248p pd=5.32u as=1.248p ps=5.32u w=4.8u l=0.4u
X90 fa.0 gp.0 tp.0 tp.0 pfet_03v3 ad=1.248p pd=5.32u as=1.248p ps=5.32u w=4.8u l=0.4u
X91 tn.0 VREF ob.0 VSS nfet_03v3 ad=1.235p pd=5.27u as=1.235p ps=5.27u w=4.75u l=0.5u
X92 tp.0 gn.0 fb.0 tp.0 pfet_03v3 ad=1.248p pd=5.32u as=1.248p ps=5.32u w=4.8u l=0.4u
X93 oa.0 VB2 fa.0 VSS nfet_03v3 ad=1.1752p pd=5.04u as=1.1752p ps=5.04u w=4.52u l=0.5u
X94 VDD VDD VDD VDD pfet_03v3 ad=0.814p pd=4.58u as=0 ps=0 w=1.85u l=0.28u
X95 ts.0 sb.0 VSS ppolyf_u_1k r_width=5u r_length=1.64u
X96 VDD d2b.0 d2a.0 VDD pfet_03v3 ad=0.481p pd=2.37u as=0.481p ps=2.37u w=1.85u l=0.28u
X97 VDD d2a.0 n3a.0 VDD pfet_03v3 ad=0.481p pd=2.37u as=0.481p ps=2.37u w=1.85u l=0.28u
X98 VSS VSS VSS ppolyf_u_1k r_width=2u r_length=9.11u
X99 VDD VDD tp.0 VDD pfet_03v3 ad=2.2p pd=10.88u as=1.3p ps=5.52u w=5u l=1u
X100 tp.0 VBP VDD VDD pfet_03v3 ad=1.3p pd=5.52u as=1.3p ps=5.52u w=5u l=1u
X101 tp.0 gp.0 fa.0 tp.0 pfet_03v3 ad=1.248p pd=5.32u as=1.248p ps=5.32u w=4.8u l=0.4u
X102 fb.0 gn.0 tp.0 tp.0 pfet_03v3 ad=1.248p pd=5.32u as=1.248p ps=5.32u w=4.8u l=0.4u
X103 fa.0 VBN VSS VSS nfet_03v3 ad=0.65p pd=3.02u as=0.65p ps=3.02u w=2.5u l=1u
X104 fb.0 VBN VSS VSS nfet_03v3 ad=0.65p pd=3.02u as=0.65p ps=3.02u w=2.5u l=1u
X105 VDD d2b.0 d3.0 VDD pfet_03v3 ad=0.481p pd=2.37u as=0.481p ps=2.37u w=1.85u l=0.28u
X106 tp.0 gp.0 fa.0 tp.0 pfet_03v3 ad=1.248p pd=5.32u as=1.248p ps=5.32u w=4.8u l=0.4u
X107 VDD VDD VDD VDD pfet_03v3 ad=0.481p pd=2.37u as=0 ps=0 w=1.85u l=0.28u
X108 VSS VBN fb.0 VSS nfet_03v3 ad=0.65p pd=3.02u as=0.65p ps=3.02u w=2.5u l=1u
X109 VDD VBP tp.0 VDD pfet_03v3 ad=1.3p pd=5.52u as=1.3p ps=5.52u w=5u l=1u
X110 n3a.0 d2a.0 VDD VDD pfet_03v3 ad=0.481p pd=2.37u as=0.481p ps=2.37u w=1.85u l=0.28u
X111 fa.0 VREF tp.0 tp.0 pfet_03v3 ad=1.248p pd=5.32u as=1.248p ps=5.32u w=4.8u l=0.4u
X112 tp.0 VREF fb.0 tp.0 pfet_03v3 ad=1.248p pd=5.32u as=1.248p ps=5.32u w=4.8u l=0.4u
X113 VSS n3a.0 n3a.0 VSS nfet_03v3 ad=1.2116p pd=5.18u as=1.2116p ps=5.18u w=4.66u l=0.28u
X114 ts.0 sa.0 VSS ppolyf_u_1k r_width=5u r_length=1.64u
X115 fa.0 VREF tp.0 tp.0 pfet_03v3 ad=1.248p pd=5.32u as=1.248p ps=5.32u w=4.8u l=0.4u
X116 ob.0 gn.0 tn.0 VSS nfet_03v3 ad=1.235p pd=5.27u as=1.235p ps=5.27u w=4.75u l=0.5u
X117 d2b.0 VDD VDD VDD pfet_03v3 ad=0.52p pd=2.52u as=0.88p ps=4.88u w=2u l=0.5u
X118 n3a.0 VDD VDD VDD pfet_03v3 ad=0.481p pd=2.37u as=0.814p ps=4.58u w=1.85u l=0.28u
D2 VSS gp.0 diode_nd2ps_03v3 pj=26u area=40p
X119 tp.0 VBP VDD VDD pfet_03v3 ad=1.3p pd=5.52u as=1.3p ps=5.52u w=5u l=1u
X120 tp.0 gp.0 fa.0 tp.0 pfet_03v3 ad=1.248p pd=5.32u as=1.248p ps=5.32u w=4.8u l=0.4u
X121 VSS VSS fa.0 VSS nfet_03v3 ad=1.1p pd=5.88u as=0.65p ps=3.02u w=2.5u l=1u
X122 fb.0 VREF tp.0 tp.0 pfet_03v3 ad=1.248p pd=5.32u as=1.248p ps=5.32u w=4.8u l=0.4u
X123 tn.0 VREF ob.0 VSS nfet_03v3 ad=1.235p pd=5.27u as=2.09p ps=10.38u w=4.75u l=0.5u
X124 tn.0 VREF oa.0 VSS nfet_03v3 ad=1.235p pd=5.27u as=1.235p ps=5.27u w=4.75u l=0.5u
X125 VDD rlb_m1.0 VSS ppolyf_u_1k r_width=2u r_length=9.11u
D3 gp.0 VDD diode_pd2nw_03v3 pj=26u area=40p
X126 fa.0 VREF tp.0 tp.0 pfet_03v3 ad=1.248p pd=5.32u as=1.248p ps=5.32u w=4.8u l=0.4u
X127 oa.0 VB2 fa.0 VSS nfet_03v3 ad=1.1752p pd=5.04u as=1.1752p ps=5.04u w=4.52u l=0.5u
X128 VDD d2b.0 d3.0 VDD pfet_03v3 ad=0.481p pd=2.37u as=0.481p ps=2.37u w=1.85u l=0.28u
X129 VSS VSS fa.0 VSS nfet_03v3 ad=1.9888p pd=9.92u as=1.1752p ps=5.04u w=4.52u l=0.5u
X130 tn.0 gn.0 ob.0 VSS nfet_03v3 ad=1.235p pd=5.27u as=1.235p ps=5.27u w=4.75u l=0.5u
X131 tn.0 VREF ob.0 VSS nfet_03v3 ad=1.235p pd=5.27u as=1.235p ps=5.27u w=4.75u l=0.5u
X132 VDD d2a.0 n3a.0 VDD pfet_03v3 ad=0.481p pd=2.37u as=0.481p ps=2.37u w=1.85u l=0.28u
X133 VDD VBP tp.0 VDD pfet_03v3 ad=1.3p pd=5.52u as=1.3p ps=5.52u w=5u l=1u
X134 tp.0 VREF fb.0 tp.0 pfet_03v3 ad=1.248p pd=5.32u as=1.248p ps=5.32u w=4.8u l=0.4u
X135 fb.0 VB2 ob.0 VSS nfet_03v3 ad=1.1752p pd=5.04u as=1.1752p ps=5.04u w=4.52u l=0.5u
X136 fa.0 gp.0 tp.0 tp.0 pfet_03v3 ad=1.248p pd=5.32u as=1.248p ps=5.32u w=4.8u l=0.4u
X137 tp.0 gp.0 fa.0 tp.0 pfet_03v3 ad=1.248p pd=5.32u as=1.248p ps=5.32u w=4.8u l=0.4u
X138 fb.0 VREF tp.0 tp.0 pfet_03v3 ad=1.248p pd=5.32u as=1.248p ps=5.32u w=4.8u l=0.4u
X139 VSS VBN tn.0 VSS nfet_03v3 ad=0.65p pd=3.02u as=0.65p ps=3.02u w=2.5u l=1u
X140 oa.0 VREF tn.0 VSS nfet_03v3 ad=1.235p pd=5.27u as=1.235p ps=5.27u w=4.75u l=0.5u
X141 VSS VBN ts.0 VSS nfet_03v3 ad=0.65p pd=3.02u as=0.65p ps=3.02u w=2.5u l=1u
X142 fa.0 VBN VSS VSS nfet_03v3 ad=0.65p pd=3.02u as=0.65p ps=3.02u w=2.5u l=1u
X143 OUT VDD VDD VDD pfet_03v3 ad=1.3p pd=5.52u as=2.2p ps=10.88u w=5u l=0.28u
X144 VDD EN d2b.0 VDD pfet_03v3 ad=0.52p pd=2.52u as=0.52p ps=2.52u w=2u l=0.5u
X145 VDD d2b.0 d2a.0 VDD pfet_03v3 ad=0.481p pd=2.37u as=0.481p ps=2.37u w=1.85u l=0.28u
X146 VDD EN d2a.0 VDD pfet_03v3 ad=0.52p pd=2.52u as=0.52p ps=2.52u w=2u l=0.5u
X147 tp.0 gp.0 fa.0 tp.0 pfet_03v3 ad=1.248p pd=5.32u as=1.248p ps=5.32u w=4.8u l=0.4u
X148 tn.0 VSS VSS VSS nfet_03v3 ad=0.65p pd=3.02u as=1.1p ps=5.88u w=2.5u l=1u
X149 ts.0 VBN VSS VSS nfet_03v3 ad=0.65p pd=3.02u as=0.65p ps=3.02u w=2.5u l=1u
X150 d2b.0 ob.0 sb.0 VSS nfet_03v3 ad=1.1362p pd=4.89u as=1.1362p ps=4.89u w=4.37u l=0.5u
X151 tp.0 VREF fb.0 tp.0 pfet_03v3 ad=1.248p pd=5.32u as=1.248p ps=5.32u w=4.8u l=0.4u
X152 tp.0 gn.0 fb.0 tp.0 pfet_03v3 ad=1.248p pd=5.32u as=1.248p ps=5.32u w=4.8u l=0.4u
X153 sa.0 oa.0 d2a.0 VSS nfet_03v3 ad=1.1362p pd=4.89u as=1.1362p ps=4.89u w=4.37u l=0.5u
X154 VSS i1.0 i2.0 VSS nfet_03v3 ad=0.78p pd=3.52u as=0.78p ps=3.52u w=3u l=0.28u
X155 VSS nd.0 i1.0 VSS nfet_03v3 ad=0.39p pd=2.02u as=0.39p ps=2.02u w=1.5u l=0.28u
X156 VSS EN nm.0 VSS nfet_03v3 ad=0.52p pd=2.52u as=0.52p ps=2.52u w=2u l=0.28u
X157 tp.0 VREF fb.0 tp.0 pfet_03v3 ad=1.248p pd=5.32u as=1.248p ps=5.32u w=4.8u l=0.4u
X158 nd.0 VSS VSS VSS nfet_03v3 ad=0.52p pd=2.52u as=0.88p ps=4.88u w=2u l=0.28u
X159 oa.0 rla_m1.0 VSS ppolyf_u_1k r_width=2u r_length=9.11u
X160 tp.0 VREF fa.0 tp.0 pfet_03v3 ad=1.248p pd=5.32u as=1.248p ps=5.32u w=4.8u l=0.4u
X161 fb.0 VBN VSS VSS nfet_03v3 ad=0.65p pd=3.02u as=0.65p ps=3.02u w=2.5u l=1u
X162 tn.0 VBN VSS VSS nfet_03v3 ad=0.65p pd=3.02u as=0.65p ps=3.02u w=2.5u l=1u
X163 ts.0 VBN VSS VSS nfet_03v3 ad=0.65p pd=3.02u as=0.65p ps=3.02u w=2.5u l=1u
X164 fb.0 VREF tp.0 tp.0 pfet_03v3 ad=1.248p pd=5.32u as=1.248p ps=5.32u w=4.8u l=0.4u
X165 tp.0 VREF fa.0 tp.0 pfet_03v3 ad=1.248p pd=5.32u as=1.248p ps=5.32u w=4.8u l=0.4u
X166 oa.0 VSS VSS VSS nfet_03v3 ad=1.1752p pd=5.04u as=1.9888p ps=9.92u w=4.52u l=0.5u
X167 fb.0 VBN VSS VSS nfet_03v3 ad=0.65p pd=3.02u as=0.65p ps=3.02u w=2.5u l=1u
X168 tn.0 VREF oa.0 VSS nfet_03v3 ad=1.235p pd=5.27u as=1.235p ps=5.27u w=4.75u l=0.5u
X169 tn.0 VREF oa.0 VSS nfet_03v3 ad=1.235p pd=5.27u as=1.235p ps=5.27u w=4.75u l=0.5u
X170 VDD VDD OUT VDD pfet_03v3 ad=2.2p pd=10.88u as=1.3p ps=5.52u w=5u l=0.28u
X171 i2.0 VSS VSS VSS nfet_03v3 ad=0.78p pd=3.52u as=1.32p ps=6.88u w=3u l=0.28u
X172 VSS VSS VSS VSS nfet_03v3 ad=0.52p pd=2.52u as=0 ps=0 w=2u l=0.28u
X173 VDD VDD n3a.0 VDD pfet_03v3 ad=0.814p pd=4.58u as=0.481p ps=2.37u w=1.85u l=0.28u
X174 tp.0 VBP VDD VDD pfet_03v3 ad=1.3p pd=5.52u as=1.3p ps=5.52u w=5u l=1u
X175 tp.0 gn.0 fb.0 tp.0 pfet_03v3 ad=1.248p pd=5.32u as=1.248p ps=5.32u w=4.8u l=0.4u
X176 fa.0 VREF tp.0 tp.0 pfet_03v3 ad=1.248p pd=5.32u as=1.248p ps=5.32u w=4.8u l=0.4u
X177 oa.0 VB2 fa.0 VSS nfet_03v3 ad=1.1752p pd=5.04u as=1.1752p ps=5.04u w=4.52u l=0.5u
X178 fb.0 VB2 ob.0 VSS nfet_03v3 ad=1.1752p pd=5.04u as=1.1752p ps=5.04u w=4.52u l=0.5u
X179 tn.0 VREF ob.0 VSS nfet_03v3 ad=1.235p pd=5.27u as=1.235p ps=5.27u w=4.75u l=0.5u
X180 i1.0 VSS VSS VSS nfet_03v3 ad=0.39p pd=2.02u as=0.66p ps=3.88u w=1.5u l=0.28u
X181 VDD VBP tp.0 VDD pfet_03v3 ad=1.3p pd=5.52u as=1.3p ps=5.52u w=5u l=1u
X182 VSS VBN fa.0 VSS nfet_03v3 ad=0.65p pd=3.02u as=0.65p ps=3.02u w=2.5u l=1u
X183 VSS VBN fa.0 VSS nfet_03v3 ad=0.65p pd=3.02u as=0.65p ps=3.02u w=2.5u l=1u
X184 fb.0 VB2 ob.0 VSS nfet_03v3 ad=1.1752p pd=5.04u as=1.1752p ps=5.04u w=4.52u l=0.5u
X185 tn.0 gn.0 ob.0 VSS nfet_03v3 ad=1.235p pd=5.27u as=1.235p ps=5.27u w=4.75u l=0.5u
X186 VDD VBP tp.0 VDD pfet_03v3 ad=1.3p pd=5.52u as=1.3p ps=5.52u w=5u l=1u
X187 fb.0 gn.0 tp.0 tp.0 pfet_03v3 ad=1.248p pd=5.32u as=1.248p ps=5.32u w=4.8u l=0.4u
X188 tp.0 VREF fb.0 tp.0 pfet_03v3 ad=1.248p pd=5.32u as=1.248p ps=5.32u w=4.8u l=0.4u
X189 VDD d3.0 nd.0 VDD pfet_03v3 ad=0.78p pd=3.52u as=0.78p ps=3.52u w=3u l=0.28u
X190 gn.0 INN VDD ppolyf_u r_width=5u r_length=1.8u
X191 fa.0 VREF tp.0 tp.0 pfet_03v3 ad=1.248p pd=5.32u as=1.248p ps=5.32u w=4.8u l=0.4u
X192 OUT i2.0 VDD VDD pfet_03v3 ad=1.3p pd=5.52u as=1.3p ps=5.52u w=5u l=0.28u
X193 tp.0 VBP VDD VDD pfet_03v3 ad=1.3p pd=5.52u as=1.3p ps=5.52u w=5u l=1u
X194 fb.0 VREF tp.0 tp.0 pfet_03v3 ad=1.248p pd=5.32u as=1.248p ps=5.32u w=4.8u l=0.4u
X195 fa.0 VSS VSS VSS nfet_03v3 ad=0.65p pd=3.02u as=1.1p ps=5.88u w=2.5u l=1u
X196 ob.0 VREF tn.0 VSS nfet_03v3 ad=1.235p pd=5.27u as=1.235p ps=5.27u w=4.75u l=0.5u
X197 tp.0 VDD VDD VDD pfet_03v3 ad=1.3p pd=5.52u as=2.2p ps=10.88u w=5u l=1u
X198 fa.0 gp.0 tp.0 tp.0 pfet_03v3 ad=1.248p pd=5.32u as=1.248p ps=5.32u w=4.8u l=0.4u
X199 oa.0 gp.0 tn.0 VSS nfet_03v3 ad=1.235p pd=5.27u as=1.235p ps=5.27u w=4.75u l=0.5u
X200 d2a.0 d2a.0 VDD VDD pfet_03v3 ad=0.481p pd=2.37u as=0.481p ps=2.37u w=1.85u l=0.28u
X201 fb.0 gn.0 tp.0 tp.0 pfet_03v3 ad=1.248p pd=5.32u as=1.248p ps=5.32u w=4.8u l=0.4u
X202 VSS VBN fb.0 VSS nfet_03v3 ad=0.65p pd=3.02u as=0.65p ps=3.02u w=2.5u l=1u
X203 ob.0 gn.0 tn.0 VSS nfet_03v3 ad=1.235p pd=5.27u as=1.235p ps=5.27u w=4.75u l=0.5u
X204 d2a.0 d2b.0 VDD VDD pfet_03v3 ad=0.481p pd=2.37u as=0.481p ps=2.37u w=1.85u l=0.28u
X205 d3.0 d2b.0 VDD VDD pfet_03v3 ad=0.481p pd=2.37u as=0.481p ps=2.37u w=1.85u l=0.28u
X206 oa.0 gp.0 tn.0 VSS nfet_03v3 ad=1.235p pd=5.27u as=1.235p ps=5.27u w=4.75u l=0.5u
X207 nd.0 EN VDD VDD pfet_03v3 ad=0.78p pd=3.52u as=0.78p ps=3.52u w=3u l=0.28u
X208 VDD VBP tp.0 VDD pfet_03v3 ad=1.3p pd=5.52u as=1.3p ps=5.52u w=5u l=1u
X209 ob.0 gn.0 tn.0 VSS nfet_03v3 ad=1.235p pd=5.27u as=1.235p ps=5.27u w=4.75u l=0.5u
X210 oa.0 gp.0 tn.0 VSS nfet_03v3 ad=1.235p pd=5.27u as=1.235p ps=5.27u w=4.75u l=0.5u
X211 VDD d2a.0 d2a.0 VDD pfet_03v3 ad=0.481p pd=2.37u as=0.481p ps=2.37u w=1.85u l=0.28u
X212 VDD d2a.0 d2b.0 VDD pfet_03v3 ad=0.481p pd=2.37u as=0.481p ps=2.37u w=1.85u l=0.28u
X213 VDD d2b.0 d3.0 VDD pfet_03v3 ad=0.481p pd=2.37u as=0.481p ps=2.37u w=1.85u l=0.28u
X214 tp.0 VREF fa.0 tp.0 pfet_03v3 ad=1.248p pd=5.32u as=1.248p ps=5.32u w=4.8u l=0.4u
X215 fb.0 VREF tp.0 tp.0 pfet_03v3 ad=1.248p pd=5.32u as=1.248p ps=5.32u w=4.8u l=0.4u
X216 fb.0 gn.0 tp.0 tp.0 pfet_03v3 ad=1.248p pd=5.32u as=1.248p ps=5.32u w=4.8u l=0.4u
X217 d3.0 n3a.0 VSS VSS nfet_03v3 ad=1.2116p pd=5.18u as=1.2116p ps=5.18u w=4.66u l=0.28u
X218 sb.0 ob.0 d2b.0 VSS nfet_03v3 ad=1.1362p pd=4.89u as=1.1362p ps=4.89u w=4.37u l=0.5u
X219 tn.0 VREF oa.0 VSS nfet_03v3 ad=1.235p pd=5.27u as=1.235p ps=5.27u w=4.75u l=0.5u
X220 d2a.0 d2a.0 VDD VDD pfet_03v3 ad=0.481p pd=2.37u as=0.481p ps=2.37u w=1.85u l=0.28u
X221 n3a.0 VSS VSS VSS nfet_03v3 ad=1.2116p pd=5.18u as=2.0504p ps=10.2u w=4.66u l=0.28u
X222 fb.0 VB2 ob.0 VSS nfet_03v3 ad=1.1752p pd=5.04u as=1.1752p ps=5.04u w=4.52u l=0.5u
X223 tn.0 VBN VSS VSS nfet_03v3 ad=0.65p pd=3.02u as=0.65p ps=3.02u w=2.5u l=1u
X224 fb.0 gn.0 tp.0 tp.0 pfet_03v3 ad=1.248p pd=5.32u as=1.248p ps=5.32u w=4.8u l=0.4u
X225 fa.0 gp.0 tp.0 tp.0 pfet_03v3 ad=1.248p pd=5.32u as=1.248p ps=5.32u w=4.8u l=0.4u
X226 tp.0 VREF fa.0 tp.0 pfet_03v3 ad=1.248p pd=5.32u as=1.248p ps=5.32u w=4.8u l=0.4u
X227 tp.0 VREF fb.0 tp.0 pfet_03v3 ad=1.248p pd=5.32u as=1.248p ps=5.32u w=4.8u l=0.4u
X228 ts.0 VBN VSS VSS nfet_03v3 ad=0.65p pd=3.02u as=0.65p ps=3.02u w=2.5u l=1u
X229 VSS VBN tn.0 VSS nfet_03v3 ad=0.65p pd=3.02u as=0.65p ps=3.02u w=2.5u l=1u
X230 VSS VSS VSS ppolyf_u_1k r_width=5u r_length=1.64u
X231 tp.0 gn.0 fb.0 tp.0 pfet_03v3 ad=1.248p pd=5.32u as=1.248p ps=5.32u w=4.8u l=0.4u
X232 tp.0 VBP VDD VDD pfet_03v3 ad=1.3p pd=5.52u as=1.3p ps=5.52u w=5u l=1u
X233 tp.0 gn.0 fb.0 tp.0 pfet_03v3 ad=1.248p pd=5.32u as=1.248p ps=5.32u w=4.8u l=0.4u
X234 fa.0 VBN VSS VSS nfet_03v3 ad=0.65p pd=3.02u as=0.65p ps=3.02u w=2.5u l=1u
X235 ob.0 VREF tn.0 VSS nfet_03v3 ad=1.235p pd=5.27u as=1.235p ps=5.27u w=4.75u l=0.5u
X236 n3a.0 d2a.0 VDD VDD pfet_03v3 ad=0.481p pd=2.37u as=0.481p ps=2.37u w=1.85u l=0.28u
X237 ob.0 gn.0 tn.0 VSS nfet_03v3 ad=1.235p pd=5.27u as=1.235p ps=5.27u w=4.75u l=0.5u
X238 d3.0 d2b.0 VDD VDD pfet_03v3 ad=0.481p pd=2.37u as=0.481p ps=2.37u w=1.85u l=0.28u
X239 fa.0 gp.0 tp.0 tp.0 pfet_03v3 ad=1.248p pd=5.32u as=1.248p ps=5.32u w=4.8u l=0.4u
X240 ts.0 VSS VSS VSS nfet_03v3 ad=0.65p pd=3.02u as=1.1p ps=5.88u w=2.5u l=1u
X241 VSS VBN fa.0 VSS nfet_03v3 ad=0.65p pd=3.02u as=0.65p ps=3.02u w=2.5u l=1u
X242 tn.0 VBN VSS VSS nfet_03v3 ad=0.65p pd=3.02u as=0.65p ps=3.02u w=2.5u l=1u
X243 VDD VDD VDD VDD pfet_03v3 ad=0.52p pd=2.52u as=0 ps=0 w=2u l=0.5u
X244 tp.0 gp.0 fa.0 tp.0 pfet_03v3 ad=1.248p pd=5.32u as=1.248p ps=5.32u w=4.8u l=0.4u
X245 fb.0 gn.0 tp.0 tp.0 pfet_03v3 ad=1.248p pd=5.32u as=1.248p ps=5.32u w=4.8u l=0.4u
X246 VSS VBN tn.0 VSS nfet_03v3 ad=0.65p pd=3.02u as=0.65p ps=3.02u w=2.5u l=1u
X247 tp.0 gn.0 fb.0 tp.0 pfet_03v3 ad=1.248p pd=5.32u as=1.248p ps=5.32u w=4.8u l=0.4u
X248 fa.0 gp.0 tp.0 tp.0 pfet_03v3 ad=1.248p pd=5.32u as=1.248p ps=5.32u w=4.8u l=0.4u
X249 VSS VBN ts.0 VSS nfet_03v3 ad=0.65p pd=3.02u as=0.65p ps=3.02u w=2.5u l=1u
X250 VDD VDD i2.0 VDD pfet_03v3 ad=1.65p pd=8.38u as=0.975p ps=4.27u w=3.75u l=0.28u
X251 d2b.0 d2a.0 VDD VDD pfet_03v3 ad=0.481p pd=2.37u as=0.481p ps=2.37u w=1.85u l=0.28u
X252 fa.0 VBN VSS VSS nfet_03v3 ad=0.65p pd=3.02u as=0.65p ps=3.02u w=2.5u l=1u
X253 tp.0 VBP VDD VDD pfet_03v3 ad=1.3p pd=5.52u as=1.3p ps=5.52u w=5u l=1u
X254 VSS VSS VSS VSS nfet_03v3 ad=0.39p pd=2.02u as=0 ps=0 w=1.5u l=0.28u
X255 VSS VBN fa.0 VSS nfet_03v3 ad=0.65p pd=3.02u as=0.65p ps=3.02u w=2.5u l=1u
X256 ob.0 gn.0 tn.0 VSS nfet_03v3 ad=1.235p pd=5.27u as=1.235p ps=5.27u w=4.75u l=0.5u
X257 i2.0 i1.0 VDD VDD pfet_03v3 ad=0.975p pd=4.27u as=0.975p ps=4.27u w=3.75u l=0.28u
X258 tp.0 VREF fa.0 tp.0 pfet_03v3 ad=1.248p pd=5.32u as=1.248p ps=5.32u w=4.8u l=0.4u
X259 fb.0 gn.0 tp.0 tp.0 pfet_03v3 ad=1.248p pd=5.32u as=1.248p ps=5.32u w=4.8u l=0.4u
X260 fa.0 gp.0 tp.0 tp.0 pfet_03v3 ad=1.248p pd=5.32u as=1.248p ps=5.32u w=4.8u l=0.4u
X261 oa.0 gp.0 tn.0 VSS nfet_03v3 ad=1.235p pd=5.27u as=1.235p ps=5.27u w=4.75u l=0.5u
X262 VDD d2a.0 d2b.0 VDD pfet_03v3 ad=0.481p pd=2.37u as=0.481p ps=2.37u w=1.85u l=0.28u
X263 i1.0 VDD VDD VDD pfet_03v3 ad=0.962p pd=4.22u as=1.628p ps=8.28u w=3.7u l=0.28u
X264 tp.0 gn.0 fb.0 tp.0 pfet_03v3 ad=1.248p pd=5.32u as=1.248p ps=5.32u w=4.8u l=0.4u
X265 fa.0 gp.0 tp.0 tp.0 pfet_03v3 ad=1.248p pd=5.32u as=1.248p ps=5.32u w=4.8u l=0.4u
X266 fa.0 VBN VSS VSS nfet_03v3 ad=0.65p pd=3.02u as=0.65p ps=3.02u w=2.5u l=1u
X267 tp.0 VREF fb.0 tp.0 pfet_03v3 ad=1.248p pd=5.32u as=1.248p ps=5.32u w=4.8u l=0.4u
X268 oa.0 gp.0 tn.0 VSS nfet_03v3 ad=1.235p pd=5.27u as=1.235p ps=5.27u w=4.75u l=0.5u
X269 fa.0 VREF tp.0 tp.0 pfet_03v3 ad=1.248p pd=5.32u as=1.248p ps=5.32u w=4.8u l=0.4u
X270 OUT i2.0 VSS VSS nfet_03v3 ad=1.04p pd=4.52u as=1.04p ps=4.52u w=4u l=0.28u
X271 VDD VBP tp.0 VDD pfet_03v3 ad=1.3p pd=5.52u as=1.3p ps=5.52u w=5u l=1u
X272 VSS VBN fb.0 VSS nfet_03v3 ad=0.65p pd=3.02u as=0.65p ps=3.02u w=2.5u l=1u
X273 VDD VBP tp.0 VDD pfet_03v3 ad=1.3p pd=5.52u as=1.3p ps=5.52u w=5u l=1u
X274 tp.0 gp.0 fa.0 tp.0 pfet_03v3 ad=1.248p pd=5.32u as=1.248p ps=5.32u w=4.8u l=0.4u
X275 VDD i2.0 OUT VDD pfet_03v3 ad=1.3p pd=5.52u as=1.3p ps=5.52u w=5u l=0.28u
X276 tp.0 gp.0 fa.0 tp.0 pfet_03v3 ad=1.248p pd=5.32u as=1.248p ps=5.32u w=4.8u l=0.4u
X277 VDD d2a.0 d2a.0 VDD pfet_03v3 ad=0.481p pd=2.37u as=0.481p ps=2.37u w=1.85u l=0.28u
X278 fb.0 VREF tp.0 tp.0 pfet_03v3 ad=1.248p pd=5.32u as=1.248p ps=5.32u w=4.8u l=0.4u
X279 tp.0 VBP VDD VDD pfet_03v3 ad=1.3p pd=5.52u as=1.3p ps=5.52u w=5u l=1u
X280 fb.0 VBN VSS VSS nfet_03v3 ad=0.65p pd=3.02u as=0.65p ps=3.02u w=2.5u l=1u
X281 VSS VSS OUT VSS nfet_03v3 ad=1.76p pd=8.88u as=1.04p ps=4.52u w=4u l=0.28u
X282 VDD VDD nd.0 VDD pfet_03v3 ad=1.32p pd=6.88u as=0.78p ps=3.52u w=3u l=0.28u
X283 oa.0 VREF tn.0 VSS nfet_03v3 ad=1.235p pd=5.27u as=1.235p ps=5.27u w=4.75u l=0.5u
X284 fa.0 VB2 oa.0 VSS nfet_03v3 ad=1.1752p pd=5.04u as=1.1752p ps=5.04u w=4.52u l=0.5u
X285 ob.0 VREF tn.0 VSS nfet_03v3 ad=1.235p pd=5.27u as=1.235p ps=5.27u w=4.75u l=0.5u
X286 d2b.0 VSS VSS VSS nfet_03v3 ad=1.1362p pd=4.89u as=1.9228p ps=9.62u w=4.37u l=0.5u
X287 tp.0 gp.0 fa.0 tp.0 pfet_03v3 ad=1.248p pd=5.32u as=1.248p ps=5.32u w=4.8u l=0.4u
X288 fa.0 VB2 oa.0 VSS nfet_03v3 ad=1.1752p pd=5.04u as=1.1752p ps=5.04u w=4.52u l=0.5u
X289 oa.0 VREF tn.0 VSS nfet_03v3 ad=1.235p pd=5.27u as=1.235p ps=5.27u w=4.75u l=0.5u
X290 oa.0 VREF tn.0 VSS nfet_03v3 ad=1.235p pd=5.27u as=1.235p ps=5.27u w=4.75u l=0.5u
X291 d2b.0 d2a.0 VDD VDD pfet_03v3 ad=0.481p pd=2.37u as=0.481p ps=2.37u w=1.85u l=0.28u
X292 d2b.0 d2b.0 VDD VDD pfet_03v3 ad=0.481p pd=2.37u as=0.481p ps=2.37u w=1.85u l=0.28u
X293 VSS VSS d2a.0 VSS nfet_03v3 ad=1.9228p pd=9.62u as=1.1362p ps=4.89u w=4.37u l=0.5u
X294 ob.0 VB2 fb.0 VSS nfet_03v3 ad=1.1752p pd=5.04u as=1.1752p ps=5.04u w=4.52u l=0.5u
X295 ob.0 VREF tn.0 VSS nfet_03v3 ad=1.235p pd=5.27u as=1.235p ps=5.27u w=4.75u l=0.5u
X296 d2b.0 d2a.0 VDD VDD pfet_03v3 ad=0.481p pd=2.37u as=0.481p ps=2.37u w=1.85u l=0.28u
X297 n3a.0 d2a.0 VDD VDD pfet_03v3 ad=0.481p pd=2.37u as=0.481p ps=2.37u w=1.85u l=0.28u
X298 fa.0 VREF tp.0 tp.0 pfet_03v3 ad=1.248p pd=5.32u as=1.248p ps=5.32u w=4.8u l=0.4u
X299 fb.0 VREF tp.0 tp.0 pfet_03v3 ad=1.248p pd=5.32u as=1.248p ps=5.32u w=4.8u l=0.4u
X300 VSS VBN ts.0 VSS nfet_03v3 ad=0.65p pd=3.02u as=0.65p ps=3.02u w=2.5u l=1u
X301 VSS VSS d3.0 VSS nfet_03v3 ad=2.0504p pd=10.2u as=1.2116p ps=5.18u w=4.66u l=0.28u
X302 tp.0 VREF fb.0 tp.0 pfet_03v3 ad=1.248p pd=5.32u as=1.248p ps=5.32u w=4.8u l=0.4u
X303 tp.0 VREF fb.0 tp.0 pfet_03v3 ad=1.248p pd=5.32u as=1.248p ps=5.32u w=4.8u l=0.4u
X304 fa.0 VREF tp.0 tp.0 pfet_03v3 ad=1.248p pd=5.32u as=1.248p ps=5.32u w=4.8u l=0.4u
X305 VSS VBN tn.0 VSS nfet_03v3 ad=0.65p pd=3.02u as=0.65p ps=3.02u w=2.5u l=1u
X306 VDD d2b.0 d2b.0 VDD pfet_03v3 ad=0.481p pd=2.37u as=0.481p ps=2.37u w=1.85u l=0.28u
X307 tp.0 gn.0 fb.0 tp.0 pfet_03v3 ad=1.248p pd=5.32u as=1.248p ps=5.32u w=4.8u l=0.4u
X308 VDD VDD VDD VDD pfet_03v3 ad=0.52p pd=2.52u as=0 ps=0 w=2u l=0.5u
X309 VDD d2a.0 d2b.0 VDD pfet_03v3 ad=0.481p pd=2.37u as=0.481p ps=2.37u w=1.85u l=0.28u
X310 VDD d2a.0 n3a.0 VDD pfet_03v3 ad=0.481p pd=2.37u as=0.481p ps=2.37u w=1.85u l=0.28u
X311 tp.0 VREF fb.0 tp.0 pfet_03v3 ad=1.248p pd=5.32u as=2.112p ps=10.48u w=4.8u l=0.4u
X312 fb.0 gn.0 tp.0 tp.0 pfet_03v3 ad=1.248p pd=5.32u as=1.248p ps=5.32u w=4.8u l=0.4u
X313 tn.0 gp.0 oa.0 VSS nfet_03v3 ad=1.235p pd=5.27u as=1.235p ps=5.27u w=4.75u l=0.5u
X314 d2a.0 VDD VDD VDD pfet_03v3 ad=0.52p pd=2.52u as=0.88p ps=4.88u w=2u l=0.5u
X315 ts.0 VBN VSS VSS nfet_03v3 ad=0.65p pd=3.02u as=0.65p ps=3.02u w=2.5u l=1u
X316 VSS VSS d2b.0 VSS nfet_03v3 ad=1.9228p pd=9.62u as=1.1362p ps=4.89u w=4.37u l=0.5u
X317 tp.0 VREF fa.0 tp.0 pfet_03v3 ad=1.248p pd=5.32u as=1.248p ps=5.32u w=4.8u l=0.4u
X318 tp.0 VREF fa.0 tp.0 pfet_03v3 ad=1.248p pd=5.32u as=1.248p ps=5.32u w=4.8u l=0.4u
X319 VSS VSS tn.0 VSS nfet_03v3 ad=1.1p pd=5.88u as=0.65p ps=3.02u w=2.5u l=1u
X320 d2a.0 VSS VSS VSS nfet_03v3 ad=1.1362p pd=4.89u as=1.9228p ps=9.62u w=4.37u l=0.5u
X321 d2b.0 d2b.0 VDD VDD pfet_03v3 ad=0.481p pd=2.37u as=0.481p ps=2.37u w=1.85u l=0.28u
X322 VDD d2a.0 n3a.0 VDD pfet_03v3 ad=0.481p pd=2.37u as=0.481p ps=2.37u w=1.85u l=0.28u
C0 VDD d3.0 4.26183f
C1 EN nd.0 0.90578f
C2 OUT EN 0.00492f
C3 ob.0 d2b.0 0.16374f
C4 VB2 ob.0 0.58885f
C5 VDD EN 16.9113f
C6 oa.0 gp.0 1.26032f
C7 fb.0 fa.0 0.8011f
C8 i1.0 i2.0 0.28557f
C9 tp.0 fa.0 25.37f
C10 fa.0 VBN 2.18465f
C11 VREF ts.0 0.00271f
C12 fb.0 gn.0 2.60941f
C13 tn.0 gn.0 0.99696f
C14 i1.0 EN 0.26447f
C15 VDD gn.0 4.52025f
C16 INN gn.0 0.14621f
C17 sb.0 sa.0 1.08061f
C18 VBP gn.0 0.26446f
C19 tp.0 gn.0 13.4751f
C20 VBN gn.0 0.27781f
C21 fa.0 oa.0 2.94526f
C22 sa.0 oa.0 0.14911f
C23 VB2 fb.0 2.09462f
C24 VDD d2b.0 10.8442f
C25 VREF ob.0 2.70252f
C26 VB2 VDD 0.12285f
C27 d3.0 n3a.0 0.46613f
C28 VB2 tp.0 0.05309f
C29 VB2 VBN 0.12676f
C30 EN n3a.0 0.00401f
C31 fa.0 gp.0 2.42263f
C32 oa.0 gn.0 0.30476f
C33 d3.0 nm.0 0.01765f
C34 EN i2.0 0.31277f
C35 rla_m1.0 sa.0 0.30587f
C36 d2b.0 sb.0 0.68313f
C37 VDD d2a.0 12.736f
C38 d3.0 EN 0.4675f
C39 VB2 oa.0 0.59315f
C40 EN nm.0 0.02238f
C41 VDD ts.0 0.60574f
C42 gn.0 gp.0 2.07546f
C43 VBN ts.0 1.02135f
C44 VREF fb.0 2.62815f
C45 VREF tn.0 1.62411f
C46 VREF VDD 0.13393f
C47 INP VDD 2.26778f
C48 VREF tp.0 14.9051f
C49 VREF VBN 0.90664f
C50 d2b.0 n3a.0 0.17133f
C51 VB2 gp.0 0.04355f
C52 VBP INP 0.03875f
C53 d2a.0 oa.0 0.16422f
C54 ob.0 fb.0 2.91705f
C55 d2b.0 rla_m1.0 0.00423f
C56 ob.0 tn.0 9.55392f
C57 VDD ob.0 1.95948f
C58 sb.0 ts.0 0.20041f
C59 rlb_m1.0 rla_m1.0 0.39394f
C60 ob.0 VBN 0.17663f
C61 d3.0 d2b.0 0.22886f
C62 VREF oa.0 2.14744f
C63 fa.0 gn.0 0.66886f
C64 d2a.0 n3a.0 0.2367f
C65 d2b.0 EN 0.31138f
C66 rla_m1.0 d2a.0 0
C67 ob.0 sb.0 0.20964f
C68 d2b.0 sa.0 0.20987f
C69 ob.0 oa.0 0.59251f
C70 VB2 fa.0 1.71129f
C71 d3.0 d2a.0 0.63055f
C72 rlb_m1.0 sa.0 0
C73 VREF gp.0 2.30895f
C74 VDD nd.0 2.7235f
C75 OUT VDD 3.99882f
C76 VDD tn.0 0.2078f
C77 INP gp.0 0.14621f
C78 INN VDD 2.56298f
C79 EN d2a.0 0.19588f
C80 tp.0 fb.0 25.7432f
C81 fb.0 VBN 1.50358f
C82 VBP VDD 28.4203f
C83 VBN tn.0 0.82513f
C84 VBP INN 0.03712f
C85 VDD tp.0 11.3411f
C86 VDD VBN 0.15007f
C87 ob.0 gp.0 0.36334f
C88 VB2 gn.0 0.04523f
C89 VBP tp.0 3.37779f
C90 d2a.0 sa.0 1.67001f
C91 sa.0 ts.0 0.13628f
C92 i1.0 nd.0 0.21598f
C93 OUT i1.0 0
C94 oa.0 tn.0 9.87791f
C95 VDD i1.0 2.62233f
C96 VREF fa.0 2.48886f
C97 VDD oa.0 1.56447f
C98 VBN oa.0 0.31902f
C99 d2b.0 d2a.0 4.0714f
C100 ob.0 fa.0 0
C101 ob.0 sa.0 0.00738f
C102 fb.0 gp.0 0.89735f
C103 tn.0 gp.0 1.20295f
C104 VDD gp.0 4.52291f
C105 VREF gn.0 2.83689f
C106 VDD n3a.0 4.03663f
C107 VBP gp.0 0.26446f
C108 OUT i2.0 0.50501f
C109 tp.0 gp.0 12.8915f
C110 VBN gp.0 0.57567f
C111 VDD i2.0 4.28491f
C112 d3.0 nd.0 0.22426f
C113 VB2 VREF 6.32287f
C114 ob.0 gn.0 1.01627f
C115 nd.0 nm.0 0.2193f
C116 OUT VSS 5.22859f
C117 EN VSS 6.32527f
C118 VBN VSS 48.9231f
C119 VB2 VSS 9.27941f
C120 VREF VSS 12.1233f
C121 INN VSS 1.65907f
C122 VBP VSS 2.82194f
C123 INP VSS 1.94577f
C124 VDD VSS 0.21112p
C125 i2.0 VSS 4.24421f
C126 i1.0 VSS 3.72118f
C127 nm.0 VSS 0.31567f
C128 nd.0 VSS 3.35368f
C129 d3.0 VSS 4.52287f
C130 n3a.0 VSS 3.27138f
C131 sb.0 VSS 3.38771f
C132 d2b.0 VSS 4.93292f
C133 rlb_m1.0 VSS 1.11225f
C134 rla_m1.0 VSS 1.48222f
C135 sa.0 VSS 5.03563f
C136 d2a.0 VSS 4.01425f
C137 ts.0 VSS 8.96904f
C138 tn.0 VSS 4.38184f
C139 ob.0 VSS 6.96006f
C140 oa.0 VSS 7.17837f
C141 fa.0 VSS 9.29453f
C142 fb.0 VSS 8.10808f
C143 gn.0 VSS 13.2934f
C144 gp.0 VSS 13.3739f
C145 tp.0 VSS 0.1029p
.ends lvds_lane
