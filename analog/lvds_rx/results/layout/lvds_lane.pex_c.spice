* lvds_lane: parasitic C on all nets (coupling and to substrate, cthresh 0)
* GENERATED by layout/macro/run_macro.py (T10) from a GDS with sha256 f71aecad1ad41a1eaad0c62a96379acec1870f6dccee852c35586f9f4c3a63a2 -- do not edit by hand.
* Ports in the order of subckt lvds_lane of netlist/lvds_rx_lvs_ref.spice (Magic's own order was: INP INN OUT EN VBN VB2 VREF VBP VDD VSS).
* NGSPICE file created from lvds_lane.ext - technology: gf180mcuD

.subckt lvds_lane VDD VSS INP INN EN VBN VBP VB2 VREF OUT
X0 tp.0 gn.0 fb.0 tp.0 pfet_03v3 ad=1.248p pd=5.32u as=1.248p ps=5.32u w=4.8u l=0.4u
X1 ob.0 VREF tn.0 VSS nfet_03v3 ad=1.235p pd=5.27u as=1.235p ps=5.27u w=4.75u l=0.5u
X2 oa.0 VREF tn.0 VSS nfet_03v3 ad=1.235p pd=5.27u as=1.235p ps=5.27u w=4.75u l=0.5u
X3 tp.0 VREF fb.0 tp.0 pfet_03v3 ad=1.248p pd=5.32u as=2.112p ps=10.48u w=4.8u l=0.4u
X4 fb.0 gn.0 tp.0 tp.0 pfet_03v3 ad=1.248p pd=5.32u as=1.248p ps=5.32u w=4.8u l=0.4u
X5 oa.0 VREF tn.0 VSS nfet_03v3 ad=1.235p pd=5.27u as=1.235p ps=5.27u w=4.75u l=0.5u
X6 ob.0 VREF tn.0 VSS nfet_03v3 ad=1.235p pd=5.27u as=1.235p ps=5.27u w=4.75u l=0.5u
X7 VSS VBN ts.0 VSS nfet_03v3 ad=0.65p pd=3.02u as=0.65p ps=3.02u w=2.5u l=1u
X8 tn.0 VBN VSS VSS nfet_03v3 ad=0.65p pd=3.02u as=0.65p ps=3.02u w=2.5u l=1u
X9 tp.0 VREF fa.0 tp.0 pfet_03v3 ad=1.248p pd=5.32u as=1.248p ps=5.32u w=4.8u l=0.4u
X10 ts.0 VBN VSS VSS nfet_03v3 ad=0.65p pd=3.02u as=0.65p ps=3.02u w=2.5u l=1u
X11 tp.0 VREF fa.0 tp.0 pfet_03v3 ad=1.248p pd=5.32u as=1.248p ps=5.32u w=4.8u l=0.4u
X12 VDD d2a.0 n3a.0 VDD pfet_03v3 ad=0.52p pd=2.52u as=0.52p ps=2.52u w=2u l=0.28u
X13 fb.0 VREF tp.0 tp.0 pfet_03v3 ad=1.248p pd=5.32u as=1.248p ps=5.32u w=4.8u l=0.4u
X14 VSS VBN fb.0 VSS nfet_03v3 ad=0.65p pd=3.02u as=0.65p ps=3.02u w=2.5u l=1u
X15 VSS VBN ts.0 VSS nfet_03v3 ad=0.65p pd=3.02u as=0.65p ps=3.02u w=2.5u l=1u
X16 tp.0 gn.0 fb.0 tp.0 pfet_03v3 ad=1.248p pd=5.32u as=1.248p ps=5.32u w=4.8u l=0.4u
X17 VSS VBN tn.0 VSS nfet_03v3 ad=0.65p pd=3.02u as=0.65p ps=3.02u w=2.5u l=1u
X18 tn.0 gp.0 oa.0 VSS nfet_03v3 ad=1.235p pd=5.27u as=1.235p ps=5.27u w=4.75u l=0.5u
X19 gp.0 INP VDD ppolyf_u r_width=5u r_length=1.8u
X20 tp.0 VREF fb.0 tp.0 pfet_03v3 ad=1.248p pd=5.32u as=1.248p ps=5.32u w=4.8u l=0.4u
X21 VSS VBN ts.0 VSS nfet_03v3 ad=0.65p pd=3.02u as=0.65p ps=3.02u w=2.5u l=1u
X22 ob.0 rlb_m1.0 VSS ppolyf_u_1k r_width=2u r_length=9.11u
X23 fa.0 VB2 oa.0 VSS nfet_03v3 ad=1.1752p pd=5.04u as=1.1752p ps=5.04u w=4.52u l=0.5u
X24 ob.0 VB2 fb.0 VSS nfet_03v3 ad=1.1752p pd=5.04u as=1.1752p ps=5.04u w=4.52u l=0.5u
X25 VDD VBP tp.0 VDD pfet_03v3 ad=1.3p pd=5.52u as=1.3p ps=5.52u w=5u l=1u
X26 fa.0 VB2 oa.0 VSS nfet_03v3 ad=1.1752p pd=5.04u as=1.1752p ps=5.04u w=4.52u l=0.5u
X27 ob.0 VB2 fb.0 VSS nfet_03v3 ad=1.1752p pd=5.04u as=1.1752p ps=5.04u w=4.52u l=0.5u
X28 tn.0 gn.0 ob.0 VSS nfet_03v3 ad=1.235p pd=5.27u as=1.235p ps=5.27u w=4.75u l=0.5u
X29 VDD i1.0 i2.0 VDD pfet_03v3 ad=0.975p pd=4.27u as=0.975p ps=4.27u w=3.75u l=0.28u
X30 tp.0 VREF fa.0 tp.0 pfet_03v3 ad=1.248p pd=5.32u as=1.248p ps=5.32u w=4.8u l=0.4u
X31 ob.0 VSS VSS VSS nfet_03v3 ad=1.1752p pd=5.04u as=1.9888p ps=9.92u w=4.52u l=0.5u
X32 tn.0 gp.0 oa.0 VSS nfet_03v3 ad=1.235p pd=5.27u as=1.235p ps=5.27u w=4.75u l=0.5u
X33 d2b.0 d2a.0 VDD VDD pfet_03v3 ad=0.52p pd=2.52u as=0.52p ps=2.52u w=2u l=0.28u
X34 VDD nd.0 i1.0 VDD pfet_03v3 ad=0.962p pd=4.22u as=0.962p ps=4.22u w=3.7u l=0.28u
X35 tp.0 VBP VDD VDD pfet_03v3 ad=1.3p pd=5.52u as=1.3p ps=5.52u w=5u l=1u
X36 VDD rla_m1.0 VSS ppolyf_u_1k r_width=2u r_length=9.11u
X37 fa.0 VBN VSS VSS nfet_03v3 ad=0.65p pd=3.02u as=0.65p ps=3.02u w=2.5u l=1u
X38 fb.0 VBN VSS VSS nfet_03v3 ad=0.65p pd=3.02u as=0.65p ps=3.02u w=2.5u l=1u
X39 tp.0 gp.0 fa.0 tp.0 pfet_03v3 ad=1.248p pd=5.32u as=1.248p ps=5.32u w=4.8u l=0.4u
X40 i2.0 VDD VDD VDD pfet_03v3 ad=0.975p pd=4.27u as=1.65p ps=8.38u w=3.75u l=0.28u
X41 oa.0 VREF tn.0 VSS nfet_03v3 ad=1.235p pd=5.27u as=1.235p ps=5.27u w=4.75u l=0.5u
X42 VSS i2.0 OUT VSS nfet_03v3 ad=1.04p pd=4.52u as=1.04p ps=4.52u w=4u l=0.28u
X43 VDD VDD VDD VDD pfet_03v3 ad=0.962p pd=4.22u as=84.03p ps=0.39294m w=3.7u l=0.28u
X44 VDD d2a.0 d2b.0 VDD pfet_03v3 ad=0.52p pd=2.52u as=0.52p ps=2.52u w=2u l=0.28u
X45 fb.0 VREF tp.0 tp.0 pfet_03v3 ad=1.248p pd=5.32u as=1.248p ps=5.32u w=4.8u l=0.4u
X46 VSS VBN fb.0 VSS nfet_03v3 ad=0.65p pd=3.02u as=0.65p ps=3.02u w=2.5u l=1u
X47 OUT i2.0 VDD VDD pfet_03v3 ad=1.3p pd=5.52u as=1.3p ps=5.52u w=5u l=0.28u
X48 VDD VDD tp.0 VDD pfet_03v3 ad=2.2p pd=10.88u as=1.3p ps=5.52u w=5u l=1u
X49 tp.0 VREF fa.0 tp.0 pfet_03v3 ad=1.248p pd=5.32u as=1.248p ps=5.32u w=4.8u l=0.4u
X50 VSS VSS VSS ppolyf_u_1k r_width=2u r_length=9.11u
X51 tp.0 VREF fa.0 tp.0 pfet_03v3 ad=1.248p pd=5.32u as=1.248p ps=5.32u w=4.8u l=0.4u
X52 tn.0 VREF ob.0 VSS nfet_03v3 ad=1.235p pd=5.27u as=1.235p ps=5.27u w=4.75u l=0.5u
X53 tp.0 VBP VDD VDD pfet_03v3 ad=1.3p pd=5.52u as=1.3p ps=5.52u w=5u l=1u
X54 tp.0 gp.0 fa.0 tp.0 pfet_03v3 ad=1.248p pd=5.32u as=1.248p ps=5.32u w=4.8u l=0.4u
X55 fa.0 VREF tp.0 tp.0 pfet_03v3 ad=1.248p pd=5.32u as=1.248p ps=5.32u w=4.8u l=0.4u
X56 OUT VSS VSS VSS nfet_03v3 ad=1.04p pd=4.52u as=1.76p ps=8.88u w=4u l=0.28u
X57 tn.0 gp.0 oa.0 VSS nfet_03v3 ad=1.235p pd=5.27u as=1.235p ps=5.27u w=4.75u l=0.5u
X58 VSS VSS VSS VSS nfet_03v3 ad=0.78p pd=3.52u as=73.16599p ps=0.35734m w=3u l=0.28u
X59 VDD i2.0 OUT VDD pfet_03v3 ad=1.3p pd=5.52u as=1.3p ps=5.52u w=5u l=0.28u
X60 d2b.0 d2b.0 VDD VDD pfet_03v3 ad=0.52p pd=2.52u as=0.52p ps=2.52u w=2u l=0.28u
X61 VSS VSS fa.0 VSS nfet_03v3 ad=1.1p pd=5.88u as=0.65p ps=3.02u w=2.5u l=1u
X62 VSS VSS fb.0 VSS nfet_03v3 ad=1.9888p pd=9.92u as=1.1752p ps=5.04u w=4.52u l=0.5u
X63 nm.0 d3.0 nd.0 VSS nfet_03v3 ad=0.52p pd=2.52u as=0.52p ps=2.52u w=2u l=0.28u
X64 VDD d2a.0 d2a.0 VDD pfet_03v3 ad=0.52p pd=2.52u as=0.52p ps=2.52u w=2u l=0.28u
X65 d3.0 d2b.0 VDD VDD pfet_03v3 ad=0.52p pd=2.52u as=0.52p ps=2.52u w=2u l=0.28u
X66 VDD VBP tp.0 VDD pfet_03v3 ad=1.3p pd=5.52u as=1.3p ps=5.52u w=5u l=1u
X67 tp.0 gn.0 fb.0 tp.0 pfet_03v3 ad=1.248p pd=5.32u as=1.248p ps=5.32u w=4.8u l=0.4u
X68 fa.0 gp.0 tp.0 tp.0 pfet_03v3 ad=1.248p pd=5.32u as=1.248p ps=5.32u w=4.8u l=0.4u
X69 tp.0 gn.0 fb.0 tp.0 pfet_03v3 ad=1.248p pd=5.32u as=1.248p ps=5.32u w=4.8u l=0.4u
X70 tp.0 VBP VDD VDD pfet_03v3 ad=1.3p pd=5.52u as=1.3p ps=5.52u w=5u l=1u
X71 fb.0 gn.0 tp.0 tp.0 pfet_03v3 ad=1.248p pd=5.32u as=1.248p ps=5.32u w=4.8u l=0.4u
X72 VSS VBN tn.0 VSS nfet_03v3 ad=0.65p pd=3.02u as=0.65p ps=3.02u w=2.5u l=1u
X73 ob.0 VREF tn.0 VSS nfet_03v3 ad=2.09p pd=10.38u as=1.235p ps=5.27u w=4.75u l=0.5u
X74 VDD d2b.0 d3.0 VDD pfet_03v3 ad=0.52p pd=2.52u as=0.52p ps=2.52u w=2u l=0.28u
X75 VSS VBN ts.0 VSS nfet_03v3 ad=0.65p pd=3.02u as=0.65p ps=3.02u w=2.5u l=1u
X76 VDD VDD VDD VDD pfet_03v3 ad=0.52p pd=2.52u as=0 ps=0 w=2u l=0.5u
X77 VDD d2a.0 n3a.0 VDD pfet_03v3 ad=0.52p pd=2.52u as=0.52p ps=2.52u w=2u l=0.28u
X78 d2a.0 VDD VDD VDD pfet_03v3 ad=0.52p pd=2.52u as=0.88p ps=4.88u w=2u l=0.5u
X79 VDD rlb_m1.0 VSS ppolyf_u_1k r_width=2u r_length=9.11u
X80 fa.0 VREF tp.0 tp.0 pfet_03v3 ad=1.248p pd=5.32u as=1.248p ps=5.32u w=4.8u l=0.4u
X81 fa.0 gp.0 tp.0 tp.0 pfet_03v3 ad=1.248p pd=5.32u as=1.248p ps=5.32u w=4.8u l=0.4u
X82 fb.0 VREF tp.0 tp.0 pfet_03v3 ad=2.112p pd=10.48u as=1.248p ps=5.32u w=4.8u l=0.4u
X83 fa.0 VBN VSS VSS nfet_03v3 ad=0.65p pd=3.02u as=0.65p ps=3.02u w=2.5u l=1u
X84 tn.0 gp.0 oa.0 VSS nfet_03v3 ad=1.235p pd=5.27u as=1.235p ps=5.27u w=4.75u l=0.5u
X85 VDD VBP tp.0 VDD pfet_03v3 ad=1.3p pd=5.52u as=1.3p ps=5.52u w=5u l=1u
X86 nd.0 VDD VDD VDD pfet_03v3 ad=0.78p pd=3.52u as=1.32p ps=6.88u w=3u l=0.28u
X87 fa.0 gp.0 tp.0 tp.0 pfet_03v3 ad=1.248p pd=5.32u as=1.248p ps=5.32u w=4.8u l=0.4u
X88 fb.0 gn.0 tp.0 tp.0 pfet_03v3 ad=1.248p pd=5.32u as=1.248p ps=5.32u w=4.8u l=0.4u
X89 tn.0 VSS VSS VSS nfet_03v3 ad=0.65p pd=3.02u as=1.1p ps=5.88u w=2.5u l=1u
X90 d2b.0 ob.0 sb.0 VSS nfet_03v3 ad=1.1362p pd=4.89u as=1.1362p ps=4.89u w=4.37u l=0.5u
X91 tn.0 VREF oa.0 VSS nfet_03v3 ad=1.235p pd=5.27u as=1.235p ps=5.27u w=4.75u l=0.5u
X92 ts.0 VBN VSS VSS nfet_03v3 ad=0.65p pd=3.02u as=0.65p ps=3.02u w=2.5u l=1u
X93 sa.0 oa.0 d2a.0 VSS nfet_03v3 ad=1.1362p pd=4.89u as=1.1362p ps=4.89u w=4.37u l=0.5u
X94 fb.0 VREF tp.0 tp.0 pfet_03v3 ad=1.248p pd=5.32u as=1.248p ps=5.32u w=4.8u l=0.4u
X95 tn.0 gn.0 ob.0 VSS nfet_03v3 ad=1.235p pd=5.27u as=1.235p ps=5.27u w=4.75u l=0.5u
X96 tn.0 gn.0 ob.0 VSS nfet_03v3 ad=1.235p pd=5.27u as=1.235p ps=5.27u w=4.75u l=0.5u
X97 tp.0 VREF fa.0 tp.0 pfet_03v3 ad=1.248p pd=5.32u as=1.248p ps=5.32u w=4.8u l=0.4u
X98 fa.0 VREF tp.0 tp.0 pfet_03v3 ad=1.248p pd=5.32u as=1.248p ps=5.32u w=4.8u l=0.4u
X99 VDD d2b.0 d2b.0 VDD pfet_03v3 ad=0.52p pd=2.52u as=0.52p ps=2.52u w=2u l=0.28u
X100 n3a.0 d2a.0 VDD VDD pfet_03v3 ad=0.52p pd=2.52u as=0.52p ps=2.52u w=2u l=0.28u
D0 gn.0 VDD diode_pd2nw_03v3 pj=26u area=40p
X101 fb.0 gn.0 tp.0 tp.0 pfet_03v3 ad=1.248p pd=5.32u as=1.248p ps=5.32u w=4.8u l=0.4u
X102 tn.0 gp.0 oa.0 VSS nfet_03v3 ad=1.235p pd=5.27u as=1.235p ps=5.27u w=4.75u l=0.5u
X103 fa.0 gp.0 tp.0 tp.0 pfet_03v3 ad=1.248p pd=5.32u as=1.248p ps=5.32u w=4.8u l=0.4u
X104 fb.0 VBN VSS VSS nfet_03v3 ad=0.65p pd=3.02u as=0.65p ps=3.02u w=2.5u l=1u
X105 tn.0 VBN VSS VSS nfet_03v3 ad=0.65p pd=3.02u as=0.65p ps=3.02u w=2.5u l=1u
X106 d3.0 d2b.0 VDD VDD pfet_03v3 ad=0.52p pd=2.52u as=0.52p ps=2.52u w=2u l=0.28u
X107 fb.0 VBN VSS VSS nfet_03v3 ad=0.65p pd=3.02u as=0.65p ps=3.02u w=2.5u l=1u
X108 ts.0 VBN VSS VSS nfet_03v3 ad=0.65p pd=3.02u as=0.65p ps=3.02u w=2.5u l=1u
D1 VSS gn.0 diode_nd2ps_03v3 pj=26u area=40p
X109 tp.0 gn.0 fb.0 tp.0 pfet_03v3 ad=1.248p pd=5.32u as=1.248p ps=5.32u w=4.8u l=0.4u
X110 oa.0 VB2 fa.0 VSS nfet_03v3 ad=1.1752p pd=5.04u as=1.1752p ps=5.04u w=4.52u l=0.5u
X111 VSS VBN fa.0 VSS nfet_03v3 ad=0.65p pd=3.02u as=0.65p ps=3.02u w=2.5u l=1u
X112 VSS VBN fa.0 VSS nfet_03v3 ad=0.65p pd=3.02u as=0.65p ps=3.02u w=2.5u l=1u
X113 tp.0 gp.0 fa.0 tp.0 pfet_03v3 ad=1.248p pd=5.32u as=1.248p ps=5.32u w=4.8u l=0.4u
X114 tp.0 gp.0 fa.0 tp.0 pfet_03v3 ad=1.248p pd=5.32u as=1.248p ps=5.32u w=4.8u l=0.4u
X115 fb.0 gn.0 tp.0 tp.0 pfet_03v3 ad=1.248p pd=5.32u as=1.248p ps=5.32u w=4.8u l=0.4u
X116 VDD d2b.0 d3.0 VDD pfet_03v3 ad=0.52p pd=2.52u as=0.52p ps=2.52u w=2u l=0.28u
X117 oa.0 rla_m1.0 VSS ppolyf_u_1k r_width=2u r_length=9.11u
X118 VSS n3a.0 n3a.0 VSS nfet_03v3 ad=0.6734p pd=3.11u as=0.6734p ps=3.11u w=2.59u l=0.28u
X119 fa.0 VSS VSS VSS nfet_03v3 ad=0.65p pd=3.02u as=1.1p ps=5.88u w=2.5u l=1u
X120 tn.0 VREF ob.0 VSS nfet_03v3 ad=1.235p pd=5.27u as=1.235p ps=5.27u w=4.75u l=0.5u
X121 VSS VSS VSS VSS nfet_03v3 ad=1.1396p pd=6.06u as=0 ps=0 w=2.59u l=0.28u
X122 tp.0 VBP VDD VDD pfet_03v3 ad=1.3p pd=5.52u as=1.3p ps=5.52u w=5u l=1u
X123 VSS VBN fb.0 VSS nfet_03v3 ad=0.65p pd=3.02u as=0.65p ps=3.02u w=2.5u l=1u
X124 VDD VBP tp.0 VDD pfet_03v3 ad=1.3p pd=5.52u as=1.3p ps=5.52u w=5u l=1u
X125 VDD VBP tp.0 VDD pfet_03v3 ad=1.3p pd=5.52u as=1.3p ps=5.52u w=5u l=1u
X126 fa.0 VREF tp.0 tp.0 pfet_03v3 ad=1.248p pd=5.32u as=1.248p ps=5.32u w=4.8u l=0.4u
X127 tp.0 VREF fb.0 tp.0 pfet_03v3 ad=1.248p pd=5.32u as=1.248p ps=5.32u w=4.8u l=0.4u
X128 gn.0 INN VDD ppolyf_u r_width=5u r_length=1.8u
X129 d3.0 d2b.0 VDD VDD pfet_03v3 ad=0.52p pd=2.52u as=0.52p ps=2.52u w=2u l=0.28u
X130 fa.0 VREF tp.0 tp.0 pfet_03v3 ad=1.248p pd=5.32u as=1.248p ps=5.32u w=4.8u l=0.4u
X131 VDD EN d2b.0 VDD pfet_03v3 ad=0.52p pd=2.52u as=0.52p ps=2.52u w=2u l=0.5u
X132 n3a.0 VDD VDD VDD pfet_03v3 ad=0.52p pd=2.52u as=0.88p ps=4.88u w=2u l=0.28u
X133 tp.0 VBP VDD VDD pfet_03v3 ad=1.3p pd=5.52u as=1.3p ps=5.52u w=5u l=1u
X134 tp.0 gp.0 fa.0 tp.0 pfet_03v3 ad=1.248p pd=5.32u as=1.248p ps=5.32u w=4.8u l=0.4u
X135 tp.0 VDD VDD VDD pfet_03v3 ad=1.3p pd=5.52u as=2.2p ps=10.88u w=5u l=1u
X136 fb.0 VREF tp.0 tp.0 pfet_03v3 ad=1.248p pd=5.32u as=1.248p ps=5.32u w=4.8u l=0.4u
X137 fa.0 VREF tp.0 tp.0 pfet_03v3 ad=1.248p pd=5.32u as=1.248p ps=5.32u w=4.8u l=0.4u
X138 oa.0 VB2 fa.0 VSS nfet_03v3 ad=1.1752p pd=5.04u as=1.1752p ps=5.04u w=4.52u l=0.5u
X139 sb.0 ob.0 d2b.0 VSS nfet_03v3 ad=1.1362p pd=4.89u as=1.1362p ps=4.89u w=4.37u l=0.5u
X140 VDD VBP tp.0 VDD pfet_03v3 ad=1.3p pd=5.52u as=1.3p ps=5.52u w=5u l=1u
X141 VSS VSS fa.0 VSS nfet_03v3 ad=1.9888p pd=9.92u as=1.1752p ps=5.04u w=4.52u l=0.5u
X142 tp.0 VREF fb.0 tp.0 pfet_03v3 ad=1.248p pd=5.32u as=1.248p ps=5.32u w=4.8u l=0.4u
X143 fb.0 VB2 ob.0 VSS nfet_03v3 ad=1.1752p pd=5.04u as=1.1752p ps=5.04u w=4.52u l=0.5u
X144 tn.0 VBN VSS VSS nfet_03v3 ad=0.65p pd=3.02u as=0.65p ps=3.02u w=2.5u l=1u
X145 ob.0 gn.0 tn.0 VSS nfet_03v3 ad=1.235p pd=5.27u as=1.235p ps=5.27u w=4.75u l=0.5u
D2 VSS gp.0 diode_nd2ps_03v3 pj=26u area=40p
X146 ts.0 VBN VSS VSS nfet_03v3 ad=0.65p pd=3.02u as=0.65p ps=3.02u w=2.5u l=1u
X147 OUT VDD VDD VDD pfet_03v3 ad=1.3p pd=5.52u as=2.2p ps=10.88u w=5u l=0.28u
X148 VDD d2b.0 d2b.0 VDD pfet_03v3 ad=0.52p pd=2.52u as=0.52p ps=2.52u w=2u l=0.28u
X149 fa.0 gp.0 tp.0 tp.0 pfet_03v3 ad=1.248p pd=5.32u as=1.248p ps=5.32u w=4.8u l=0.4u
X150 tp.0 gp.0 fa.0 tp.0 pfet_03v3 ad=1.248p pd=5.32u as=1.248p ps=5.32u w=4.8u l=0.4u
X151 fb.0 VREF tp.0 tp.0 pfet_03v3 ad=1.248p pd=5.32u as=1.248p ps=5.32u w=4.8u l=0.4u
X152 VSS VBN tn.0 VSS nfet_03v3 ad=0.65p pd=3.02u as=0.65p ps=3.02u w=2.5u l=1u
X153 VSS i1.0 i2.0 VSS nfet_03v3 ad=0.78p pd=3.52u as=0.78p ps=3.52u w=3u l=0.28u
X154 VSS nd.0 i1.0 VSS nfet_03v3 ad=0.39p pd=2.02u as=0.39p ps=2.02u w=1.5u l=0.28u
X155 VSS EN nm.0 VSS nfet_03v3 ad=0.52p pd=2.52u as=0.52p ps=2.52u w=2u l=0.28u
X156 VSS VSS VSS ppolyf_u_1k r_width=2u r_length=3.17u
D3 gp.0 VDD diode_pd2nw_03v3 pj=26u area=40p
X157 fa.0 VBN VSS VSS nfet_03v3 ad=0.65p pd=3.02u as=0.65p ps=3.02u w=2.5u l=1u
X158 tn.0 VREF ob.0 VSS nfet_03v3 ad=1.235p pd=5.27u as=2.09p ps=10.38u w=4.75u l=0.5u
X159 tn.0 VREF oa.0 VSS nfet_03v3 ad=1.235p pd=5.27u as=1.235p ps=5.27u w=4.75u l=0.5u
X160 nd.0 VSS VSS VSS nfet_03v3 ad=0.52p pd=2.52u as=0.88p ps=4.88u w=2u l=0.28u
X161 tn.0 gn.0 ob.0 VSS nfet_03v3 ad=1.235p pd=5.27u as=1.235p ps=5.27u w=4.75u l=0.5u
X162 tn.0 VREF ob.0 VSS nfet_03v3 ad=1.235p pd=5.27u as=1.235p ps=5.27u w=4.75u l=0.5u
X163 tp.0 gp.0 fa.0 tp.0 pfet_03v3 ad=1.248p pd=5.32u as=1.248p ps=5.32u w=4.8u l=0.4u
X164 ts.0 VSS VSS VSS nfet_03v3 ad=0.65p pd=3.02u as=1.1p ps=5.88u w=2.5u l=1u
X165 tp.0 gn.0 fb.0 tp.0 pfet_03v3 ad=1.248p pd=5.32u as=1.248p ps=5.32u w=4.8u l=0.4u
X166 VSS VBN fa.0 VSS nfet_03v3 ad=0.65p pd=3.02u as=0.65p ps=3.02u w=2.5u l=1u
X167 tn.0 VBN VSS VSS nfet_03v3 ad=0.65p pd=3.02u as=0.65p ps=3.02u w=2.5u l=1u
X168 tp.0 VREF fb.0 tp.0 pfet_03v3 ad=1.248p pd=5.32u as=1.248p ps=5.32u w=4.8u l=0.4u
X169 VDD VDD OUT VDD pfet_03v3 ad=2.2p pd=10.88u as=1.3p ps=5.52u w=5u l=0.28u
X170 i2.0 VSS VSS VSS nfet_03v3 ad=0.78p pd=3.52u as=1.32p ps=6.88u w=3u l=0.28u
X171 VSS VSS VSS VSS nfet_03v3 ad=0.52p pd=2.52u as=0 ps=0 w=2u l=0.28u
X172 n3a.0 d2a.0 VDD VDD pfet_03v3 ad=0.52p pd=2.52u as=0.52p ps=2.52u w=2u l=0.28u
X173 tp.0 VREF fb.0 tp.0 pfet_03v3 ad=1.248p pd=5.32u as=1.248p ps=5.32u w=4.8u l=0.4u
X174 i1.0 VSS VSS VSS nfet_03v3 ad=0.39p pd=2.02u as=0.66p ps=3.88u w=1.5u l=0.28u
X175 VSS VBN tn.0 VSS nfet_03v3 ad=0.65p pd=3.02u as=0.65p ps=3.02u w=2.5u l=1u
X176 oa.0 VREF tn.0 VSS nfet_03v3 ad=1.235p pd=5.27u as=1.235p ps=5.27u w=4.75u l=0.5u
X177 tp.0 VBP VDD VDD pfet_03v3 ad=1.3p pd=5.52u as=1.3p ps=5.52u w=5u l=1u
X178 tp.0 VREF fa.0 tp.0 pfet_03v3 ad=1.248p pd=5.32u as=1.248p ps=5.32u w=4.8u l=0.4u
X179 VSS VBN ts.0 VSS nfet_03v3 ad=0.65p pd=3.02u as=0.65p ps=3.02u w=2.5u l=1u
X180 oa.0 VSS VSS VSS nfet_03v3 ad=1.1752p pd=5.04u as=1.9888p ps=9.92u w=4.52u l=0.5u
X181 VDD d3.0 nd.0 VDD pfet_03v3 ad=0.78p pd=3.52u as=0.78p ps=3.52u w=3u l=0.28u
X182 fb.0 VREF tp.0 tp.0 pfet_03v3 ad=1.248p pd=5.32u as=1.248p ps=5.32u w=4.8u l=0.4u
X183 tp.0 VREF fa.0 tp.0 pfet_03v3 ad=1.248p pd=5.32u as=1.248p ps=5.32u w=4.8u l=0.4u
X184 fa.0 VBN VSS VSS nfet_03v3 ad=0.65p pd=3.02u as=0.65p ps=3.02u w=2.5u l=1u
X185 OUT i2.0 VDD VDD pfet_03v3 ad=1.3p pd=5.52u as=1.3p ps=5.52u w=5u l=0.28u
X186 VDD VDD n3a.0 VDD pfet_03v3 ad=0.88p pd=4.88u as=0.52p ps=2.52u w=2u l=0.28u
X187 tp.0 gn.0 fb.0 tp.0 pfet_03v3 ad=1.248p pd=5.32u as=1.248p ps=5.32u w=4.8u l=0.4u
X188 fa.0 VREF tp.0 tp.0 pfet_03v3 ad=1.248p pd=5.32u as=1.248p ps=5.32u w=4.8u l=0.4u
X189 oa.0 VB2 fa.0 VSS nfet_03v3 ad=1.1752p pd=5.04u as=1.1752p ps=5.04u w=4.52u l=0.5u
X190 fb.0 VB2 ob.0 VSS nfet_03v3 ad=1.1752p pd=5.04u as=1.1752p ps=5.04u w=4.52u l=0.5u
X191 fb.0 gn.0 tp.0 tp.0 pfet_03v3 ad=1.248p pd=5.32u as=1.248p ps=5.32u w=4.8u l=0.4u
X192 VSS VBN fa.0 VSS nfet_03v3 ad=0.65p pd=3.02u as=0.65p ps=3.02u w=2.5u l=1u
X193 fb.0 VB2 ob.0 VSS nfet_03v3 ad=1.1752p pd=5.04u as=1.1752p ps=5.04u w=4.52u l=0.5u
X194 d2a.0 VDD VDD VDD pfet_03v3 ad=0.52p pd=2.52u as=0.88p ps=4.88u w=2u l=0.28u
X195 tp.0 VREF fb.0 tp.0 pfet_03v3 ad=1.248p pd=5.32u as=1.248p ps=5.32u w=4.8u l=0.4u
X196 d2b.0 d2b.0 VDD VDD pfet_03v3 ad=0.52p pd=2.52u as=0.52p ps=2.52u w=2u l=0.28u
X197 VDD d2a.0 n3a.0 VDD pfet_03v3 ad=0.52p pd=2.52u as=0.52p ps=2.52u w=2u l=0.28u
X198 nd.0 EN VDD VDD pfet_03v3 ad=0.78p pd=3.52u as=0.78p ps=3.52u w=3u l=0.28u
X199 fa.0 VREF tp.0 tp.0 pfet_03v3 ad=1.248p pd=5.32u as=1.248p ps=5.32u w=4.8u l=0.4u
X200 fb.0 VREF tp.0 tp.0 pfet_03v3 ad=1.248p pd=5.32u as=1.248p ps=5.32u w=4.8u l=0.4u
X201 tn.0 VREF oa.0 VSS nfet_03v3 ad=1.235p pd=5.27u as=1.235p ps=5.27u w=4.75u l=0.5u
X202 fa.0 gp.0 tp.0 tp.0 pfet_03v3 ad=1.248p pd=5.32u as=1.248p ps=5.32u w=4.8u l=0.4u
X203 fa.0 VBN VSS VSS nfet_03v3 ad=0.65p pd=3.02u as=0.65p ps=3.02u w=2.5u l=1u
X204 tn.0 VREF oa.0 VSS nfet_03v3 ad=1.235p pd=5.27u as=1.235p ps=5.27u w=4.75u l=0.5u
X205 VDD VDD d2b.0 VDD pfet_03v3 ad=0.88p pd=4.88u as=0.52p ps=2.52u w=2u l=0.28u
X206 ts.0 sa.0 VSS ppolyf_u_1k r_width=2u r_length=3.17u
X207 tp.0 VBP VDD VDD pfet_03v3 ad=1.3p pd=5.52u as=1.3p ps=5.52u w=5u l=1u
X208 fb.0 gn.0 tp.0 tp.0 pfet_03v3 ad=1.248p pd=5.32u as=1.248p ps=5.32u w=4.8u l=0.4u
X209 tn.0 VREF ob.0 VSS nfet_03v3 ad=1.235p pd=5.27u as=1.235p ps=5.27u w=4.75u l=0.5u
X210 VDD d2b.0 d2a.0 VDD pfet_03v3 ad=0.52p pd=2.52u as=0.52p ps=2.52u w=2u l=0.28u
X211 d3.0 d2b.0 VDD VDD pfet_03v3 ad=0.52p pd=2.52u as=0.52p ps=2.52u w=2u l=0.28u
X212 tn.0 gn.0 ob.0 VSS nfet_03v3 ad=1.235p pd=5.27u as=1.235p ps=5.27u w=4.75u l=0.5u
X213 VSS VBN fb.0 VSS nfet_03v3 ad=0.65p pd=3.02u as=0.65p ps=3.02u w=2.5u l=1u
X214 d3.0 n3a.0 VSS VSS nfet_03v3 ad=0.6734p pd=3.11u as=0.6734p ps=3.11u w=2.59u l=0.28u
X215 ob.0 VREF tn.0 VSS nfet_03v3 ad=1.235p pd=5.27u as=1.235p ps=5.27u w=4.75u l=0.5u
X216 d2b.0 d2a.0 VDD VDD pfet_03v3 ad=0.52p pd=2.52u as=0.52p ps=2.52u w=2u l=0.28u
X217 n3a.0 n3a.0 VSS VSS nfet_03v3 ad=0.6734p pd=3.11u as=0.6734p ps=3.11u w=2.59u l=0.28u
X218 oa.0 gp.0 tn.0 VSS nfet_03v3 ad=1.235p pd=5.27u as=1.235p ps=5.27u w=4.75u l=0.5u
X219 d2b.0 VDD VDD VDD pfet_03v3 ad=0.52p pd=2.52u as=0.88p ps=4.88u w=2u l=0.5u
X220 ts.0 sb.0 VSS ppolyf_u_1k r_width=2u r_length=3.17u
X221 tp.0 VREF fa.0 tp.0 pfet_03v3 ad=1.248p pd=5.32u as=1.248p ps=5.32u w=4.8u l=0.4u
X222 fb.0 VREF tp.0 tp.0 pfet_03v3 ad=1.248p pd=5.32u as=1.248p ps=5.32u w=4.8u l=0.4u
X223 ob.0 gn.0 tn.0 VSS nfet_03v3 ad=1.235p pd=5.27u as=1.235p ps=5.27u w=4.75u l=0.5u
X224 VDD VDD VDD VDD pfet_03v3 ad=0.52p pd=2.52u as=0 ps=0 w=2u l=0.5u
X225 fb.0 gn.0 tp.0 tp.0 pfet_03v3 ad=1.248p pd=5.32u as=1.248p ps=5.32u w=4.8u l=0.4u
X226 fb.0 VBN VSS VSS nfet_03v3 ad=0.65p pd=3.02u as=0.65p ps=3.02u w=2.5u l=1u
X227 oa.0 gp.0 tn.0 VSS nfet_03v3 ad=1.235p pd=5.27u as=1.235p ps=5.27u w=4.75u l=0.5u
X228 VDD VBP tp.0 VDD pfet_03v3 ad=1.3p pd=5.52u as=1.3p ps=5.52u w=5u l=1u
X229 VDD VBP tp.0 VDD pfet_03v3 ad=1.3p pd=5.52u as=1.3p ps=5.52u w=5u l=1u
X230 ob.0 gn.0 tn.0 VSS nfet_03v3 ad=1.235p pd=5.27u as=1.235p ps=5.27u w=4.75u l=0.5u
X231 VDD d2b.0 d3.0 VDD pfet_03v3 ad=0.52p pd=2.52u as=0.52p ps=2.52u w=2u l=0.28u
X232 d2b.0 VSS VSS VSS nfet_03v3 ad=1.1362p pd=4.89u as=1.9228p ps=9.62u w=4.37u l=0.5u
X233 fb.0 VB2 ob.0 VSS nfet_03v3 ad=1.1752p pd=5.04u as=1.1752p ps=5.04u w=4.52u l=0.5u
X234 oa.0 gp.0 tn.0 VSS nfet_03v3 ad=1.235p pd=5.27u as=1.235p ps=5.27u w=4.75u l=0.5u
X235 VDD d2a.0 n3a.0 VDD pfet_03v3 ad=0.52p pd=2.52u as=0.52p ps=2.52u w=2u l=0.28u
X236 VSS VSS d2a.0 VSS nfet_03v3 ad=1.9228p pd=9.62u as=1.1362p ps=4.89u w=4.37u l=0.5u
X237 fb.0 gn.0 tp.0 tp.0 pfet_03v3 ad=1.248p pd=5.32u as=1.248p ps=5.32u w=4.8u l=0.4u
X238 fa.0 gp.0 tp.0 tp.0 pfet_03v3 ad=1.248p pd=5.32u as=1.248p ps=5.32u w=4.8u l=0.4u
X239 tp.0 VREF fa.0 tp.0 pfet_03v3 ad=1.248p pd=5.32u as=1.248p ps=5.32u w=4.8u l=0.4u
X240 tp.0 VREF fb.0 tp.0 pfet_03v3 ad=1.248p pd=5.32u as=1.248p ps=5.32u w=4.8u l=0.4u
X241 tp.0 VBP VDD VDD pfet_03v3 ad=1.3p pd=5.52u as=1.3p ps=5.52u w=5u l=1u
X242 tp.0 gn.0 fb.0 tp.0 pfet_03v3 ad=1.248p pd=5.32u as=1.248p ps=5.32u w=4.8u l=0.4u
X243 tp.0 gn.0 fb.0 tp.0 pfet_03v3 ad=1.248p pd=5.32u as=1.248p ps=5.32u w=4.8u l=0.4u
X244 VSS VBN ts.0 VSS nfet_03v3 ad=0.65p pd=3.02u as=0.65p ps=3.02u w=2.5u l=1u
X245 VSS VBN tn.0 VSS nfet_03v3 ad=0.65p pd=3.02u as=0.65p ps=3.02u w=2.5u l=1u
X246 tn.0 VREF oa.0 VSS nfet_03v3 ad=1.235p pd=5.27u as=1.235p ps=5.27u w=4.75u l=0.5u
X247 fa.0 gp.0 tp.0 tp.0 pfet_03v3 ad=1.248p pd=5.32u as=1.248p ps=5.32u w=4.8u l=0.4u
X248 VDD VDD i2.0 VDD pfet_03v3 ad=1.65p pd=8.38u as=0.975p ps=4.27u w=3.75u l=0.28u
X249 d2a.0 d2b.0 VDD VDD pfet_03v3 ad=0.52p pd=2.52u as=0.52p ps=2.52u w=2u l=0.28u
X250 VDD EN d2a.0 VDD pfet_03v3 ad=0.52p pd=2.52u as=0.52p ps=2.52u w=2u l=0.5u
X251 tp.0 gp.0 fa.0 tp.0 pfet_03v3 ad=1.248p pd=5.32u as=1.248p ps=5.32u w=4.8u l=0.4u
X252 ts.0 VBN VSS VSS nfet_03v3 ad=0.65p pd=3.02u as=0.65p ps=3.02u w=2.5u l=1u
X253 VSS VSS VSS VSS nfet_03v3 ad=0.39p pd=2.02u as=0 ps=0 w=1.5u l=0.28u
X254 VSS VSS d2b.0 VSS nfet_03v3 ad=1.9228p pd=9.62u as=1.1362p ps=4.89u w=4.37u l=0.5u
X255 fb.0 gn.0 tp.0 tp.0 pfet_03v3 ad=1.248p pd=5.32u as=1.248p ps=5.32u w=4.8u l=0.4u
X256 VSS VSS tn.0 VSS nfet_03v3 ad=1.1p pd=5.88u as=0.65p ps=3.02u w=2.5u l=1u
X257 ob.0 VREF tn.0 VSS nfet_03v3 ad=1.235p pd=5.27u as=1.235p ps=5.27u w=4.75u l=0.5u
X258 d2a.0 VSS VSS VSS nfet_03v3 ad=1.1362p pd=4.89u as=1.9228p ps=9.62u w=4.37u l=0.5u
X259 tp.0 gn.0 fb.0 tp.0 pfet_03v3 ad=1.248p pd=5.32u as=1.248p ps=5.32u w=4.8u l=0.4u
X260 fa.0 gp.0 tp.0 tp.0 pfet_03v3 ad=1.248p pd=5.32u as=1.248p ps=5.32u w=4.8u l=0.4u
X261 VSS VBN fb.0 VSS nfet_03v3 ad=0.65p pd=3.02u as=0.65p ps=3.02u w=2.5u l=1u
X262 ob.0 gn.0 tn.0 VSS nfet_03v3 ad=1.235p pd=5.27u as=1.235p ps=5.27u w=4.75u l=0.5u
X263 d2a.0 oa.0 sa.0 VSS nfet_03v3 ad=1.1362p pd=4.89u as=1.1362p ps=4.89u w=4.37u l=0.5u
X264 i2.0 i1.0 VDD VDD pfet_03v3 ad=0.975p pd=4.27u as=0.975p ps=4.27u w=3.75u l=0.28u
X265 VDD d2b.0 d2a.0 VDD pfet_03v3 ad=0.52p pd=2.52u as=0.52p ps=2.52u w=2u l=0.28u
X266 VSS VSS VSS ppolyf_u_1k r_width=2u r_length=3.17u
X267 fb.0 VBN VSS VSS nfet_03v3 ad=0.65p pd=3.02u as=0.65p ps=3.02u w=2.5u l=1u
X268 fa.0 VBN VSS VSS nfet_03v3 ad=0.65p pd=3.02u as=0.65p ps=3.02u w=2.5u l=1u
X269 i1.0 VDD VDD VDD pfet_03v3 ad=0.962p pd=4.22u as=1.628p ps=8.28u w=3.7u l=0.28u
X270 tn.0 VBN VSS VSS nfet_03v3 ad=0.65p pd=3.02u as=0.65p ps=3.02u w=2.5u l=1u
X271 VSS VBN fa.0 VSS nfet_03v3 ad=0.65p pd=3.02u as=0.65p ps=3.02u w=2.5u l=1u
X272 tp.0 VREF fa.0 tp.0 pfet_03v3 ad=1.248p pd=5.32u as=1.248p ps=5.32u w=4.8u l=0.4u
X273 fb.0 gn.0 tp.0 tp.0 pfet_03v3 ad=1.248p pd=5.32u as=1.248p ps=5.32u w=4.8u l=0.4u
X274 fa.0 gp.0 tp.0 tp.0 pfet_03v3 ad=1.248p pd=5.32u as=1.248p ps=5.32u w=4.8u l=0.4u
X275 OUT i2.0 VSS VSS nfet_03v3 ad=1.04p pd=4.52u as=1.04p ps=4.52u w=4u l=0.28u
X276 VDD VBP tp.0 VDD pfet_03v3 ad=1.3p pd=5.52u as=1.3p ps=5.52u w=5u l=1u
X277 VSS VBN fa.0 VSS nfet_03v3 ad=0.65p pd=3.02u as=0.65p ps=3.02u w=2.5u l=1u
X278 tp.0 gn.0 fb.0 tp.0 pfet_03v3 ad=1.248p pd=5.32u as=1.248p ps=5.32u w=4.8u l=0.4u
X279 fa.0 gp.0 tp.0 tp.0 pfet_03v3 ad=1.248p pd=5.32u as=1.248p ps=5.32u w=4.8u l=0.4u
X280 VDD i2.0 OUT VDD pfet_03v3 ad=1.3p pd=5.52u as=1.3p ps=5.52u w=5u l=0.28u
X281 tp.0 VREF fb.0 tp.0 pfet_03v3 ad=1.248p pd=5.32u as=1.248p ps=5.32u w=4.8u l=0.4u
X282 fb.0 VBN VSS VSS nfet_03v3 ad=0.65p pd=3.02u as=0.65p ps=3.02u w=2.5u l=1u
X283 VDD d2b.0 d2a.0 VDD pfet_03v3 ad=0.52p pd=2.52u as=0.52p ps=2.52u w=2u l=0.28u
X284 VSS VSS VSS ppolyf_u_1k r_width=2u r_length=9.11u
X285 fa.0 VREF tp.0 tp.0 pfet_03v3 ad=1.248p pd=5.32u as=1.248p ps=5.32u w=4.8u l=0.4u
X286 ob.0 gn.0 tn.0 VSS nfet_03v3 ad=1.235p pd=5.27u as=1.235p ps=5.27u w=4.75u l=0.5u
X287 oa.0 gp.0 tn.0 VSS nfet_03v3 ad=1.235p pd=5.27u as=1.235p ps=5.27u w=4.75u l=0.5u
X288 VSS VSS OUT VSS nfet_03v3 ad=1.76p pd=8.88u as=1.04p ps=4.52u w=4u l=0.28u
X289 VDD VDD nd.0 VDD pfet_03v3 ad=1.32p pd=6.88u as=0.78p ps=3.52u w=3u l=0.28u
X290 tp.0 gp.0 fa.0 tp.0 pfet_03v3 ad=1.248p pd=5.32u as=1.248p ps=5.32u w=4.8u l=0.4u
X291 VSS VSS ts.0 VSS nfet_03v3 ad=1.1p pd=5.88u as=0.65p ps=3.02u w=2.5u l=1u
X292 VDD VBP tp.0 VDD pfet_03v3 ad=1.3p pd=5.52u as=1.3p ps=5.52u w=5u l=1u
X293 tp.0 gp.0 fa.0 tp.0 pfet_03v3 ad=1.248p pd=5.32u as=1.248p ps=5.32u w=4.8u l=0.4u
X294 VDD VBP tp.0 VDD pfet_03v3 ad=1.3p pd=5.52u as=1.3p ps=5.52u w=5u l=1u
X295 d2b.0 d2a.0 VDD VDD pfet_03v3 ad=0.52p pd=2.52u as=0.52p ps=2.52u w=2u l=0.28u
X296 d2a.0 d2a.0 VDD VDD pfet_03v3 ad=0.52p pd=2.52u as=0.52p ps=2.52u w=2u l=0.28u
X297 fb.0 VREF tp.0 tp.0 pfet_03v3 ad=1.248p pd=5.32u as=1.248p ps=5.32u w=4.8u l=0.4u
X298 oa.0 gp.0 tn.0 VSS nfet_03v3 ad=1.235p pd=5.27u as=1.235p ps=5.27u w=4.75u l=0.5u
X299 d2a.0 d2b.0 VDD VDD pfet_03v3 ad=0.52p pd=2.52u as=0.52p ps=2.52u w=2u l=0.28u
X300 VDD d2b.0 d3.0 VDD pfet_03v3 ad=0.52p pd=2.52u as=0.52p ps=2.52u w=2u l=0.28u
X301 tp.0 VBP VDD VDD pfet_03v3 ad=1.3p pd=5.52u as=1.3p ps=5.52u w=5u l=1u
X302 tp.0 VBP VDD VDD pfet_03v3 ad=1.3p pd=5.52u as=1.3p ps=5.52u w=5u l=1u
X303 fa.0 VB2 oa.0 VSS nfet_03v3 ad=1.1752p pd=5.04u as=1.1752p ps=5.04u w=4.52u l=0.5u
X304 VSS n3a.0 d3.0 VSS nfet_03v3 ad=0.6734p pd=3.11u as=0.6734p ps=3.11u w=2.59u l=0.28u
X305 tp.0 gp.0 fa.0 tp.0 pfet_03v3 ad=1.248p pd=5.32u as=1.248p ps=5.32u w=4.8u l=0.4u
X306 fa.0 VB2 oa.0 VSS nfet_03v3 ad=1.1752p pd=5.04u as=1.1752p ps=5.04u w=4.52u l=0.5u
X307 VDD d2a.0 d2a.0 VDD pfet_03v3 ad=0.52p pd=2.52u as=0.52p ps=2.52u w=2u l=0.28u
X308 ob.0 VB2 fb.0 VSS nfet_03v3 ad=1.1752p pd=5.04u as=1.1752p ps=5.04u w=4.52u l=0.5u
X309 VDD d2a.0 d2b.0 VDD pfet_03v3 ad=0.52p pd=2.52u as=0.52p ps=2.52u w=2u l=0.28u
X310 n3a.0 d2a.0 VDD VDD pfet_03v3 ad=0.52p pd=2.52u as=0.52p ps=2.52u w=2u l=0.28u
X311 VSS VBN fb.0 VSS nfet_03v3 ad=0.65p pd=3.02u as=0.65p ps=3.02u w=2.5u l=1u
X312 ts.0 VBN VSS VSS nfet_03v3 ad=0.65p pd=3.02u as=0.65p ps=3.02u w=2.5u l=1u
X313 tp.0 VBP VDD VDD pfet_03v3 ad=1.3p pd=5.52u as=1.3p ps=5.52u w=5u l=1u
X314 fa.0 VREF tp.0 tp.0 pfet_03v3 ad=1.248p pd=5.32u as=1.248p ps=5.32u w=4.8u l=0.4u
X315 fb.0 VREF tp.0 tp.0 pfet_03v3 ad=1.248p pd=5.32u as=1.248p ps=5.32u w=4.8u l=0.4u
X316 VSS VSS VSS VSS nfet_03v3 ad=0.6734p pd=3.11u as=0 ps=0 w=2.59u l=0.28u
X317 tp.0 VREF fb.0 tp.0 pfet_03v3 ad=1.248p pd=5.32u as=1.248p ps=5.32u w=4.8u l=0.4u
X318 tp.0 VREF fb.0 tp.0 pfet_03v3 ad=1.248p pd=5.32u as=1.248p ps=5.32u w=4.8u l=0.4u
X319 fa.0 VREF tp.0 tp.0 pfet_03v3 ad=1.248p pd=5.32u as=1.248p ps=5.32u w=4.8u l=0.4u
X320 oa.0 VREF tn.0 VSS nfet_03v3 ad=1.235p pd=5.27u as=1.235p ps=5.27u w=4.75u l=0.5u
X321 d2a.0 d2a.0 VDD VDD pfet_03v3 ad=0.52p pd=2.52u as=0.52p ps=2.52u w=2u l=0.28u
X322 n3a.0 d2a.0 VDD VDD pfet_03v3 ad=0.52p pd=2.52u as=0.52p ps=2.52u w=2u l=0.28u
C0 d2b.0 sa.0 0.20995f
C1 ob.0 oa.0 0.59251f
C2 d3.0 d2a.0 2.37176f
C3 gn.0 VDD 4.52025f
C4 rlb_m1.0 sa.0 0
C5 VBN fa.0 2.39287f
C6 INP VBP 0.03875f
C7 VREF fb.0 2.88984f
C8 VREF tn.0 1.62411f
C9 d2b.0 VDD 11.7806f
C10 tp.0 fb.0 25.7437f
C11 ob.0 gp.0 0.3633f
C12 VREF tp.0 14.925f
C13 d2a.0 sa.0 1.67001f
C14 EN VDD 16.8221f
C15 VBN VDD 0.15007f
C16 VB2 fb.0 2.14447f
C17 VBN gn.0 0.11482f
C18 VB2 VREF 6.32706f
C19 sa.0 ts.0 0.03853f
C20 INP gp.0 0.14621f
C21 VB2 tp.0 0.05309f
C22 i1.0 nd.0 0.21598f
C23 d2b.0 EN 0.44208f
C24 d2a.0 VDD 12.6668f
C25 oa.0 tn.0 9.87797f
C26 VBP tp.0 3.37779f
C27 VREF oa.0 2.14744f
C28 VDD ts.0 0.93712f
C29 d2b.0 d2a.0 2.76659f
C30 gn.0 ts.0 0.01921f
C31 ob.0 fa.0 0
C32 ob.0 sa.0 0.00738f
C33 VB2 oa.0 0.57905f
C34 fb.0 gp.0 0.86843f
C35 tn.0 gp.0 1.20627f
C36 d2a.0 EN 0.17357f
C37 VREF gp.0 1.91483f
C38 tp.0 gp.0 12.8757f
C39 ob.0 VDD 1.92789f
C40 VBN ts.0 0.99312f
C41 d3.0 nd.0 0.22426f
C42 ob.0 gn.0 1.03804f
C43 nd.0 nm.0 0.2193f
C44 VB2 gp.0 0.05601f
C45 INN VBP 0.03712f
C46 INP VDD 2.26778f
C47 ob.0 d2b.0 0.16374f
C48 VBP gp.0 0.26446f
C49 oa.0 gp.0 1.23135f
C50 fb.0 fa.0 0.80129f
C51 VBN ob.0 0.19136f
C52 VREF fa.0 2.64932f
C53 i1.0 i2.0 0.28557f
C54 tp.0 fa.0 25.3704f
C55 nd.0 VDD 2.72485f
C56 tn.0 VDD 0.19528f
C57 VB2 fa.0 1.75715f
C58 OUT i1.0 0
C59 fb.0 gn.0 2.59553f
C60 VREF VDD 0.13393f
C61 tn.0 gn.0 0.99696f
C62 tp.0 VDD 11.3411f
C63 ob.0 ts.0 0.21086f
C64 VREF gn.0 2.33633f
C65 sb.0 sa.0 0.7765f
C66 tp.0 gn.0 13.4594f
C67 fa.0 oa.0 2.90441f
C68 sa.0 oa.0 0.14911f
C69 VB2 VDD 0.12285f
C70 nd.0 EN 0.90578f
C71 d3.0 n3a.0 0.80741f
C72 VB2 gn.0 0.05558f
C73 VBN fb.0 1.48704f
C74 VBN tn.0 0.82513f
C75 VBP VDD 28.4203f
C76 VREF VBN 0.90664f
C77 i1.0 VDD 2.62232f
C78 oa.0 VDD 1.56447f
C79 VBP gn.0 0.26446f
C80 OUT i2.0 0.50501f
C81 fa.0 gp.0 2.44274f
C82 oa.0 gn.0 0.30476f
C83 d3.0 nm.0 0.01765f
C84 rla_m1.0 sa.0 0.30587f
C85 d2b.0 sb.0 0.68313f
C86 VB2 VBN 0.12676f
C87 INN VDD 2.56298f
C88 tn.0 ts.0 0
C89 gp.0 VDD 4.5498f
C90 i1.0 EN 0.26447f
C91 VREF ts.0 0.07669f
C92 INN gn.0 0.14621f
C93 VDD n3a.0 4.08941f
C94 VBN oa.0 0.33374f
C95 gn.0 gp.0 2.07546f
C96 i2.0 VDD 4.2831f
C97 d2b.0 n3a.0 0.16863f
C98 d2a.0 oa.0 0.16422f
C99 d3.0 VDD 4.47773f
C100 ob.0 fb.0 2.81909f
C101 d2b.0 rla_m1.0 0.00423f
C102 ob.0 tn.0 9.55392f
C103 sb.0 ts.0 0.06367f
C104 OUT VDD 3.99882f
C105 VREF ob.0 2.70252f
C106 EN n3a.0 0.00585f
C107 VBN gp.0 0.14191f
C108 rlb_m1.0 rla_m1.0 0.39394f
C109 d3.0 d2b.0 0.34009f
C110 EN i2.0 0.31277f
C111 sa.0 VDD 0.00366f
C112 VB2 ob.0 0.57476f
C113 fa.0 gn.0 0.67123f
C114 d2a.0 n3a.0 0.24692f
C115 d3.0 EN 0.46698f
C116 rla_m1.0 d2a.0 0
C117 EN nm.0 0.02238f
C118 ob.0 sb.0 0.20964f
C119 OUT EN 0.00492f
C120 OUT VSS 5.22859f
C121 EN VSS 6.31796f
C122 VBN VSS 49.0137f
C123 VB2 VSS 9.2495f
C124 VREF VSS 12.2401f
C125 INN VSS 1.65907f
C126 VBP VSS 2.82194f
C127 INP VSS 1.94577f
C128 VDD VSS 0.21041p
C129 i2.0 VSS 4.2469f
C130 i1.0 VSS 3.72118f
C131 nm.0 VSS 0.31567f
C132 nd.0 VSS 3.35161f
C133 d3.0 VSS 4.9259f
C134 n3a.0 VSS 3.56595f
C135 sb.0 VSS 2.33901f
C136 d2b.0 VSS 5.02018f
C137 rlb_m1.0 VSS 1.11225f
C138 rla_m1.0 VSS 1.48222f
C139 sa.0 VSS 4.30772f
C140 d2a.0 VSS 3.35523f
C141 ts.0 VSS 7.37304f
C142 tn.0 VSS 4.38031f
C143 ob.0 VSS 6.80006f
C144 oa.0 VSS 7.22376f
C145 fa.0 VSS 9.0556f
C146 fb.0 VSS 7.93573f
C147 gn.0 VSS 13.8994f
C148 gp.0 VSS 14.1023f
C149 tp.0 VSS 0.1029p
.ends lvds_lane
