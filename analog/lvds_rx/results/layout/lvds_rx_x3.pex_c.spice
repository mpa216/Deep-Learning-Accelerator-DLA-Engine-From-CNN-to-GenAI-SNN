* lvds_rx_x3: parasitic C on all nets (coupling and to substrate, cthresh 0) (flat copy of the hierarchy)
* GENERATED by layout/macro/run_macro.py (T10) from a GDS with sha256 892add3ba9d5678886b7c95fd525a1ce2fd3bd1663b6679324fd69c7b6b96f89 -- do not edit by hand.
* Ports in the order of subckt lvds_rx_x3 of netlist/lvds_rx_lvs_ref.spice (Magic's own order was: RX0_O RX1_O RX2_O EN RX0_P RX0_N RX1_P RX1_N RX2_P RX2_N VDD VSS).
* NGSPICE file created from lvds_rx_x3_flat.ext - technology: gf180mcuD

.subckt lvds_rx_x3 VDD VSS RX0_P RX0_N RX1_P RX1_N RX2_P RX2_N EN RX0_O RX1_O RX2_O
X0 lvds_lane_1.tp.0 lvds_lane_1.gp.0 lvds_lane_1.fa.0 lvds_lane_1.tp.0 pfet_03v3 ad=1.248p pd=5.32u as=1.248p ps=5.32u w=4.8u l=0.4u
X1 VSS VSS lvds_lane_2.d2b.0 VSS nfet_03v3 ad=1.9228p pd=9.62u as=1.1362p ps=4.89u w=4.37u l=0.5u
X2 VSS VSS RX1_O VSS nfet_03v3 ad=1.76p pd=8.88u as=1.04p ps=4.52u w=4u l=0.28u
X3 lvds_lane_2.fb.0 lvds_lane_2.gn.0 lvds_lane_2.tp.0 lvds_lane_2.tp.0 pfet_03v3 ad=1.248p pd=5.32u as=1.248p ps=5.32u w=4.8u l=0.4u
X4 VSS lvds_lane_0.VBN.0 lvds_lane_1.fb.0 VSS nfet_03v3 ad=0.65p pd=3.02u as=0.65p ps=3.02u w=2.5u l=1u
X5 lvds_lane_1.ob.0 lvds_lane_0.VB2.0 lvds_lane_1.fb.0 VSS nfet_03v3 ad=1.1752p pd=5.04u as=1.1752p ps=5.04u w=4.52u l=0.5u
X6 lvds_lane_0.tn.0 lvds_lane_0.VBN.0 VSS VSS nfet_03v3 ad=0.65p pd=3.02u as=0.65p ps=3.02u w=2.5u l=1u
X7 lvds_bias_0.rb_m3.0 lvds_lane_0.VBN.0 VSS ppolyf_u_1k r_width=2u r_length=22.27u
X8 VSS lvds_lane_0.VBN.0 lvds_lane_2.ts.0 VSS nfet_03v3 ad=0.65p pd=3.02u as=0.65p ps=3.02u w=2.5u l=1u
X9 lvds_lane_0.tp.0 lvds_lane_0.gp.0 lvds_lane_0.fa.0 lvds_lane_0.tp.0 pfet_03v3 ad=1.248p pd=5.32u as=1.248p ps=5.32u w=4.8u l=0.4u
X10 lvds_lane_0.d2a.0 lvds_lane_0.d2a.0 VDD VDD pfet_03v3 ad=0.481p pd=2.37u as=0.481p ps=2.37u w=1.85u l=0.28u
X11 lvds_lane_0.tn.0 lvds_lane_0.gn.0 lvds_lane_0.ob.0 VSS nfet_03v3 ad=1.235p pd=5.27u as=1.235p ps=5.27u w=4.75u l=0.5u
X12 lvds_lane_0.fa.0 lvds_lane_0.gp.0 lvds_lane_0.tp.0 lvds_lane_0.tp.0 pfet_03v3 ad=1.248p pd=5.32u as=1.248p ps=5.32u w=4.8u l=0.4u
X13 lvds_lane_1.fa.0 lvds_lane_0.VREF.0 lvds_lane_1.tp.0 lvds_lane_1.tp.0 pfet_03v3 ad=1.248p pd=5.32u as=1.248p ps=5.32u w=4.8u l=0.4u
X14 lvds_bias_0.rdt_m2.0 lvds_bias_0.rdt_m3.0 VSS ppolyf_u_1k r_width=2u r_length=21.01u
X15 lvds_lane_0.tn.0 lvds_lane_0.VREF.0 lvds_lane_0.oa.0 VSS nfet_03v3 ad=1.235p pd=5.27u as=1.235p ps=5.27u w=4.75u l=0.5u
X16 VDD lvds_lane_0.d2a.0 lvds_lane_0.n3a.0 VDD pfet_03v3 ad=0.481p pd=2.37u as=0.481p ps=2.37u w=1.85u l=0.28u
X17 VSS VSS VSS ppolyf_u_1k r_width=2u r_length=9.11u
X18 VSS lvds_lane_0.VBN.0 lvds_lane_2.ts.0 VSS nfet_03v3 ad=0.65p pd=3.02u as=0.65p ps=3.02u w=2.5u l=1u
X19 lvds_lane_0.tp.0 lvds_lane_0.VREF.0 lvds_lane_0.fb.0 lvds_lane_0.tp.0 pfet_03v3 ad=1.248p pd=5.32u as=1.248p ps=5.32u w=4.8u l=0.4u
X20 lvds_lane_2.fb.0 lvds_lane_0.VREF.0 lvds_lane_2.tp.0 lvds_lane_2.tp.0 pfet_03v3 ad=1.248p pd=5.32u as=1.248p ps=5.32u w=4.8u l=0.4u
X21 lvds_lane_0.d2b.0 lvds_lane_0.d2a.0 VDD VDD pfet_03v3 ad=0.481p pd=2.37u as=0.481p ps=2.37u w=1.85u l=0.28u
X22 lvds_lane_2.tn.0 lvds_lane_2.gn.0 lvds_lane_2.ob.0 VSS nfet_03v3 ad=1.235p pd=5.27u as=1.235p ps=5.27u w=4.75u l=0.5u
X23 lvds_lane_1.fa.0 lvds_lane_0.VREF.0 lvds_lane_1.tp.0 lvds_lane_1.tp.0 pfet_03v3 ad=1.248p pd=5.32u as=1.248p ps=5.32u w=4.8u l=0.4u
X24 lvds_lane_1.tn.0 lvds_lane_0.VBN.0 VSS VSS nfet_03v3 ad=0.65p pd=3.02u as=0.65p ps=3.02u w=2.5u l=1u
X25 VDD VDD lvds_lane_1.n3a.0 VDD pfet_03v3 ad=0.814p pd=4.58u as=0.481p ps=2.37u w=1.85u l=0.28u
X26 lvds_lane_2.fa.0 lvds_lane_0.VREF.0 lvds_lane_2.tp.0 lvds_lane_2.tp.0 pfet_03v3 ad=1.248p pd=5.32u as=1.248p ps=5.32u w=4.8u l=0.4u
X27 VSS lvds_lane_0.VBN.0 lvds_lane_0.ts.0 VSS nfet_03v3 ad=0.65p pd=3.02u as=0.65p ps=3.02u w=2.5u l=1u
X28 VSS VSS lvds_lane_1.d3.0 VSS nfet_03v3 ad=2.0504p pd=10.2u as=1.2116p ps=5.18u w=4.66u l=0.28u
X29 lvds_lane_2.tn.0 lvds_lane_2.gp.0 lvds_lane_2.oa.0 VSS nfet_03v3 ad=1.235p pd=5.27u as=1.235p ps=5.27u w=4.75u l=0.5u
X30 lvds_lane_0.fa.0 lvds_lane_0.gp.0 lvds_lane_0.tp.0 lvds_lane_0.tp.0 pfet_03v3 ad=1.248p pd=5.32u as=1.248p ps=5.32u w=4.8u l=0.4u
X31 lvds_lane_2.tp.0 lvds_lane_0.VREF.0 lvds_lane_2.fa.0 lvds_lane_2.tp.0 pfet_03v3 ad=1.248p pd=5.32u as=1.248p ps=5.32u w=4.8u l=0.4u
X32 VSS lvds_lane_0.VBN.0 lvds_lane_1.ts.0 VSS nfet_03v3 ad=0.65p pd=3.02u as=0.65p ps=3.02u w=2.5u l=1u
X33 VDD lvds_lane_1.d2b.0 lvds_lane_1.d2b.0 VDD pfet_03v3 ad=0.481p pd=2.37u as=0.481p ps=2.37u w=1.85u l=0.28u
X34 lvds_lane_0.fb.0 lvds_lane_0.VREF.0 lvds_lane_0.tp.0 lvds_lane_0.tp.0 pfet_03v3 ad=1.248p pd=5.32u as=1.248p ps=5.32u w=4.8u l=0.4u
X35 lvds_lane_0.ob.0 lvds_lane_0.gn.0 lvds_lane_0.tn.0 VSS nfet_03v3 ad=1.235p pd=5.27u as=1.235p ps=5.27u w=4.75u l=0.5u
D0 lvds_lane_2.gn.0 VDD diode_pd2nw_03v3 pj=26u area=40p
X36 lvds_lane_1.tp.0 lvds_lane_1.gn.0 lvds_lane_1.fb.0 lvds_lane_1.tp.0 pfet_03v3 ad=1.248p pd=5.32u as=1.248p ps=5.32u w=4.8u l=0.4u
X37 lvds_lane_1.fa.0 lvds_lane_0.VREF.0 lvds_lane_1.tp.0 lvds_lane_1.tp.0 pfet_03v3 ad=1.248p pd=5.32u as=1.248p ps=5.32u w=4.8u l=0.4u
X38 lvds_lane_0.d2a.0 lvds_lane_0.oa.0 lvds_lane_0.sa.0 VSS nfet_03v3 ad=1.1362p pd=4.89u as=1.1362p ps=4.89u w=4.37u l=0.5u
X39 lvds_lane_0.tp.0 lvds_lane_0.gp.0 lvds_lane_0.fa.0 lvds_lane_0.tp.0 pfet_03v3 ad=1.248p pd=5.32u as=1.248p ps=5.32u w=4.8u l=0.4u
X40 lvds_lane_2.fa.0 lvds_lane_2.gp.0 lvds_lane_2.tp.0 lvds_lane_2.tp.0 pfet_03v3 ad=1.248p pd=5.32u as=1.248p ps=5.32u w=4.8u l=0.4u
X41 lvds_lane_0.nm.0 lvds_lane_0.d3.0 lvds_lane_0.nd.0 VSS nfet_03v3 ad=0.52p pd=2.52u as=0.52p ps=2.52u w=2u l=0.28u
X42 lvds_lane_1.tp.0 lvds_lane_0.VREF.0 lvds_lane_1.fb.0 lvds_lane_1.tp.0 pfet_03v3 ad=1.248p pd=5.32u as=1.248p ps=5.32u w=4.8u l=0.4u
X43 VSS lvds_lane_0.VBN.0 lvds_lane_0.tn.0 VSS nfet_03v3 ad=0.65p pd=3.02u as=0.65p ps=3.02u w=2.5u l=1u
X44 lvds_lane_0.ob.0 lvds_lane_0.gn.0 lvds_lane_0.tn.0 VSS nfet_03v3 ad=1.235p pd=5.27u as=1.235p ps=5.27u w=4.75u l=0.5u
X45 RX0_O lvds_lane_0.i2.0 VSS VSS nfet_03v3 ad=1.04p pd=4.52u as=1.04p ps=4.52u w=4u l=0.28u
X46 VDD lvds_lane_0.VBP.0 lvds_lane_0.tp.0 VDD pfet_03v3 ad=1.3p pd=5.52u as=1.3p ps=5.52u w=5u l=1u
X47 lvds_lane_2.tp.0 lvds_lane_2.gn.0 lvds_lane_2.fb.0 lvds_lane_2.tp.0 pfet_03v3 ad=1.248p pd=5.32u as=1.248p ps=5.32u w=4.8u l=0.4u
X48 VSS lvds_lane_0.VBN.0 lvds_lane_1.fa.0 VSS nfet_03v3 ad=0.65p pd=3.02u as=0.65p ps=3.02u w=2.5u l=1u
X49 VSS lvds_lane_0.VBN.0 lvds_lane_0.VBP.0 VSS nfet_03v3 ad=0.65p pd=3.02u as=0.65p ps=3.02u w=2.5u l=1u
X50 VDD VDD VDD VDD pfet_03v3 ad=0.52p pd=2.52u as=0.29939n ps=1.39696m w=2u l=0.5u
X51 lvds_lane_2.sa.0 lvds_lane_2.oa.0 lvds_lane_2.d2a.0 VSS nfet_03v3 ad=1.1362p pd=4.89u as=1.1362p ps=4.89u w=4.37u l=0.5u
X52 VSS VSS VSS ppolyf_u_1k r_width=2u r_length=9.11u
X53 lvds_lane_2.n3a.0 lvds_lane_2.d2a.0 VDD VDD pfet_03v3 ad=0.481p pd=2.37u as=0.481p ps=2.37u w=1.85u l=0.28u
X54 VDD lvds_lane_1.d2b.0 lvds_lane_1.d2a.0 VDD pfet_03v3 ad=0.481p pd=2.37u as=0.481p ps=2.37u w=1.85u l=0.28u
X55 lvds_lane_0.n3a.0 lvds_lane_0.d2a.0 VDD VDD pfet_03v3 ad=0.481p pd=2.37u as=0.481p ps=2.37u w=1.85u l=0.28u
X56 lvds_lane_0.fa.0 lvds_lane_0.VBN.0 VSS VSS nfet_03v3 ad=0.65p pd=3.02u as=0.65p ps=3.02u w=2.5u l=1u
X57 lvds_lane_1.oa.0 lvds_lane_0.VREF.0 lvds_lane_1.tn.0 VSS nfet_03v3 ad=1.235p pd=5.27u as=1.235p ps=5.27u w=4.75u l=0.5u
X58 lvds_lane_0.oa.0 lvds_lane_0.gp.0 lvds_lane_0.tn.0 VSS nfet_03v3 ad=1.235p pd=5.27u as=1.235p ps=5.27u w=4.75u l=0.5u
X59 lvds_lane_2.d3.0 lvds_lane_2.n3a.0 VSS VSS nfet_03v3 ad=1.2116p pd=5.18u as=1.2116p ps=5.18u w=4.66u l=0.28u
X60 lvds_lane_0.fa.0 lvds_lane_0.VB2.0 lvds_lane_0.oa.0 VSS nfet_03v3 ad=1.1752p pd=5.04u as=1.1752p ps=5.04u w=4.52u l=0.5u
X61 VDD lvds_lane_0.VBP.0 lvds_lane_1.tp.0 VDD pfet_03v3 ad=1.3p pd=5.52u as=1.3p ps=5.52u w=5u l=1u
X62 lvds_lane_0.tp.0 lvds_lane_0.VREF.0 lvds_lane_0.fa.0 lvds_lane_0.tp.0 pfet_03v3 ad=1.248p pd=5.32u as=1.248p ps=5.32u w=4.8u l=0.4u
X63 lvds_lane_1.tp.0 lvds_lane_0.VREF.0 lvds_lane_1.fa.0 lvds_lane_1.tp.0 pfet_03v3 ad=1.248p pd=5.32u as=1.248p ps=5.32u w=4.8u l=0.4u
D1 VSS lvds_lane_2.gn.0 diode_nd2ps_03v3 pj=26u area=40p
X64 lvds_lane_1.fb.0 lvds_lane_1.gn.0 lvds_lane_1.tp.0 lvds_lane_1.tp.0 pfet_03v3 ad=1.248p pd=5.32u as=1.248p ps=5.32u w=4.8u l=0.4u
X65 lvds_lane_0.tn.0 lvds_lane_0.VBN.0 VSS VSS nfet_03v3 ad=0.65p pd=3.02u as=0.65p ps=3.02u w=2.5u l=1u
X66 lvds_lane_1.ob.0 lvds_lane_0.VREF.0 lvds_lane_1.tn.0 VSS nfet_03v3 ad=1.235p pd=5.27u as=1.235p ps=5.27u w=4.75u l=0.5u
X67 RX2_O lvds_lane_2.i2.0 VSS VSS nfet_03v3 ad=1.04p pd=4.52u as=1.04p ps=4.52u w=4u l=0.28u
X68 lvds_lane_2.oa.0 lvds_lane_0.VB2.0 lvds_lane_2.fa.0 VSS nfet_03v3 ad=1.1752p pd=5.04u as=1.1752p ps=5.04u w=4.52u l=0.5u
X69 lvds_lane_0.d2b.0 lvds_lane_0.d2a.0 VDD VDD pfet_03v3 ad=0.481p pd=2.37u as=0.481p ps=2.37u w=1.85u l=0.28u
X70 VDD lvds_lane_0.VBP.0 lvds_lane_1.tp.0 VDD pfet_03v3 ad=1.3p pd=5.52u as=1.3p ps=5.52u w=5u l=1u
X71 lvds_lane_0.fa.0 lvds_lane_0.VB2.0 lvds_lane_0.oa.0 VSS nfet_03v3 ad=1.1752p pd=5.04u as=1.1752p ps=5.04u w=4.52u l=0.5u
X72 lvds_lane_1.tn.0 VSS VSS VSS nfet_03v3 ad=0.65p pd=3.02u as=1.1p ps=5.88u w=2.5u l=1u
X73 VDD lvds_lane_0.i2.0 RX0_O VDD pfet_03v3 ad=1.3p pd=5.52u as=1.3p ps=5.52u w=5u l=0.28u
X74 VDD lvds_lane_2.d3.0 lvds_lane_2.nd.0 VDD pfet_03v3 ad=0.78p pd=3.52u as=0.78p ps=3.52u w=3u l=0.28u
X75 VDD VDD VDD VDD pfet_03v3 ad=0.481p pd=2.37u as=0 ps=0 w=1.85u l=0.28u
X76 VDD VDD lvds_lane_0.i2.0 VDD pfet_03v3 ad=1.65p pd=8.38u as=0.975p ps=4.27u w=3.75u l=0.28u
X77 VSS lvds_lane_0.VBN.0 lvds_lane_2.fa.0 VSS nfet_03v3 ad=0.65p pd=3.02u as=0.65p ps=3.02u w=2.5u l=1u
X78 lvds_lane_1.tn.0 lvds_lane_1.gp.0 lvds_lane_1.oa.0 VSS nfet_03v3 ad=1.235p pd=5.27u as=1.235p ps=5.27u w=4.75u l=0.5u
X79 lvds_lane_1.ts.0 lvds_lane_0.VBN.0 VSS VSS nfet_03v3 ad=0.65p pd=3.02u as=0.65p ps=3.02u w=2.5u l=1u
X80 VDD lvds_lane_0.d2b.0 lvds_lane_0.d3.0 VDD pfet_03v3 ad=0.481p pd=2.37u as=0.481p ps=2.37u w=1.85u l=0.28u
X81 VDD lvds_lane_0.rla_m1.0 VSS ppolyf_u_1k r_width=2u r_length=9.11u
X82 lvds_lane_2.oa.0 VSS VSS VSS nfet_03v3 ad=1.1752p pd=5.04u as=1.9888p ps=9.92u w=4.52u l=0.5u
X83 lvds_lane_2.d2a.0 lvds_lane_2.d2b.0 VDD VDD pfet_03v3 ad=0.481p pd=2.37u as=0.481p ps=2.37u w=1.85u l=0.28u
X84 lvds_lane_0.d2a.0 lvds_lane_0.d2a.0 VDD VDD pfet_03v3 ad=0.481p pd=2.37u as=0.481p ps=2.37u w=1.85u l=0.28u
X85 VSS lvds_lane_0.VBN.0 lvds_lane_0.fa.0 VSS nfet_03v3 ad=0.65p pd=3.02u as=0.65p ps=3.02u w=2.5u l=1u
X86 VDD lvds_lane_1.d2b.0 lvds_lane_1.d3.0 VDD pfet_03v3 ad=0.481p pd=2.37u as=0.481p ps=2.37u w=1.85u l=0.28u
X87 lvds_lane_1.d2a.0 lvds_lane_1.d2b.0 VDD VDD pfet_03v3 ad=0.481p pd=2.37u as=0.481p ps=2.37u w=1.85u l=0.28u
X88 lvds_lane_1.ts.0 lvds_lane_1.sb.0 VSS ppolyf_u_1k r_width=5u r_length=1.64u
X89 lvds_lane_0.tp.0 lvds_lane_0.VREF.0 lvds_lane_0.fb.0 lvds_lane_0.tp.0 pfet_03v3 ad=1.248p pd=5.32u as=2.112p ps=10.48u w=4.8u l=0.4u
X90 lvds_lane_2.fb.0 lvds_lane_2.gn.0 lvds_lane_2.tp.0 lvds_lane_2.tp.0 pfet_03v3 ad=1.248p pd=5.32u as=1.248p ps=5.32u w=4.8u l=0.4u
X91 VDD lvds_lane_2.i2.0 RX2_O VDD pfet_03v3 ad=1.3p pd=5.52u as=1.3p ps=5.52u w=5u l=0.28u
X92 lvds_lane_0.fa.0 lvds_lane_0.gp.0 lvds_lane_0.tp.0 lvds_lane_0.tp.0 pfet_03v3 ad=1.248p pd=5.32u as=1.248p ps=5.32u w=4.8u l=0.4u
X93 lvds_lane_1.tp.0 lvds_lane_0.VREF.0 lvds_lane_1.fa.0 lvds_lane_1.tp.0 pfet_03v3 ad=1.248p pd=5.32u as=1.248p ps=5.32u w=4.8u l=0.4u
X94 lvds_lane_0.tp.0 lvds_lane_0.VBP.0 VDD VDD pfet_03v3 ad=1.3p pd=5.52u as=1.3p ps=5.52u w=5u l=1u
X95 lvds_lane_1.fb.0 lvds_lane_0.VBN.0 VSS VSS nfet_03v3 ad=0.65p pd=3.02u as=0.65p ps=3.02u w=2.5u l=1u
X96 lvds_lane_2.tp.0 lvds_lane_2.gp.0 lvds_lane_2.fa.0 lvds_lane_2.tp.0 pfet_03v3 ad=1.248p pd=5.32u as=1.248p ps=5.32u w=4.8u l=0.4u
X97 lvds_lane_1.tp.0 lvds_lane_0.VBP.0 VDD VDD pfet_03v3 ad=1.3p pd=5.52u as=1.3p ps=5.52u w=5u l=1u
X98 lvds_lane_1.fa.0 lvds_lane_1.gp.0 lvds_lane_1.tp.0 lvds_lane_1.tp.0 pfet_03v3 ad=1.248p pd=5.32u as=1.248p ps=5.32u w=4.8u l=0.4u
X99 lvds_lane_2.fa.0 lvds_lane_2.gp.0 lvds_lane_2.tp.0 lvds_lane_2.tp.0 pfet_03v3 ad=1.248p pd=5.32u as=1.248p ps=5.32u w=4.8u l=0.4u
X100 lvds_lane_2.fa.0 lvds_lane_0.VBN.0 VSS VSS nfet_03v3 ad=0.65p pd=3.02u as=0.65p ps=3.02u w=2.5u l=1u
X101 VSS lvds_lane_0.VBN.0 lvds_lane_1.fb.0 VSS nfet_03v3 ad=0.65p pd=3.02u as=0.65p ps=3.02u w=2.5u l=1u
X102 VSS VSS RX0_O VSS nfet_03v3 ad=1.76p pd=8.88u as=1.04p ps=4.52u w=4u l=0.28u
X103 VDD lvds_lane_0.d2b.0 lvds_lane_0.d2a.0 VDD pfet_03v3 ad=0.481p pd=2.37u as=0.481p ps=2.37u w=1.85u l=0.28u
X104 VSS VSS lvds_lane_2.ts.0 VSS nfet_03v3 ad=1.1p pd=5.88u as=0.65p ps=3.02u w=2.5u l=1u
X105 lvds_lane_0.tp.0 lvds_lane_0.VREF.0 lvds_lane_0.fb.0 lvds_lane_0.tp.0 pfet_03v3 ad=1.248p pd=5.32u as=1.248p ps=5.32u w=4.8u l=0.4u
X106 VDD lvds_lane_2.d2a.0 lvds_lane_2.d2b.0 VDD pfet_03v3 ad=0.481p pd=2.37u as=0.481p ps=2.37u w=1.85u l=0.28u
X107 VDD VDD VDD VDD pfet_03v3 ad=0.814p pd=4.58u as=0 ps=0 w=1.85u l=0.28u
X108 lvds_lane_1.tp.0 lvds_lane_1.gp.0 lvds_lane_1.fa.0 lvds_lane_1.tp.0 pfet_03v3 ad=1.248p pd=5.32u as=1.248p ps=5.32u w=4.8u l=0.4u
X109 VDD EN lvds_lane_2.d2b.0 VDD pfet_03v3 ad=0.52p pd=2.52u as=0.52p ps=2.52u w=2u l=0.5u
X110 VDD VDD VDD VDD pfet_03v3 ad=1.3p pd=5.52u as=0 ps=0 w=5u l=1u
X111 lvds_lane_0.fb.0 lvds_lane_0.VREF.0 lvds_lane_0.tp.0 lvds_lane_0.tp.0 pfet_03v3 ad=1.248p pd=5.32u as=1.248p ps=5.32u w=4.8u l=0.4u
X112 VSS lvds_lane_0.VBN.0 lvds_lane_1.tn.0 VSS nfet_03v3 ad=0.65p pd=3.02u as=0.65p ps=3.02u w=2.5u l=1u
X113 lvds_lane_0.d3.0 lvds_lane_0.d2b.0 VDD VDD pfet_03v3 ad=0.481p pd=2.37u as=0.481p ps=2.37u w=1.85u l=0.28u
X114 lvds_lane_0.tp.0 lvds_lane_0.VREF.0 lvds_lane_0.fb.0 lvds_lane_0.tp.0 pfet_03v3 ad=1.248p pd=5.32u as=1.248p ps=5.32u w=4.8u l=0.4u
X115 lvds_lane_1.tp.0 lvds_lane_1.gn.0 lvds_lane_1.fb.0 lvds_lane_1.tp.0 pfet_03v3 ad=1.248p pd=5.32u as=1.248p ps=5.32u w=4.8u l=0.4u
X116 lvds_lane_1.tp.0 lvds_lane_1.gn.0 lvds_lane_1.fb.0 lvds_lane_1.tp.0 pfet_03v3 ad=1.248p pd=5.32u as=1.248p ps=5.32u w=4.8u l=0.4u
X117 lvds_lane_2.i2.0 lvds_lane_2.i1.0 VDD VDD pfet_03v3 ad=0.975p pd=4.27u as=0.975p ps=4.27u w=3.75u l=0.28u
X118 VDD lvds_lane_2.d2a.0 lvds_lane_2.d2b.0 VDD pfet_03v3 ad=0.481p pd=2.37u as=0.481p ps=2.37u w=1.85u l=0.28u
X119 lvds_lane_0.VB2.0 lvds_lane_0.VBP.0 VDD VDD pfet_03v3 ad=1.3p pd=5.52u as=1.3p ps=5.52u w=5u l=1u
X120 lvds_lane_2.fa.0 lvds_lane_0.VREF.0 lvds_lane_2.tp.0 lvds_lane_2.tp.0 pfet_03v3 ad=1.248p pd=5.32u as=1.248p ps=5.32u w=4.8u l=0.4u
X121 VSS lvds_lane_0.VBN.0 lvds_lane_2.tn.0 VSS nfet_03v3 ad=0.65p pd=3.02u as=0.65p ps=3.02u w=2.5u l=1u
X122 VDD lvds_lane_0.d2b.0 lvds_lane_0.d2b.0 VDD pfet_03v3 ad=0.481p pd=2.37u as=0.481p ps=2.37u w=1.85u l=0.28u
X123 lvds_lane_1.d3.0 lvds_lane_1.d2b.0 VDD VDD pfet_03v3 ad=0.481p pd=2.37u as=0.481p ps=2.37u w=1.85u l=0.28u
D2 VSS lvds_lane_0.gp.0 diode_nd2ps_03v3 pj=26u area=40p
X124 lvds_lane_1.fb.0 lvds_lane_1.gn.0 lvds_lane_1.tp.0 lvds_lane_1.tp.0 pfet_03v3 ad=1.248p pd=5.32u as=1.248p ps=5.32u w=4.8u l=0.4u
X125 VSS VSS RX2_O VSS nfet_03v3 ad=1.76p pd=8.88u as=1.04p ps=4.52u w=4u l=0.28u
X126 VSS VSS lvds_lane_1.d2a.0 VSS nfet_03v3 ad=1.9228p pd=9.62u as=1.1362p ps=4.89u w=4.37u l=0.5u
X127 lvds_lane_0.fb.0 lvds_lane_0.VBN.0 VSS VSS nfet_03v3 ad=0.65p pd=3.02u as=0.65p ps=3.02u w=2.5u l=1u
X128 lvds_lane_1.n3a.0 VSS VSS VSS nfet_03v3 ad=1.2116p pd=5.18u as=2.0504p ps=10.2u w=4.66u l=0.28u
X129 lvds_lane_1.sb.0 lvds_lane_1.ob.0 lvds_lane_1.d2b.0 VSS nfet_03v3 ad=1.1362p pd=4.89u as=1.1362p ps=4.89u w=4.37u l=0.5u
X130 lvds_lane_1.oa.0 lvds_lane_0.VREF.0 lvds_lane_1.tn.0 VSS nfet_03v3 ad=1.235p pd=5.27u as=1.235p ps=5.27u w=4.75u l=0.5u
X131 lvds_lane_1.d2a.0 lvds_lane_1.d2b.0 VDD VDD pfet_03v3 ad=0.481p pd=2.37u as=0.481p ps=2.37u w=1.85u l=0.28u
X132 lvds_lane_2.n3a.0 VDD VDD VDD pfet_03v3 ad=0.481p pd=2.37u as=0.814p ps=4.58u w=1.85u l=0.28u
X133 VDD lvds_lane_0.VBP.0 lvds_lane_1.tp.0 VDD pfet_03v3 ad=1.3p pd=5.52u as=1.3p ps=5.52u w=5u l=1u
X134 VDD lvds_lane_0.VBP.0 lvds_lane_2.tp.0 VDD pfet_03v3 ad=1.3p pd=5.52u as=1.3p ps=5.52u w=5u l=1u
X135 VDD lvds_lane_0.VBP.0 lvds_lane_0.VB2.0 VDD pfet_03v3 ad=1.3p pd=5.52u as=1.3p ps=5.52u w=5u l=1u
X136 lvds_lane_1.fb.0 lvds_lane_1.gn.0 lvds_lane_1.tp.0 lvds_lane_1.tp.0 pfet_03v3 ad=1.248p pd=5.32u as=1.248p ps=5.32u w=4.8u l=0.4u
X137 lvds_lane_2.fb.0 lvds_lane_2.gn.0 lvds_lane_2.tp.0 lvds_lane_2.tp.0 pfet_03v3 ad=1.248p pd=5.32u as=1.248p ps=5.32u w=4.8u l=0.4u
X138 VSS lvds_lane_0.VBN.0 lvds_lane_2.fa.0 VSS nfet_03v3 ad=0.65p pd=3.02u as=0.65p ps=3.02u w=2.5u l=1u
X139 lvds_lane_0.tn.0 lvds_lane_0.gp.0 lvds_lane_0.oa.0 VSS nfet_03v3 ad=1.235p pd=5.27u as=1.235p ps=5.27u w=4.75u l=0.5u
X140 lvds_lane_1.ob.0 lvds_lane_0.VREF.0 lvds_lane_1.tn.0 VSS nfet_03v3 ad=1.235p pd=5.27u as=1.235p ps=5.27u w=4.75u l=0.5u
X141 VSS lvds_lane_0.VBN.0 lvds_lane_0.fb.0 VSS nfet_03v3 ad=0.65p pd=3.02u as=0.65p ps=3.02u w=2.5u l=1u
X142 lvds_lane_1.d2b.0 lvds_lane_1.d2b.0 VDD VDD pfet_03v3 ad=0.481p pd=2.37u as=0.481p ps=2.37u w=1.85u l=0.28u
X143 lvds_lane_2.tp.0 lvds_lane_0.VREF.0 lvds_lane_2.fb.0 lvds_lane_2.tp.0 pfet_03v3 ad=1.248p pd=5.32u as=1.248p ps=5.32u w=4.8u l=0.4u
X144 lvds_lane_1.ob.0 lvds_lane_0.VB2.0 lvds_lane_1.fb.0 VSS nfet_03v3 ad=1.1752p pd=5.04u as=1.1752p ps=5.04u w=4.52u l=0.5u
X145 VDD lvds_lane_2.d2a.0 lvds_lane_2.n3a.0 VDD pfet_03v3 ad=0.481p pd=2.37u as=0.481p ps=2.37u w=1.85u l=0.28u
X146 VSS lvds_lane_0.VBN.0 lvds_lane_1.fa.0 VSS nfet_03v3 ad=0.65p pd=3.02u as=0.65p ps=3.02u w=2.5u l=1u
X147 lvds_lane_2.oa.0 lvds_lane_2.gp.0 lvds_lane_2.tn.0 VSS nfet_03v3 ad=1.235p pd=5.27u as=1.235p ps=5.27u w=4.75u l=0.5u
X148 lvds_lane_1.tp.0 lvds_lane_1.gn.0 lvds_lane_1.fb.0 lvds_lane_1.tp.0 pfet_03v3 ad=1.248p pd=5.32u as=1.248p ps=5.32u w=4.8u l=0.4u
X149 lvds_lane_0.tn.0 lvds_lane_0.gn.0 lvds_lane_0.ob.0 VSS nfet_03v3 ad=1.235p pd=5.27u as=1.235p ps=5.27u w=4.75u l=0.5u
X150 lvds_lane_1.oa.0 lvds_lane_0.VREF.0 lvds_lane_1.tn.0 VSS nfet_03v3 ad=1.235p pd=5.27u as=1.235p ps=5.27u w=4.75u l=0.5u
X151 lvds_lane_1.ob.0 lvds_lane_0.VB2.0 lvds_lane_1.fb.0 VSS nfet_03v3 ad=1.1752p pd=5.04u as=1.1752p ps=5.04u w=4.52u l=0.5u
X152 lvds_lane_1.tp.0 lvds_lane_0.VBP.0 VDD VDD pfet_03v3 ad=1.3p pd=5.52u as=1.3p ps=5.52u w=5u l=1u
X153 lvds_lane_0.tp.0 lvds_lane_0.gp.0 lvds_lane_0.fa.0 lvds_lane_0.tp.0 pfet_03v3 ad=1.248p pd=5.32u as=1.248p ps=5.32u w=4.8u l=0.4u
X154 lvds_lane_2.fb.0 lvds_lane_0.VREF.0 lvds_lane_2.tp.0 lvds_lane_2.tp.0 pfet_03v3 ad=1.248p pd=5.32u as=1.248p ps=5.32u w=4.8u l=0.4u
X155 lvds_lane_2.ob.0 lvds_lane_2.gn.0 lvds_lane_2.tn.0 VSS nfet_03v3 ad=1.235p pd=5.27u as=1.235p ps=5.27u w=4.75u l=0.5u
X156 VSS lvds_lane_0.VBN.0 lvds_lane_0.VBN.0 VSS nfet_03v3 ad=0.65p pd=3.02u as=0.65p ps=3.02u w=2.5u l=1u
X157 lvds_lane_0.tn.0 lvds_lane_0.VREF.0 lvds_lane_0.ob.0 VSS nfet_03v3 ad=1.235p pd=5.27u as=1.235p ps=5.27u w=4.75u l=0.5u
X158 lvds_lane_2.tn.0 lvds_lane_0.VBN.0 VSS VSS nfet_03v3 ad=0.65p pd=3.02u as=0.65p ps=3.02u w=2.5u l=1u
X159 lvds_lane_2.tp.0 lvds_lane_0.VBP.0 VDD VDD pfet_03v3 ad=1.3p pd=5.52u as=1.3p ps=5.52u w=5u l=1u
X160 lvds_lane_2.fa.0 lvds_lane_0.VBN.0 VSS VSS nfet_03v3 ad=0.65p pd=3.02u as=0.65p ps=3.02u w=2.5u l=1u
X161 lvds_bias_0.rdb_m2.0 lvds_bias_0.rdb_m1.0 VSS ppolyf_u_1k r_width=2u r_length=19.26u
X162 lvds_lane_1.fa.0 lvds_lane_1.gp.0 lvds_lane_1.tp.0 lvds_lane_1.tp.0 pfet_03v3 ad=1.248p pd=5.32u as=1.248p ps=5.32u w=4.8u l=0.4u
X163 lvds_lane_1.ob.0 VSS VSS VSS nfet_03v3 ad=1.1752p pd=5.04u as=1.9888p ps=9.92u w=4.52u l=0.5u
X164 lvds_lane_2.tp.0 lvds_lane_0.VBP.0 VDD VDD pfet_03v3 ad=1.3p pd=5.52u as=1.3p ps=5.52u w=5u l=1u
X165 lvds_lane_1.tp.0 lvds_lane_0.VREF.0 lvds_lane_1.fa.0 lvds_lane_1.tp.0 pfet_03v3 ad=1.248p pd=5.32u as=1.248p ps=5.32u w=4.8u l=0.4u
X166 VDD EN lvds_bias_0.enb.0 VDD pfet_03v3 ad=0.65p pd=3.02u as=0.65p ps=3.02u w=2.5u l=0.28u
X167 lvds_lane_0.fb.0 lvds_lane_0.gn.0 lvds_lane_0.tp.0 lvds_lane_0.tp.0 pfet_03v3 ad=1.248p pd=5.32u as=1.248p ps=5.32u w=4.8u l=0.4u
X168 lvds_lane_2.tp.0 lvds_lane_2.gp.0 lvds_lane_2.fa.0 lvds_lane_2.tp.0 pfet_03v3 ad=1.248p pd=5.32u as=1.248p ps=5.32u w=4.8u l=0.4u
X169 lvds_lane_2.ob.0 lvds_lane_0.VREF.0 lvds_lane_2.tn.0 VSS nfet_03v3 ad=1.235p pd=5.27u as=1.235p ps=5.27u w=4.75u l=0.5u
X170 lvds_lane_2.tn.0 lvds_lane_2.gn.0 lvds_lane_2.ob.0 VSS nfet_03v3 ad=1.235p pd=5.27u as=1.235p ps=5.27u w=4.75u l=0.5u
X171 VSS VSS VSS VSS nfet_03v3 ad=0.52p pd=2.52u as=0.26641n ps=1.29436m w=2u l=0.5u
X172 lvds_lane_0.oa.0 lvds_lane_0.gp.0 lvds_lane_0.tn.0 VSS nfet_03v3 ad=1.235p pd=5.27u as=1.235p ps=5.27u w=4.75u l=0.5u
X173 VDD EN lvds_lane_1.d2a.0 VDD pfet_03v3 ad=0.52p pd=2.52u as=0.52p ps=2.52u w=2u l=0.5u
X174 lvds_lane_1.n3a.0 lvds_lane_1.d2a.0 VDD VDD pfet_03v3 ad=0.481p pd=2.37u as=0.481p ps=2.37u w=1.85u l=0.28u
X175 lvds_lane_0.tp.0 lvds_lane_0.gn.0 lvds_lane_0.fb.0 lvds_lane_0.tp.0 pfet_03v3 ad=1.248p pd=5.32u as=1.248p ps=5.32u w=4.8u l=0.4u
X176 lvds_lane_0.VBN.0 VSS VSS VSS nfet_03v3 ad=0.52p pd=2.52u as=0.88p ps=4.88u w=2u l=0.5u
X177 VDD lvds_lane_0.VBP.0 lvds_lane_1.tp.0 VDD pfet_03v3 ad=1.3p pd=5.52u as=1.3p ps=5.52u w=5u l=1u
X178 lvds_lane_0.fb.0 lvds_lane_0.VREF.0 lvds_lane_0.tp.0 lvds_lane_0.tp.0 pfet_03v3 ad=1.248p pd=5.32u as=1.248p ps=5.32u w=4.8u l=0.4u
X179 lvds_lane_1.tp.0 lvds_lane_1.gn.0 lvds_lane_1.fb.0 lvds_lane_1.tp.0 pfet_03v3 ad=1.248p pd=5.32u as=1.248p ps=5.32u w=4.8u l=0.4u
X180 lvds_lane_0.tp.0 lvds_lane_0.VBP.0 VDD VDD pfet_03v3 ad=1.3p pd=5.52u as=1.3p ps=5.52u w=5u l=1u
X181 lvds_lane_1.fb.0 lvds_lane_0.VBN.0 VSS VSS nfet_03v3 ad=0.65p pd=3.02u as=0.65p ps=3.02u w=2.5u l=1u
X182 VSS VSS lvds_bias_0.vf.0 VSS nfet_03v3 ad=3.4804p pd=16.7u as=2.0566p ps=8.43u w=7.91u l=0.5u
X183 lvds_lane_1.d2b.0 VDD VDD VDD pfet_03v3 ad=0.52p pd=2.52u as=0.88p ps=4.88u w=2u l=0.5u
X184 lvds_lane_2.ts.0 lvds_lane_2.sa.0 VSS ppolyf_u_1k r_width=5u r_length=1.64u
X185 lvds_lane_0.VBP.0 VDD VDD VDD pfet_03v3 ad=1.3p pd=5.52u as=2.2p ps=10.88u w=5u l=1u
X186 lvds_lane_2.fa.0 lvds_lane_0.VREF.0 lvds_lane_2.tp.0 lvds_lane_2.tp.0 pfet_03v3 ad=1.248p pd=5.32u as=1.248p ps=5.32u w=4.8u l=0.4u
X187 VSS VSS lvds_lane_2.fa.0 VSS nfet_03v3 ad=1.9888p pd=9.92u as=1.1752p ps=5.04u w=4.52u l=0.5u
X188 VDD lvds_lane_2.nd.0 lvds_lane_2.i1.0 VDD pfet_03v3 ad=0.962p pd=4.22u as=0.962p ps=4.22u w=3.7u l=0.28u
X189 VDD lvds_lane_0.VBP.0 lvds_lane_0.VBP.0 VDD pfet_03v3 ad=1.3p pd=5.52u as=1.3p ps=5.52u w=5u l=1u
X190 VDD lvds_lane_0.VBP.0 lvds_lane_2.tp.0 VDD pfet_03v3 ad=1.3p pd=5.52u as=1.3p ps=5.52u w=5u l=1u
X191 lvds_lane_1.fb.0 lvds_lane_1.gn.0 lvds_lane_1.tp.0 lvds_lane_1.tp.0 pfet_03v3 ad=1.248p pd=5.32u as=1.248p ps=5.32u w=4.8u l=0.4u
X192 lvds_lane_1.oa.0 lvds_lane_0.VREF.0 lvds_lane_1.tn.0 VSS nfet_03v3 ad=1.235p pd=5.27u as=1.235p ps=5.27u w=4.75u l=0.5u
X193 lvds_lane_2.tp.0 lvds_lane_0.VREF.0 lvds_lane_2.fb.0 lvds_lane_2.tp.0 pfet_03v3 ad=1.248p pd=5.32u as=1.248p ps=5.32u w=4.8u l=0.4u
X194 VDD lvds_lane_0.VBP.0 lvds_lane_2.tp.0 VDD pfet_03v3 ad=1.3p pd=5.52u as=1.3p ps=5.52u w=5u l=1u
X195 lvds_lane_2.oa.0 lvds_lane_0.VB2.0 lvds_lane_2.fa.0 VSS nfet_03v3 ad=1.1752p pd=5.04u as=1.1752p ps=5.04u w=4.52u l=0.5u
X196 lvds_lane_0.tp.0 lvds_lane_0.gp.0 lvds_lane_0.fa.0 lvds_lane_0.tp.0 pfet_03v3 ad=1.248p pd=5.32u as=1.248p ps=5.32u w=4.8u l=0.4u
X197 lvds_lane_1.fb.0 lvds_lane_0.VREF.0 lvds_lane_1.tp.0 lvds_lane_1.tp.0 pfet_03v3 ad=1.248p pd=5.32u as=1.248p ps=5.32u w=4.8u l=0.4u
X198 lvds_lane_2.fb.0 lvds_lane_0.VB2.0 lvds_lane_2.ob.0 VSS nfet_03v3 ad=1.1752p pd=5.04u as=1.1752p ps=5.04u w=4.52u l=0.5u
X199 VSS lvds_lane_0.VREF.0 VSS VSS nfet_03v3 ad=8.8p pd=40.88u as=0 ps=0 w=20u l=25.13u
X200 lvds_lane_1.i2.0 VDD VDD VDD pfet_03v3 ad=0.975p pd=4.27u as=1.65p ps=8.38u w=3.75u l=0.28u
X201 lvds_bias_0.rf_m1.0 VSS VSS ppolyf_u_1k r_width=2u r_length=23.07u
X202 lvds_lane_0.VB2.0 VSS VSS VSS nfet_03v3 ad=2.0566p pd=8.43u as=3.4804p ps=16.7u w=7.91u l=0.5u
X203 lvds_lane_2.tp.0 lvds_lane_2.gp.0 lvds_lane_2.fa.0 lvds_lane_2.tp.0 pfet_03v3 ad=1.248p pd=5.32u as=1.248p ps=5.32u w=4.8u l=0.4u
X204 VSS lvds_lane_0.VBN.0 lvds_lane_0.fb.0 VSS nfet_03v3 ad=0.65p pd=3.02u as=0.65p ps=3.02u w=2.5u l=1u
X205 lvds_lane_0.ob.0 lvds_lane_0.VB2.0 lvds_lane_0.fb.0 VSS nfet_03v3 ad=1.1752p pd=5.04u as=1.1752p ps=5.04u w=4.52u l=0.5u
X206 lvds_lane_2.tp.0 lvds_lane_0.VBP.0 VDD VDD pfet_03v3 ad=1.3p pd=5.52u as=1.3p ps=5.52u w=5u l=1u
X207 lvds_lane_0.fa.0 lvds_lane_0.VREF.0 lvds_lane_0.tp.0 lvds_lane_0.tp.0 pfet_03v3 ad=1.248p pd=5.32u as=1.248p ps=5.32u w=4.8u l=0.4u
X208 lvds_lane_1.fb.0 lvds_lane_1.gn.0 lvds_lane_1.tp.0 lvds_lane_1.tp.0 pfet_03v3 ad=1.248p pd=5.32u as=1.248p ps=5.32u w=4.8u l=0.4u
X209 lvds_lane_2.fb.0 lvds_lane_0.VREF.0 lvds_lane_2.tp.0 lvds_lane_2.tp.0 pfet_03v3 ad=1.248p pd=5.32u as=1.248p ps=5.32u w=4.8u l=0.4u
X210 VDD VDD lvds_lane_1.tp.0 VDD pfet_03v3 ad=2.2p pd=10.88u as=1.3p ps=5.52u w=5u l=1u
X211 lvds_lane_0.fa.0 lvds_lane_0.VREF.0 lvds_lane_0.tp.0 lvds_lane_0.tp.0 pfet_03v3 ad=1.248p pd=5.32u as=1.248p ps=5.32u w=4.8u l=0.4u
X212 lvds_lane_1.tp.0 lvds_lane_0.VREF.0 lvds_lane_1.fa.0 lvds_lane_1.tp.0 pfet_03v3 ad=1.248p pd=5.32u as=1.248p ps=5.32u w=4.8u l=0.4u
X213 lvds_lane_0.tn.0 lvds_lane_0.VBN.0 VSS VSS nfet_03v3 ad=0.65p pd=3.02u as=0.65p ps=3.02u w=2.5u l=1u
X214 VDD VDD lvds_lane_0.n3a.0 VDD pfet_03v3 ad=0.814p pd=4.58u as=0.481p ps=2.37u w=1.85u l=0.28u
X215 VSS lvds_lane_0.VBN.0 lvds_lane_2.ts.0 VSS nfet_03v3 ad=0.65p pd=3.02u as=0.65p ps=3.02u w=2.5u l=1u
X216 VSS lvds_bias_0.enb.0 lvds_lane_0.VB2.0 VSS nfet_03v3 ad=0.52p pd=2.52u as=0.52p ps=2.52u w=2u l=0.5u
X217 VSS lvds_lane_0.VBN.0 lvds_lane_0.ts.0 VSS nfet_03v3 ad=0.65p pd=3.02u as=0.65p ps=3.02u w=2.5u l=1u
X218 lvds_lane_1.tp.0 lvds_lane_0.VREF.0 lvds_lane_1.fa.0 lvds_lane_1.tp.0 pfet_03v3 ad=1.248p pd=5.32u as=1.248p ps=5.32u w=4.8u l=0.4u
X219 VDD lvds_lane_0.d2b.0 lvds_lane_0.d2b.0 VDD pfet_03v3 ad=0.481p pd=2.37u as=0.481p ps=2.37u w=1.85u l=0.28u
X220 lvds_lane_0.tp.0 lvds_lane_0.gn.0 lvds_lane_0.fb.0 lvds_lane_0.tp.0 pfet_03v3 ad=1.248p pd=5.32u as=1.248p ps=5.32u w=4.8u l=0.4u
X221 lvds_lane_0.fa.0 lvds_lane_0.VREF.0 lvds_lane_0.tp.0 lvds_lane_0.tp.0 pfet_03v3 ad=1.248p pd=5.32u as=1.248p ps=5.32u w=4.8u l=0.4u
X222 lvds_lane_1.fa.0 lvds_lane_0.VREF.0 lvds_lane_1.tp.0 lvds_lane_1.tp.0 pfet_03v3 ad=1.248p pd=5.32u as=1.248p ps=5.32u w=4.8u l=0.4u
X223 lvds_lane_2.tp.0 lvds_lane_2.gp.0 lvds_lane_2.fa.0 lvds_lane_2.tp.0 pfet_03v3 ad=1.248p pd=5.32u as=1.248p ps=5.32u w=4.8u l=0.4u
X224 lvds_lane_1.tn.0 lvds_lane_1.gp.0 lvds_lane_1.oa.0 VSS nfet_03v3 ad=1.235p pd=5.27u as=1.235p ps=5.27u w=4.75u l=0.5u
X225 lvds_lane_0.tp.0 lvds_lane_0.VREF.0 lvds_lane_0.fb.0 lvds_lane_0.tp.0 pfet_03v3 ad=1.248p pd=5.32u as=1.248p ps=5.32u w=4.8u l=0.4u
X226 lvds_lane_1.tp.0 lvds_lane_1.gn.0 lvds_lane_1.fb.0 lvds_lane_1.tp.0 pfet_03v3 ad=1.248p pd=5.32u as=1.248p ps=5.32u w=4.8u l=0.4u
X227 lvds_lane_2.fa.0 lvds_lane_2.gp.0 lvds_lane_2.tp.0 lvds_lane_2.tp.0 pfet_03v3 ad=1.248p pd=5.32u as=1.248p ps=5.32u w=4.8u l=0.4u
X228 lvds_bias_0.nrb.0 VDD VDD VDD pfet_03v3 ad=1.3p pd=5.52u as=2.2p ps=10.88u w=5u l=0.5u
X229 lvds_lane_1.sa.0 lvds_lane_1.oa.0 lvds_lane_1.d2a.0 VSS nfet_03v3 ad=1.1362p pd=4.89u as=1.1362p ps=4.89u w=4.37u l=0.5u
X230 VSS VSS VSS ppolyf_u_1k r_width=2u r_length=9.11u
X231 lvds_lane_2.tn.0 lvds_lane_0.VREF.0 lvds_lane_2.ob.0 VSS nfet_03v3 ad=1.235p pd=5.27u as=1.235p ps=5.27u w=4.75u l=0.5u
X232 VSS lvds_lane_0.VBN.0 lvds_lane_0.fa.0 VSS nfet_03v3 ad=0.65p pd=3.02u as=0.65p ps=3.02u w=2.5u l=1u
X233 VSS VSS lvds_lane_0.VBP.0 VSS nfet_03v3 ad=1.1p pd=5.88u as=0.65p ps=3.02u w=2.5u l=1u
X234 lvds_lane_1.n3a.0 lvds_lane_1.d2a.0 VDD VDD pfet_03v3 ad=0.481p pd=2.37u as=0.481p ps=2.37u w=1.85u l=0.28u
X235 VDD VDD VDD VDD pfet_03v3 ad=0.52p pd=2.52u as=0 ps=0 w=2u l=0.5u
X236 VDD lvds_lane_0.d2b.0 lvds_lane_0.d2a.0 VDD pfet_03v3 ad=0.481p pd=2.37u as=0.481p ps=2.37u w=1.85u l=0.28u
X237 lvds_lane_0.oa.0 lvds_lane_0.VREF.0 lvds_lane_0.tn.0 VSS nfet_03v3 ad=1.235p pd=5.27u as=1.235p ps=5.27u w=4.75u l=0.5u
X238 lvds_lane_1.tn.0 lvds_lane_1.gp.0 lvds_lane_1.oa.0 VSS nfet_03v3 ad=1.235p pd=5.27u as=1.235p ps=5.27u w=4.75u l=0.5u
X239 lvds_lane_1.d3.0 lvds_lane_1.n3a.0 VSS VSS nfet_03v3 ad=1.2116p pd=5.18u as=1.2116p ps=5.18u w=4.66u l=0.28u
X240 lvds_lane_1.fa.0 lvds_lane_1.gp.0 lvds_lane_1.tp.0 lvds_lane_1.tp.0 pfet_03v3 ad=1.248p pd=5.32u as=1.248p ps=5.32u w=4.8u l=0.4u
X241 VSS VSS lvds_lane_1.fa.0 VSS nfet_03v3 ad=1.1p pd=5.88u as=0.65p ps=3.02u w=2.5u l=1u
D3 lvds_lane_0.gp.0 VDD diode_pd2nw_03v3 pj=26u area=40p
X242 lvds_lane_0.tp.0 lvds_lane_0.VREF.0 lvds_lane_0.fa.0 lvds_lane_0.tp.0 pfet_03v3 ad=1.248p pd=5.32u as=1.248p ps=5.32u w=4.8u l=0.4u
X243 VSS lvds_lane_1.i1.0 lvds_lane_1.i2.0 VSS nfet_03v3 ad=0.78p pd=3.52u as=0.78p ps=3.52u w=3u l=0.28u
X244 VSS lvds_lane_1.i2.0 RX1_O VSS nfet_03v3 ad=1.04p pd=4.52u as=1.04p ps=4.52u w=4u l=0.28u
X245 VDD lvds_lane_0.VBP.0 lvds_lane_0.tp.0 VDD pfet_03v3 ad=1.3p pd=5.52u as=1.3p ps=5.52u w=5u l=1u
X246 lvds_lane_0.fb.0 lvds_lane_0.gn.0 lvds_lane_0.tp.0 lvds_lane_0.tp.0 pfet_03v3 ad=1.248p pd=5.32u as=1.248p ps=5.32u w=4.8u l=0.4u
X247 lvds_lane_0.ob.0 lvds_lane_0.VREF.0 lvds_lane_0.tn.0 VSS nfet_03v3 ad=1.235p pd=5.27u as=1.235p ps=5.27u w=4.75u l=0.5u
X248 lvds_lane_1.tn.0 lvds_lane_1.gn.0 lvds_lane_1.ob.0 VSS nfet_03v3 ad=1.235p pd=5.27u as=1.235p ps=5.27u w=4.75u l=0.5u
X249 lvds_lane_2.tp.0 lvds_lane_0.VREF.0 lvds_lane_2.fb.0 lvds_lane_2.tp.0 pfet_03v3 ad=1.248p pd=5.32u as=1.248p ps=5.32u w=4.8u l=0.4u
X250 VDD lvds_lane_0.VBP.0 lvds_lane_0.tp.0 VDD pfet_03v3 ad=1.3p pd=5.52u as=1.3p ps=5.52u w=5u l=1u
X251 VDD lvds_lane_0.VBP.0 lvds_lane_1.tp.0 VDD pfet_03v3 ad=1.3p pd=5.52u as=1.3p ps=5.52u w=5u l=1u
X252 lvds_lane_1.oa.0 lvds_lane_0.VB2.0 lvds_lane_1.fa.0 VSS nfet_03v3 ad=1.1752p pd=5.04u as=1.1752p ps=5.04u w=4.52u l=0.5u
X253 lvds_lane_0.tn.0 VSS VSS VSS nfet_03v3 ad=0.65p pd=3.02u as=1.1p ps=5.88u w=2.5u l=1u
X254 VSS VSS VSS ppolyf_u_1k r_width=5u r_length=1.64u
X255 lvds_lane_2.ts.0 lvds_lane_0.VBN.0 VSS VSS nfet_03v3 ad=0.65p pd=3.02u as=0.65p ps=3.02u w=2.5u l=1u
X256 VSS VSS lvds_lane_1.fb.0 VSS nfet_03v3 ad=1.9888p pd=9.92u as=1.1752p ps=5.04u w=4.52u l=0.5u
X257 VDD lvds_lane_1.d3.0 lvds_lane_1.nd.0 VDD pfet_03v3 ad=0.78p pd=3.52u as=0.78p ps=3.52u w=3u l=0.28u
X258 VDD VDD VDD VDD pfet_03v3 ad=0.481p pd=2.37u as=0 ps=0 w=1.85u l=0.28u
X259 lvds_lane_0.tn.0 lvds_lane_0.gp.0 lvds_lane_0.oa.0 VSS nfet_03v3 ad=1.235p pd=5.27u as=1.235p ps=5.27u w=4.75u l=0.5u
X260 lvds_lane_0.ts.0 lvds_lane_0.VBN.0 VSS VSS nfet_03v3 ad=0.65p pd=3.02u as=0.65p ps=3.02u w=2.5u l=1u
X261 lvds_lane_1.oa.0 VSS VSS VSS nfet_03v3 ad=1.1752p pd=5.04u as=1.9888p ps=9.92u w=4.52u l=0.5u
X262 lvds_lane_2.d2b.0 lvds_lane_2.d2b.0 VDD VDD pfet_03v3 ad=0.481p pd=2.37u as=0.481p ps=2.37u w=1.85u l=0.28u
X263 lvds_lane_1.d2a.0 lvds_lane_1.d2b.0 VDD VDD pfet_03v3 ad=0.481p pd=2.37u as=0.481p ps=2.37u w=1.85u l=0.28u
X264 lvds_lane_2.tp.0 lvds_lane_0.VREF.0 lvds_lane_2.fb.0 lvds_lane_2.tp.0 pfet_03v3 ad=1.248p pd=5.32u as=1.248p ps=5.32u w=4.8u l=0.4u
X265 lvds_lane_1.ts.0 lvds_lane_0.VBN.0 VSS VSS nfet_03v3 ad=0.65p pd=3.02u as=0.65p ps=3.02u w=2.5u l=1u
X266 VDD lvds_lane_0.d2b.0 lvds_lane_0.d3.0 VDD pfet_03v3 ad=0.481p pd=2.37u as=0.481p ps=2.37u w=1.85u l=0.28u
X267 lvds_lane_1.tp.0 lvds_lane_1.gn.0 lvds_lane_1.fb.0 lvds_lane_1.tp.0 pfet_03v3 ad=1.248p pd=5.32u as=1.248p ps=5.32u w=4.8u l=0.4u
X268 lvds_lane_2.oa.0 lvds_lane_2.gp.0 lvds_lane_2.tn.0 VSS nfet_03v3 ad=1.235p pd=5.27u as=1.235p ps=5.27u w=4.75u l=0.5u
X269 RX1_O lvds_lane_1.i2.0 VDD VDD pfet_03v3 ad=1.3p pd=5.52u as=1.3p ps=5.52u w=5u l=0.28u
X270 lvds_lane_0.ts.0 lvds_lane_0.sb.0 VSS ppolyf_u_1k r_width=5u r_length=1.64u
X271 VSS lvds_lane_2.n3a.0 lvds_lane_2.n3a.0 VSS nfet_03v3 ad=1.2116p pd=5.18u as=1.2116p ps=5.18u w=4.66u l=0.28u
X272 lvds_lane_0.d2a.0 lvds_lane_0.d2b.0 VDD VDD pfet_03v3 ad=0.481p pd=2.37u as=0.481p ps=2.37u w=1.85u l=0.28u
X273 lvds_lane_0.tp.0 lvds_lane_0.VREF.0 lvds_lane_0.fa.0 lvds_lane_0.tp.0 pfet_03v3 ad=1.248p pd=5.32u as=1.248p ps=5.32u w=4.8u l=0.4u
X274 lvds_lane_2.fb.0 lvds_lane_0.VREF.0 lvds_lane_2.tp.0 lvds_lane_2.tp.0 pfet_03v3 ad=1.248p pd=5.32u as=1.248p ps=5.32u w=4.8u l=0.4u
X275 lvds_lane_0.fb.0 lvds_lane_0.VBN.0 VSS VSS nfet_03v3 ad=0.65p pd=3.02u as=0.65p ps=3.02u w=2.5u l=1u
X276 lvds_lane_2.ob.0 lvds_lane_0.VREF.0 lvds_lane_2.tn.0 VSS nfet_03v3 ad=1.235p pd=5.27u as=1.235p ps=5.27u w=4.75u l=0.5u
X277 lvds_lane_0.tp.0 lvds_lane_0.VBP.0 VDD VDD pfet_03v3 ad=1.3p pd=5.52u as=1.3p ps=5.52u w=5u l=1u
X278 lvds_lane_1.fa.0 lvds_lane_1.gp.0 lvds_lane_1.tp.0 lvds_lane_1.tp.0 pfet_03v3 ad=1.248p pd=5.32u as=1.248p ps=5.32u w=4.8u l=0.4u
X279 lvds_lane_0.fa.0 lvds_lane_0.gp.0 lvds_lane_0.tp.0 lvds_lane_0.tp.0 pfet_03v3 ad=1.248p pd=5.32u as=1.248p ps=5.32u w=4.8u l=0.4u
X280 lvds_lane_1.fa.0 lvds_lane_0.VBN.0 VSS VSS nfet_03v3 ad=0.65p pd=3.02u as=0.65p ps=3.02u w=2.5u l=1u
X281 lvds_lane_2.nd.0 VDD VDD VDD pfet_03v3 ad=0.78p pd=3.52u as=1.32p ps=6.88u w=3u l=0.28u
X282 VDD lvds_lane_1.d2a.0 lvds_lane_1.d2a.0 VDD pfet_03v3 ad=0.481p pd=2.37u as=0.481p ps=2.37u w=1.85u l=0.28u
X283 lvds_lane_2.tp.0 lvds_lane_0.VREF.0 lvds_lane_2.fa.0 lvds_lane_2.tp.0 pfet_03v3 ad=1.248p pd=5.32u as=1.248p ps=5.32u w=4.8u l=0.4u
X284 VSS lvds_lane_0.VBN.0 lvds_lane_0.fb.0 VSS nfet_03v3 ad=0.65p pd=3.02u as=0.65p ps=3.02u w=2.5u l=1u
X285 VDD lvds_lane_2.d2a.0 lvds_lane_2.n3a.0 VDD pfet_03v3 ad=0.481p pd=2.37u as=0.481p ps=2.37u w=1.85u l=0.28u
X286 lvds_lane_1.i2.0 VSS VSS VSS nfet_03v3 ad=0.78p pd=3.52u as=1.32p ps=6.88u w=3u l=0.28u
X287 RX1_O VSS VSS VSS nfet_03v3 ad=1.04p pd=4.52u as=1.76p ps=8.88u w=4u l=0.28u
X288 lvds_lane_0.tp.0 lvds_lane_0.gp.0 lvds_lane_0.fa.0 lvds_lane_0.tp.0 pfet_03v3 ad=1.248p pd=5.32u as=1.248p ps=5.32u w=4.8u l=0.4u
X289 VSS VSS VSS VSS nfet_03v3 ad=0.39p pd=2.02u as=0 ps=0 w=1.5u l=0.28u
X290 VDD VDD VDD VDD pfet_03v3 ad=0.814p pd=4.58u as=0 ps=0 w=1.85u l=0.28u
X291 lvds_lane_1.tp.0 lvds_lane_0.VBP.0 VDD VDD pfet_03v3 ad=1.3p pd=5.52u as=1.3p ps=5.52u w=5u l=1u
X292 VSS lvds_lane_0.VBN.0 lvds_lane_0.tn.0 VSS nfet_03v3 ad=0.65p pd=3.02u as=0.65p ps=3.02u w=2.5u l=1u
X293 VDD EN lvds_lane_0.VBP.0 VDD pfet_03v3 ad=0.52p pd=2.52u as=0.52p ps=2.52u w=2u l=0.5u
X294 lvds_lane_0.tp.0 lvds_lane_0.gn.0 lvds_lane_0.fb.0 lvds_lane_0.tp.0 pfet_03v3 ad=1.248p pd=5.32u as=1.248p ps=5.32u w=4.8u l=0.4u
X295 lvds_lane_0.tp.0 lvds_lane_0.gn.0 lvds_lane_0.fb.0 lvds_lane_0.tp.0 pfet_03v3 ad=1.248p pd=5.32u as=1.248p ps=5.32u w=4.8u l=0.4u
X296 VDD lvds_lane_1.d2a.0 lvds_lane_1.d2b.0 VDD pfet_03v3 ad=0.481p pd=2.37u as=0.481p ps=2.37u w=1.85u l=0.28u
X297 lvds_lane_2.ts.0 lvds_lane_0.VBN.0 VSS VSS nfet_03v3 ad=0.65p pd=3.02u as=0.65p ps=3.02u w=2.5u l=1u
X298 lvds_lane_1.fa.0 lvds_lane_0.VREF.0 lvds_lane_1.tp.0 lvds_lane_1.tp.0 pfet_03v3 ad=1.248p pd=5.32u as=1.248p ps=5.32u w=4.8u l=0.4u
X299 lvds_lane_2.fa.0 lvds_lane_0.VREF.0 lvds_lane_2.tp.0 lvds_lane_2.tp.0 pfet_03v3 ad=1.248p pd=5.32u as=1.248p ps=5.32u w=4.8u l=0.4u
X300 lvds_bias_0.nmid.0 EN VSS VSS nfet_03v3 ad=1.3p pd=5.52u as=1.3p ps=5.52u w=5u l=0.5u
X301 lvds_lane_2.fb.0 lvds_lane_0.VBN.0 VSS VSS nfet_03v3 ad=0.65p pd=3.02u as=0.65p ps=3.02u w=2.5u l=1u
X302 VSS lvds_lane_0.VBN.0 lvds_lane_1.tn.0 VSS nfet_03v3 ad=0.65p pd=3.02u as=0.65p ps=3.02u w=2.5u l=1u
X303 VSS VSS VSS VSS nfet_03v3 ad=0.78p pd=3.52u as=0 ps=0 w=3u l=0.28u
X304 VSS lvds_lane_0.VBN.0 lvds_lane_0.VBP.0 VSS nfet_03v3 ad=0.65p pd=3.02u as=0.65p ps=3.02u w=2.5u l=1u
X305 lvds_lane_0.d3.0 lvds_lane_0.d2b.0 VDD VDD pfet_03v3 ad=0.481p pd=2.37u as=0.481p ps=2.37u w=1.85u l=0.28u
X306 lvds_lane_2.d2b.0 lvds_lane_2.ob.0 lvds_lane_2.sb.0 VSS nfet_03v3 ad=1.1362p pd=4.89u as=1.1362p ps=4.89u w=4.37u l=0.5u
X307 lvds_lane_0.fb.0 lvds_lane_0.gn.0 lvds_lane_0.tp.0 lvds_lane_0.tp.0 pfet_03v3 ad=1.248p pd=5.32u as=1.248p ps=5.32u w=4.8u l=0.4u
X308 lvds_lane_2.tp.0 lvds_lane_0.VREF.0 lvds_lane_2.fa.0 lvds_lane_2.tp.0 pfet_03v3 ad=1.248p pd=5.32u as=1.248p ps=5.32u w=4.8u l=0.4u
X309 lvds_lane_1.ob.0 lvds_lane_0.VREF.0 lvds_lane_1.tn.0 VSS nfet_03v3 ad=2.09p pd=10.38u as=1.235p ps=5.27u w=4.75u l=0.5u
X310 VDD lvds_bias_0.rdt_m1.0 VSS ppolyf_u_1k r_width=2u r_length=21.01u
X311 lvds_lane_2.fa.0 lvds_lane_0.VBN.0 VSS VSS nfet_03v3 ad=0.65p pd=3.02u as=0.65p ps=3.02u w=2.5u l=1u
X312 VSS lvds_lane_0.VBN.0 lvds_lane_1.ts.0 VSS nfet_03v3 ad=0.65p pd=3.02u as=0.65p ps=3.02u w=2.5u l=1u
X313 lvds_bias_0.nmid.0 VSS VSS VSS nfet_03v3 ad=1.3p pd=5.52u as=2.2p ps=10.88u w=5u l=0.5u
X314 lvds_lane_0.sb.0 lvds_lane_0.ob.0 lvds_lane_0.d2b.0 VSS nfet_03v3 ad=1.1362p pd=4.89u as=1.1362p ps=4.89u w=4.37u l=0.5u
X315 VSS VSS lvds_lane_0.d2a.0 VSS nfet_03v3 ad=1.9228p pd=9.62u as=1.1362p ps=4.89u w=4.37u l=0.5u
X316 lvds_lane_2.fa.0 lvds_lane_0.VREF.0 lvds_lane_2.tp.0 lvds_lane_2.tp.0 pfet_03v3 ad=1.248p pd=5.32u as=1.248p ps=5.32u w=4.8u l=0.4u
X317 VDD lvds_lane_1.i2.0 RX1_O VDD pfet_03v3 ad=1.3p pd=5.52u as=1.3p ps=5.52u w=5u l=0.28u
X318 lvds_lane_2.fb.0 lvds_lane_0.VB2.0 lvds_lane_2.ob.0 VSS nfet_03v3 ad=1.1752p pd=5.04u as=1.1752p ps=5.04u w=4.52u l=0.5u
X319 lvds_lane_0.d2a.0 lvds_lane_0.d2b.0 VDD VDD pfet_03v3 ad=0.481p pd=2.37u as=0.481p ps=2.37u w=1.85u l=0.28u
X320 lvds_lane_0.oa.0 lvds_lane_0.VREF.0 lvds_lane_0.tn.0 VSS nfet_03v3 ad=1.235p pd=5.27u as=1.235p ps=5.27u w=4.75u l=0.5u
X321 lvds_lane_1.n3a.0 VDD VDD VDD pfet_03v3 ad=0.481p pd=2.37u as=0.814p ps=4.58u w=1.85u l=0.28u
X322 lvds_lane_2.fa.0 lvds_lane_0.VREF.0 lvds_lane_2.tp.0 lvds_lane_2.tp.0 pfet_03v3 ad=1.248p pd=5.32u as=1.248p ps=5.32u w=4.8u l=0.4u
X323 lvds_lane_2.oa.0 lvds_lane_0.VB2.0 lvds_lane_2.fa.0 VSS nfet_03v3 ad=1.1752p pd=5.04u as=1.1752p ps=5.04u w=4.52u l=0.5u
X324 VDD VDD lvds_lane_2.nd.0 VDD pfet_03v3 ad=1.32p pd=6.88u as=0.78p ps=3.52u w=3u l=0.28u
X325 lvds_lane_2.d2b.0 lvds_lane_2.d2a.0 VDD VDD pfet_03v3 ad=0.481p pd=2.37u as=0.481p ps=2.37u w=1.85u l=0.28u
X326 VDD lvds_lane_0.VBP.0 lvds_lane_0.tp.0 VDD pfet_03v3 ad=1.3p pd=5.52u as=1.3p ps=5.52u w=5u l=1u
X327 lvds_lane_0.fb.0 lvds_lane_0.gn.0 lvds_lane_0.tp.0 lvds_lane_0.tp.0 pfet_03v3 ad=1.248p pd=5.32u as=1.248p ps=5.32u w=4.8u l=0.4u
X328 lvds_lane_1.fb.0 lvds_lane_1.gn.0 lvds_lane_1.tp.0 lvds_lane_1.tp.0 pfet_03v3 ad=1.248p pd=5.32u as=1.248p ps=5.32u w=4.8u l=0.4u
X329 lvds_lane_2.fb.0 lvds_lane_0.VB2.0 lvds_lane_2.ob.0 VSS nfet_03v3 ad=1.1752p pd=5.04u as=1.1752p ps=5.04u w=4.52u l=0.5u
X330 VSS lvds_lane_0.VBN.0 lvds_lane_1.fa.0 VSS nfet_03v3 ad=0.65p pd=3.02u as=0.65p ps=3.02u w=2.5u l=1u
X331 lvds_lane_0.ob.0 lvds_lane_0.VREF.0 lvds_lane_0.tn.0 VSS nfet_03v3 ad=1.235p pd=5.27u as=1.235p ps=5.27u w=4.75u l=0.5u
X332 lvds_lane_1.ts.0 lvds_lane_0.VBN.0 VSS VSS nfet_03v3 ad=0.65p pd=3.02u as=0.65p ps=3.02u w=2.5u l=1u
X333 VSS VSS VSS ppolyf_u_1k r_width=5u r_length=1.64u
X334 VDD lvds_lane_2.i1.0 lvds_lane_2.i2.0 VDD pfet_03v3 ad=0.975p pd=4.27u as=0.975p ps=4.27u w=3.75u l=0.28u
X335 VSS VSS VSS ppolyf_u_1k r_width=2u r_length=21.01u
X336 lvds_bias_0.rdb_m2.0 lvds_bias_0.rdb_m3.0 VSS ppolyf_u_1k r_width=2u r_length=19.26u
X337 lvds_lane_2.tp.0 lvds_lane_0.VREF.0 lvds_lane_2.fb.0 lvds_lane_2.tp.0 pfet_03v3 ad=1.248p pd=5.32u as=1.248p ps=5.32u w=4.8u l=0.4u
X338 lvds_lane_0.ob.0 lvds_lane_0.VB2.0 lvds_lane_0.fb.0 VSS nfet_03v3 ad=1.1752p pd=5.04u as=1.1752p ps=5.04u w=4.52u l=0.5u
X339 VSS lvds_lane_0.VBN.0 lvds_lane_2.fb.0 VSS nfet_03v3 ad=0.65p pd=3.02u as=0.65p ps=3.02u w=2.5u l=1u
X340 VDD lvds_lane_1.d2a.0 lvds_lane_1.n3a.0 VDD pfet_03v3 ad=0.481p pd=2.37u as=0.481p ps=2.37u w=1.85u l=0.28u
X341 lvds_lane_0.d2b.0 lvds_lane_0.d2b.0 VDD VDD pfet_03v3 ad=0.481p pd=2.37u as=0.481p ps=2.37u w=1.85u l=0.28u
X342 lvds_lane_1.fb.0 lvds_lane_0.VREF.0 lvds_lane_1.tp.0 lvds_lane_1.tp.0 pfet_03v3 ad=2.112p pd=10.48u as=1.248p ps=5.32u w=4.8u l=0.4u
X343 VSS lvds_lane_0.VBN.0 lvds_lane_0.fa.0 VSS nfet_03v3 ad=0.65p pd=3.02u as=0.65p ps=3.02u w=2.5u l=1u
X344 lvds_lane_1.oa.0 lvds_lane_1.gp.0 lvds_lane_1.tn.0 VSS nfet_03v3 ad=1.235p pd=5.27u as=1.235p ps=5.27u w=4.75u l=0.5u
X345 lvds_lane_2.tn.0 lvds_lane_0.VREF.0 lvds_lane_2.oa.0 VSS nfet_03v3 ad=1.235p pd=5.27u as=1.235p ps=5.27u w=4.75u l=0.5u
X346 lvds_lane_2.ob.0 lvds_lane_2.rlb_m1.0 VSS ppolyf_u_1k r_width=2u r_length=9.11u
X347 lvds_lane_0.tp.0 lvds_lane_0.gn.0 lvds_lane_0.fb.0 lvds_lane_0.tp.0 pfet_03v3 ad=1.248p pd=5.32u as=1.248p ps=5.32u w=4.8u l=0.4u
X348 lvds_lane_0.oa.0 lvds_lane_0.VREF.0 lvds_lane_0.tn.0 VSS nfet_03v3 ad=1.235p pd=5.27u as=1.235p ps=5.27u w=4.75u l=0.5u
X349 VSS VSS VSS ppolyf_u_1k r_width=2u r_length=23.07u
X350 lvds_lane_0.ob.0 lvds_lane_0.VB2.0 lvds_lane_0.fb.0 VSS nfet_03v3 ad=1.1752p pd=5.04u as=1.1752p ps=5.04u w=4.52u l=0.5u
X351 lvds_lane_0.tp.0 lvds_lane_0.VBP.0 VDD VDD pfet_03v3 ad=1.3p pd=5.52u as=1.3p ps=5.52u w=5u l=1u
X352 lvds_lane_1.fb.0 lvds_lane_0.VREF.0 lvds_lane_1.tp.0 lvds_lane_1.tp.0 pfet_03v3 ad=1.248p pd=5.32u as=1.248p ps=5.32u w=4.8u l=0.4u
X353 lvds_lane_1.tn.0 lvds_lane_0.VBN.0 VSS VSS nfet_03v3 ad=0.65p pd=3.02u as=0.65p ps=3.02u w=2.5u l=1u
X354 lvds_lane_1.ob.0 lvds_lane_1.gn.0 lvds_lane_1.tn.0 VSS nfet_03v3 ad=1.235p pd=5.27u as=1.235p ps=5.27u w=4.75u l=0.5u
X355 lvds_lane_1.tp.0 lvds_lane_0.VBP.0 VDD VDD pfet_03v3 ad=1.3p pd=5.52u as=1.3p ps=5.52u w=5u l=1u
X356 VSS VSS lvds_lane_1.d2b.0 VSS nfet_03v3 ad=1.9228p pd=9.62u as=1.1362p ps=4.89u w=4.37u l=0.5u
X357 VDD lvds_lane_0.VBP.0 lvds_lane_0.VBP.0 VDD pfet_03v3 ad=1.3p pd=5.52u as=1.3p ps=5.52u w=5u l=1u
X358 lvds_lane_0.fa.0 lvds_lane_0.gp.0 lvds_lane_0.tp.0 lvds_lane_0.tp.0 pfet_03v3 ad=1.248p pd=5.32u as=1.248p ps=5.32u w=4.8u l=0.4u
X359 lvds_lane_0.ob.0 VSS VSS VSS nfet_03v3 ad=1.1752p pd=5.04u as=1.9888p ps=9.92u w=4.52u l=0.5u
X360 lvds_lane_2.fa.0 VSS VSS VSS nfet_03v3 ad=0.65p pd=3.02u as=1.1p ps=5.88u w=2.5u l=1u
X361 lvds_lane_0.tp.0 lvds_lane_0.VREF.0 lvds_lane_0.fa.0 lvds_lane_0.tp.0 pfet_03v3 ad=1.248p pd=5.32u as=1.248p ps=5.32u w=4.8u l=0.4u
X362 lvds_lane_1.fb.0 lvds_lane_1.gn.0 lvds_lane_1.tp.0 lvds_lane_1.tp.0 pfet_03v3 ad=1.248p pd=5.32u as=1.248p ps=5.32u w=4.8u l=0.4u
X363 lvds_lane_2.tn.0 lvds_lane_0.VBN.0 VSS VSS nfet_03v3 ad=0.65p pd=3.02u as=0.65p ps=3.02u w=2.5u l=1u
X364 VSS lvds_lane_0.i2.0 RX0_O VSS nfet_03v3 ad=1.04p pd=4.52u as=1.04p ps=4.52u w=4u l=0.28u
X365 VSS lvds_lane_0.i1.0 lvds_lane_0.i2.0 VSS nfet_03v3 ad=0.78p pd=3.52u as=0.78p ps=3.52u w=3u l=0.28u
X366 lvds_lane_2.gp.0 RX2_P VDD ppolyf_u r_width=5u r_length=1.8u
X367 lvds_lane_2.fb.0 lvds_lane_0.VBN.0 VSS VSS nfet_03v3 ad=0.65p pd=3.02u as=0.65p ps=3.02u w=2.5u l=1u
X368 lvds_lane_1.ob.0 lvds_lane_0.VREF.0 lvds_lane_1.tn.0 VSS nfet_03v3 ad=1.235p pd=5.27u as=1.235p ps=5.27u w=4.75u l=0.5u
X369 VSS lvds_lane_0.VBN.0 lvds_lane_1.ts.0 VSS nfet_03v3 ad=0.65p pd=3.02u as=0.65p ps=3.02u w=2.5u l=1u
X370 lvds_bias_0.nrb.0 lvds_bias_0.enb.0 VDD VDD pfet_03v3 ad=1.3p pd=5.52u as=1.3p ps=5.52u w=5u l=0.5u
X371 lvds_lane_2.fb.0 lvds_lane_0.VREF.0 lvds_lane_2.tp.0 lvds_lane_2.tp.0 pfet_03v3 ad=1.248p pd=5.32u as=1.248p ps=5.32u w=4.8u l=0.4u
X372 VDD lvds_lane_2.d2a.0 lvds_lane_2.d2b.0 VDD pfet_03v3 ad=0.481p pd=2.37u as=0.481p ps=2.37u w=1.85u l=0.28u
X373 lvds_lane_2.d2a.0 VSS VSS VSS nfet_03v3 ad=1.1362p pd=4.89u as=1.9228p ps=9.62u w=4.37u l=0.5u
X374 VDD lvds_lane_2.d2b.0 lvds_lane_2.d2a.0 VDD pfet_03v3 ad=0.481p pd=2.37u as=0.481p ps=2.37u w=1.85u l=0.28u
X375 VDD VDD VDD VDD pfet_03v3 ad=0.52p pd=2.52u as=0 ps=0 w=2u l=0.5u
X376 VDD EN lvds_lane_0.d2a.0 VDD pfet_03v3 ad=0.52p pd=2.52u as=0.52p ps=2.52u w=2u l=0.5u
X377 lvds_lane_0.n3a.0 lvds_lane_0.d2a.0 VDD VDD pfet_03v3 ad=0.481p pd=2.37u as=0.481p ps=2.37u w=1.85u l=0.28u
X378 lvds_bias_0.nrb.0 lvds_bias_0.enb.0 VDD VDD pfet_03v3 ad=1.3p pd=5.52u as=1.3p ps=5.52u w=5u l=0.5u
X379 lvds_lane_2.tn.0 lvds_lane_0.VREF.0 lvds_lane_2.oa.0 VSS nfet_03v3 ad=1.235p pd=5.27u as=1.235p ps=5.27u w=4.75u l=0.5u
X380 VDD lvds_lane_0.VBP.0 lvds_lane_0.tp.0 VDD pfet_03v3 ad=1.3p pd=5.52u as=1.3p ps=5.52u w=5u l=1u
X381 lvds_lane_1.fb.0 lvds_lane_0.VREF.0 lvds_lane_1.tp.0 lvds_lane_1.tp.0 pfet_03v3 ad=1.248p pd=5.32u as=1.248p ps=5.32u w=4.8u l=0.4u
X382 VSS lvds_lane_0.VBN.0 lvds_lane_1.ts.0 VSS nfet_03v3 ad=0.65p pd=3.02u as=0.65p ps=3.02u w=2.5u l=1u
X383 VSS lvds_lane_2.i1.0 lvds_lane_2.i2.0 VSS nfet_03v3 ad=0.78p pd=3.52u as=0.78p ps=3.52u w=3u l=0.28u
X384 VSS lvds_lane_2.i2.0 RX2_O VSS nfet_03v3 ad=1.04p pd=4.52u as=1.04p ps=4.52u w=4u l=0.28u
X385 VSS VSS VSS ppolyf_u_1k r_width=2u r_length=9.11u
X386 lvds_lane_2.tp.0 lvds_lane_0.VBP.0 VDD VDD pfet_03v3 ad=1.3p pd=5.52u as=1.3p ps=5.52u w=5u l=1u
X387 lvds_lane_1.tn.0 lvds_lane_1.gn.0 lvds_lane_1.ob.0 VSS nfet_03v3 ad=1.235p pd=5.27u as=1.235p ps=5.27u w=4.75u l=0.5u
X388 lvds_lane_2.d2a.0 VDD VDD VDD pfet_03v3 ad=0.52p pd=2.52u as=0.88p ps=4.88u w=2u l=0.5u
X389 lvds_lane_0.tp.0 lvds_lane_0.gn.0 lvds_lane_0.fb.0 lvds_lane_0.tp.0 pfet_03v3 ad=1.248p pd=5.32u as=1.248p ps=5.32u w=4.8u l=0.4u
X390 lvds_lane_2.fb.0 lvds_lane_2.gn.0 lvds_lane_2.tp.0 lvds_lane_2.tp.0 pfet_03v3 ad=1.248p pd=5.32u as=1.248p ps=5.32u w=4.8u l=0.4u
X391 lvds_lane_2.fa.0 lvds_lane_0.VBN.0 VSS VSS nfet_03v3 ad=0.65p pd=3.02u as=0.65p ps=3.02u w=2.5u l=1u
X392 lvds_bias_0.nrb.0 lvds_bias_0.enb.0 VDD VDD pfet_03v3 ad=1.3p pd=5.52u as=1.3p ps=5.52u w=5u l=0.5u
X393 RX0_O lvds_lane_0.i2.0 VDD VDD pfet_03v3 ad=1.3p pd=5.52u as=1.3p ps=5.52u w=5u l=0.28u
X394 lvds_lane_2.tn.0 lvds_lane_0.VREF.0 lvds_lane_2.ob.0 VSS nfet_03v3 ad=1.235p pd=5.27u as=1.235p ps=5.27u w=4.75u l=0.5u
X395 lvds_lane_1.fa.0 lvds_lane_0.VREF.0 lvds_lane_1.tp.0 lvds_lane_1.tp.0 pfet_03v3 ad=1.248p pd=5.32u as=1.248p ps=5.32u w=4.8u l=0.4u
X396 lvds_lane_2.tp.0 lvds_lane_2.gp.0 lvds_lane_2.fa.0 lvds_lane_2.tp.0 pfet_03v3 ad=1.248p pd=5.32u as=1.248p ps=5.32u w=4.8u l=0.4u
X397 lvds_lane_0.fb.0 lvds_lane_0.VBN.0 VSS VSS nfet_03v3 ad=0.65p pd=3.02u as=0.65p ps=3.02u w=2.5u l=1u
X398 lvds_lane_0.d2b.0 VDD VDD VDD pfet_03v3 ad=0.52p pd=2.52u as=0.88p ps=4.88u w=2u l=0.5u
X399 lvds_lane_1.tn.0 lvds_lane_1.gp.0 lvds_lane_1.oa.0 VSS nfet_03v3 ad=1.235p pd=5.27u as=1.235p ps=5.27u w=4.75u l=0.5u
X400 lvds_lane_2.d3.0 lvds_lane_2.d2b.0 VDD VDD pfet_03v3 ad=0.481p pd=2.37u as=0.481p ps=2.37u w=1.85u l=0.28u
X401 VSS VSS lvds_lane_1.fa.0 VSS nfet_03v3 ad=1.9888p pd=9.92u as=1.1752p ps=5.04u w=4.52u l=0.5u
X402 VDD lvds_lane_1.nd.0 lvds_lane_1.i1.0 VDD pfet_03v3 ad=0.962p pd=4.22u as=0.962p ps=4.22u w=3.7u l=0.28u
X403 VDD lvds_lane_0.VBP.0 lvds_lane_1.tp.0 VDD pfet_03v3 ad=1.3p pd=5.52u as=1.3p ps=5.52u w=5u l=1u
D4 lvds_lane_1.gn.0 VDD diode_pd2nw_03v3 pj=26u area=40p
X404 lvds_lane_0.fb.0 lvds_lane_0.gn.0 lvds_lane_0.tp.0 lvds_lane_0.tp.0 pfet_03v3 ad=1.248p pd=5.32u as=1.248p ps=5.32u w=4.8u l=0.4u
X405 lvds_lane_0.oa.0 lvds_lane_0.VREF.0 lvds_lane_0.tn.0 VSS nfet_03v3 ad=1.235p pd=5.27u as=1.235p ps=5.27u w=4.75u l=0.5u
X406 lvds_lane_1.tp.0 lvds_lane_0.VREF.0 lvds_lane_1.fb.0 lvds_lane_1.tp.0 pfet_03v3 ad=1.248p pd=5.32u as=1.248p ps=5.32u w=4.8u l=0.4u
X407 VSS lvds_lane_0.VBN.0 lvds_lane_2.fa.0 VSS nfet_03v3 ad=0.65p pd=3.02u as=0.65p ps=3.02u w=2.5u l=1u
X408 VSS VSS lvds_lane_2.tn.0 VSS nfet_03v3 ad=1.1p pd=5.88u as=0.65p ps=3.02u w=2.5u l=1u
X409 RX2_O lvds_lane_2.i2.0 VDD VDD pfet_03v3 ad=1.3p pd=5.52u as=1.3p ps=5.52u w=5u l=0.28u
X410 lvds_lane_2.gn.0 RX2_N VDD ppolyf_u r_width=5u r_length=1.8u
X411 lvds_lane_1.fa.0 lvds_lane_1.gp.0 lvds_lane_1.tp.0 lvds_lane_1.tp.0 pfet_03v3 ad=1.248p pd=5.32u as=1.248p ps=5.32u w=4.8u l=0.4u
X412 lvds_lane_1.oa.0 lvds_lane_0.VB2.0 lvds_lane_1.fa.0 VSS nfet_03v3 ad=1.1752p pd=5.04u as=1.1752p ps=5.04u w=4.52u l=0.5u
X413 lvds_lane_0.i2.0 VSS VSS VSS nfet_03v3 ad=0.78p pd=3.52u as=1.32p ps=6.88u w=3u l=0.28u
X414 VSS lvds_lane_0.VBN.0 lvds_lane_2.fb.0 VSS nfet_03v3 ad=0.65p pd=3.02u as=0.65p ps=3.02u w=2.5u l=1u
X415 RX0_O VSS VSS VSS nfet_03v3 ad=1.04p pd=4.52u as=1.76p ps=8.88u w=4u l=0.28u
X416 lvds_lane_0.fb.0 lvds_lane_0.VREF.0 lvds_lane_0.tp.0 lvds_lane_0.tp.0 pfet_03v3 ad=1.248p pd=5.32u as=1.248p ps=5.32u w=4.8u l=0.4u
X417 lvds_lane_2.ob.0 lvds_lane_2.gn.0 lvds_lane_2.tn.0 VSS nfet_03v3 ad=1.235p pd=5.27u as=1.235p ps=5.27u w=4.75u l=0.5u
X418 VSS VSS VSS VSS nfet_03v3 ad=0.39p pd=2.02u as=0 ps=0 w=1.5u l=0.28u
X419 lvds_lane_2.tp.0 lvds_lane_2.gn.0 lvds_lane_2.fb.0 lvds_lane_2.tp.0 pfet_03v3 ad=1.248p pd=5.32u as=1.248p ps=5.32u w=4.8u l=0.4u
X420 lvds_lane_0.i2.0 VDD VDD VDD pfet_03v3 ad=0.975p pd=4.27u as=1.65p ps=8.38u w=3.75u l=0.28u
X421 lvds_lane_1.tp.0 lvds_lane_1.gp.0 lvds_lane_1.fa.0 lvds_lane_1.tp.0 pfet_03v3 ad=1.248p pd=5.32u as=1.248p ps=5.32u w=4.8u l=0.4u
X422 VSS VSS VSS VSS nfet_03v3 ad=0.78p pd=3.52u as=0 ps=0 w=3u l=0.28u
X423 lvds_lane_2.i1.0 VDD VDD VDD pfet_03v3 ad=0.962p pd=4.22u as=1.628p ps=8.28u w=3.7u l=0.28u
D5 VSS lvds_lane_1.gn.0 diode_nd2ps_03v3 pj=26u area=40p
X424 lvds_lane_2.i2.0 VSS VSS VSS nfet_03v3 ad=0.78p pd=3.52u as=1.32p ps=6.88u w=3u l=0.28u
X425 RX2_O VSS VSS VSS nfet_03v3 ad=1.04p pd=4.52u as=1.76p ps=8.88u w=4u l=0.28u
X426 lvds_lane_0.VBP.0 lvds_lane_0.VBN.0 VSS VSS nfet_03v3 ad=0.65p pd=3.02u as=0.65p ps=3.02u w=2.5u l=1u
X427 VDD lvds_lane_0.i2.0 RX0_O VDD pfet_03v3 ad=1.3p pd=5.52u as=1.3p ps=5.52u w=5u l=0.28u
X428 lvds_lane_2.tp.0 lvds_lane_0.VBP.0 VDD VDD pfet_03v3 ad=1.3p pd=5.52u as=1.3p ps=5.52u w=5u l=1u
X429 lvds_lane_0.fb.0 lvds_lane_0.gn.0 lvds_lane_0.tp.0 lvds_lane_0.tp.0 pfet_03v3 ad=1.248p pd=5.32u as=1.248p ps=5.32u w=4.8u l=0.4u
X430 lvds_lane_2.fb.0 lvds_lane_0.VBN.0 VSS VSS nfet_03v3 ad=0.65p pd=3.02u as=0.65p ps=3.02u w=2.5u l=1u
X431 lvds_lane_2.oa.0 lvds_lane_0.VREF.0 lvds_lane_2.tn.0 VSS nfet_03v3 ad=1.235p pd=5.27u as=1.235p ps=5.27u w=4.75u l=0.5u
X432 VDD VDD lvds_lane_0.tp.0 VDD pfet_03v3 ad=2.2p pd=10.88u as=1.3p ps=5.52u w=5u l=1u
X433 lvds_lane_0.tp.0 lvds_lane_0.VREF.0 lvds_lane_0.fa.0 lvds_lane_0.tp.0 pfet_03v3 ad=1.248p pd=5.32u as=1.248p ps=5.32u w=4.8u l=0.4u
X434 VSS lvds_lane_0.VBN.0 lvds_lane_1.fa.0 VSS nfet_03v3 ad=0.65p pd=3.02u as=0.65p ps=3.02u w=2.5u l=1u
X435 lvds_lane_2.fb.0 lvds_lane_2.gn.0 lvds_lane_2.tp.0 lvds_lane_2.tp.0 pfet_03v3 ad=1.248p pd=5.32u as=1.248p ps=5.32u w=4.8u l=0.4u
X436 VSS VSS VSS VSS nfet_03v3 ad=0.78p pd=3.52u as=0 ps=0 w=3u l=0.28u
X437 lvds_lane_2.fb.0 lvds_lane_0.VREF.0 lvds_lane_2.tp.0 lvds_lane_2.tp.0 pfet_03v3 ad=1.248p pd=5.32u as=1.248p ps=5.32u w=4.8u l=0.4u
X438 lvds_lane_2.ob.0 lvds_lane_2.gn.0 lvds_lane_2.tn.0 VSS nfet_03v3 ad=1.235p pd=5.27u as=1.235p ps=5.27u w=4.75u l=0.5u
X439 lvds_lane_0.VBP.0 lvds_lane_0.VBP.0 VDD VDD pfet_03v3 ad=1.3p pd=5.52u as=1.3p ps=5.52u w=5u l=1u
X440 lvds_lane_0.tp.0 lvds_lane_0.VREF.0 lvds_lane_0.fa.0 lvds_lane_0.tp.0 pfet_03v3 ad=1.248p pd=5.32u as=1.248p ps=5.32u w=4.8u l=0.4u
X441 lvds_lane_2.tp.0 lvds_lane_0.VBP.0 VDD VDD pfet_03v3 ad=1.3p pd=5.52u as=1.3p ps=5.52u w=5u l=1u
X442 lvds_lane_1.fb.0 lvds_lane_1.gn.0 lvds_lane_1.tp.0 lvds_lane_1.tp.0 pfet_03v3 ad=1.248p pd=5.32u as=1.248p ps=5.32u w=4.8u l=0.4u
X443 VDD lvds_lane_2.i2.0 RX2_O VDD pfet_03v3 ad=1.3p pd=5.52u as=1.3p ps=5.52u w=5u l=0.28u
X444 VSS lvds_lane_0.VBN.0 lvds_lane_2.tn.0 VSS nfet_03v3 ad=0.65p pd=3.02u as=0.65p ps=3.02u w=2.5u l=1u
X445 lvds_lane_2.oa.0 lvds_lane_2.gp.0 lvds_lane_2.tn.0 VSS nfet_03v3 ad=1.235p pd=5.27u as=1.235p ps=5.27u w=4.75u l=0.5u
X446 lvds_lane_0.fa.0 lvds_lane_0.VREF.0 lvds_lane_0.tp.0 lvds_lane_0.tp.0 pfet_03v3 ad=1.248p pd=5.32u as=1.248p ps=5.32u w=4.8u l=0.4u
X447 lvds_lane_1.tp.0 lvds_lane_1.gp.0 lvds_lane_1.fa.0 lvds_lane_1.tp.0 pfet_03v3 ad=1.248p pd=5.32u as=1.248p ps=5.32u w=4.8u l=0.4u
X448 lvds_lane_1.tp.0 lvds_lane_1.gp.0 lvds_lane_1.fa.0 lvds_lane_1.tp.0 pfet_03v3 ad=1.248p pd=5.32u as=1.248p ps=5.32u w=4.8u l=0.4u
X449 lvds_lane_2.tp.0 lvds_lane_0.VREF.0 lvds_lane_2.fa.0 lvds_lane_2.tp.0 pfet_03v3 ad=1.248p pd=5.32u as=1.248p ps=5.32u w=4.8u l=0.4u
X450 lvds_lane_2.d2b.0 VSS VSS VSS nfet_03v3 ad=1.1362p pd=4.89u as=1.9228p ps=9.62u w=4.37u l=0.5u
X451 lvds_lane_0.tn.0 lvds_lane_0.gp.0 lvds_lane_0.oa.0 VSS nfet_03v3 ad=1.235p pd=5.27u as=1.235p ps=5.27u w=4.75u l=0.5u
X452 lvds_lane_0.tp.0 lvds_lane_0.gn.0 lvds_lane_0.fb.0 lvds_lane_0.tp.0 pfet_03v3 ad=1.248p pd=5.32u as=1.248p ps=5.32u w=4.8u l=0.4u
X453 lvds_lane_1.fa.0 lvds_lane_1.gp.0 lvds_lane_1.tp.0 lvds_lane_1.tp.0 pfet_03v3 ad=1.248p pd=5.32u as=1.248p ps=5.32u w=4.8u l=0.4u
X454 lvds_bias_0.nmid.0 lvds_bias_0.rdb_m3.0 VSS ppolyf_u_1k r_width=2u r_length=19.26u
X455 lvds_lane_0.sa.0 lvds_lane_0.oa.0 lvds_lane_0.d2a.0 VSS nfet_03v3 ad=1.1362p pd=4.89u as=1.1362p ps=4.89u w=4.37u l=0.5u
X456 VSS VSS lvds_lane_1.ts.0 VSS nfet_03v3 ad=1.1p pd=5.88u as=0.65p ps=3.02u w=2.5u l=1u
X457 VSS VSS VSS ppolyf_u_1k r_width=2u r_length=22.27u
X458 lvds_lane_0.n3a.0 lvds_lane_0.d2a.0 VDD VDD pfet_03v3 ad=0.481p pd=2.37u as=0.481p ps=2.37u w=1.85u l=0.28u
X459 lvds_lane_0.tn.0 lvds_lane_0.gp.0 lvds_lane_0.oa.0 VSS nfet_03v3 ad=1.235p pd=5.27u as=1.235p ps=5.27u w=4.75u l=0.5u
X460 VDD EN lvds_lane_1.d2b.0 VDD pfet_03v3 ad=0.52p pd=2.52u as=0.52p ps=2.52u w=2u l=0.5u
X461 VDD lvds_lane_1.d2a.0 lvds_lane_1.d2b.0 VDD pfet_03v3 ad=0.481p pd=2.37u as=0.481p ps=2.37u w=1.85u l=0.28u
X462 VDD lvds_lane_0.VBP.0 lvds_lane_2.tp.0 VDD pfet_03v3 ad=1.3p pd=5.52u as=1.3p ps=5.52u w=5u l=1u
X463 lvds_lane_0.fa.0 lvds_lane_0.gp.0 lvds_lane_0.tp.0 lvds_lane_0.tp.0 pfet_03v3 ad=1.248p pd=5.32u as=1.248p ps=5.32u w=4.8u l=0.4u
X464 VSS VSS lvds_lane_0.fa.0 VSS nfet_03v3 ad=1.1p pd=5.88u as=0.65p ps=3.02u w=2.5u l=1u
X465 lvds_lane_2.fb.0 lvds_lane_0.VB2.0 lvds_lane_2.ob.0 VSS nfet_03v3 ad=1.1752p pd=5.04u as=1.1752p ps=5.04u w=4.52u l=0.5u
X466 lvds_lane_1.i2.0 lvds_lane_1.i1.0 VDD VDD pfet_03v3 ad=0.975p pd=4.27u as=0.975p ps=4.27u w=3.75u l=0.28u
X467 lvds_lane_1.tp.0 lvds_lane_0.VREF.0 lvds_lane_1.fb.0 lvds_lane_1.tp.0 pfet_03v3 ad=1.248p pd=5.32u as=1.248p ps=5.32u w=4.8u l=0.4u
X468 lvds_lane_0.tn.0 lvds_lane_0.gn.0 lvds_lane_0.ob.0 VSS nfet_03v3 ad=1.235p pd=5.27u as=1.235p ps=5.27u w=4.75u l=0.5u
X469 VDD lvds_lane_0.VBP.0 lvds_lane_0.tp.0 VDD pfet_03v3 ad=1.3p pd=5.52u as=1.3p ps=5.52u w=5u l=1u
X470 lvds_lane_2.fa.0 lvds_lane_2.gp.0 lvds_lane_2.tp.0 lvds_lane_2.tp.0 pfet_03v3 ad=1.248p pd=5.32u as=1.248p ps=5.32u w=4.8u l=0.4u
X471 lvds_lane_0.oa.0 lvds_lane_0.VB2.0 lvds_lane_0.fa.0 VSS nfet_03v3 ad=1.1752p pd=5.04u as=1.1752p ps=5.04u w=4.52u l=0.5u
X472 VSS VSS lvds_lane_0.fb.0 VSS nfet_03v3 ad=1.9888p pd=9.92u as=1.1752p ps=5.04u w=4.52u l=0.5u
X473 VDD lvds_lane_0.d3.0 lvds_lane_0.nd.0 VDD pfet_03v3 ad=0.78p pd=3.52u as=0.78p ps=3.52u w=3u l=0.28u
X474 lvds_lane_2.tp.0 lvds_lane_0.VREF.0 lvds_lane_2.fa.0 lvds_lane_2.tp.0 pfet_03v3 ad=1.248p pd=5.32u as=1.248p ps=5.32u w=4.8u l=0.4u
X475 lvds_lane_2.d3.0 lvds_lane_2.d2b.0 VDD VDD pfet_03v3 ad=0.481p pd=2.37u as=0.481p ps=2.37u w=1.85u l=0.28u
X476 lvds_lane_2.oa.0 lvds_lane_2.rla_m1.0 VSS ppolyf_u_1k r_width=2u r_length=9.11u
X477 lvds_lane_2.ts.0 lvds_lane_0.VBN.0 VSS VSS nfet_03v3 ad=0.65p pd=3.02u as=0.65p ps=3.02u w=2.5u l=1u
X478 lvds_lane_2.tn.0 lvds_lane_0.VREF.0 lvds_lane_2.ob.0 VSS nfet_03v3 ad=1.235p pd=5.27u as=2.09p ps=10.38u w=4.75u l=0.5u
X479 lvds_lane_2.tn.0 lvds_lane_0.VREF.0 lvds_lane_2.oa.0 VSS nfet_03v3 ad=1.235p pd=5.27u as=1.235p ps=5.27u w=4.75u l=0.5u
X480 lvds_lane_0.oa.0 VSS VSS VSS nfet_03v3 ad=1.1752p pd=5.04u as=1.9888p ps=9.92u w=4.52u l=0.5u
X481 lvds_bias_0.rb_m1.0 lvds_bias_0.nrb.0 VSS ppolyf_u_1k r_width=2u r_length=22.27u
X482 lvds_lane_0.d2a.0 lvds_lane_0.d2b.0 VDD VDD pfet_03v3 ad=0.481p pd=2.37u as=0.481p ps=2.37u w=1.85u l=0.28u
X483 lvds_lane_2.tp.0 lvds_lane_0.VREF.0 lvds_lane_2.fb.0 lvds_lane_2.tp.0 pfet_03v3 ad=1.248p pd=5.32u as=1.248p ps=5.32u w=4.8u l=0.4u
X484 lvds_lane_2.tp.0 VDD VDD VDD pfet_03v3 ad=1.3p pd=5.52u as=2.2p ps=10.88u w=5u l=1u
X485 lvds_lane_0.ts.0 lvds_lane_0.VBN.0 VSS VSS nfet_03v3 ad=0.65p pd=3.02u as=0.65p ps=3.02u w=2.5u l=1u
X486 lvds_lane_0.tp.0 lvds_lane_0.gn.0 lvds_lane_0.fb.0 lvds_lane_0.tp.0 pfet_03v3 ad=1.248p pd=5.32u as=1.248p ps=5.32u w=4.8u l=0.4u
X487 lvds_lane_1.oa.0 lvds_lane_1.gp.0 lvds_lane_1.tn.0 VSS nfet_03v3 ad=1.235p pd=5.27u as=1.235p ps=5.27u w=4.75u l=0.5u
X488 VSS VSS lvds_lane_0.d3.0 VSS nfet_03v3 ad=2.0504p pd=10.2u as=1.2116p ps=5.18u w=4.66u l=0.28u
X489 VDD lvds_lane_0.VBP.0 lvds_lane_0.VBP.0 VDD pfet_03v3 ad=1.3p pd=5.52u as=1.3p ps=5.52u w=5u l=1u
X490 lvds_lane_2.fa.0 lvds_lane_0.VREF.0 lvds_lane_2.tp.0 lvds_lane_2.tp.0 pfet_03v3 ad=1.248p pd=5.32u as=1.248p ps=5.32u w=4.8u l=0.4u
X491 VSS lvds_lane_1.n3a.0 lvds_lane_1.n3a.0 VSS nfet_03v3 ad=1.2116p pd=5.18u as=1.2116p ps=5.18u w=4.66u l=0.28u
X492 VDD lvds_lane_0.VBP.0 lvds_lane_1.tp.0 VDD pfet_03v3 ad=1.3p pd=5.52u as=1.3p ps=5.52u w=5u l=1u
X493 lvds_lane_1.fb.0 lvds_lane_0.VREF.0 lvds_lane_1.tp.0 lvds_lane_1.tp.0 pfet_03v3 ad=1.248p pd=5.32u as=1.248p ps=5.32u w=4.8u l=0.4u
X494 lvds_lane_1.tp.0 lvds_lane_0.VREF.0 lvds_lane_1.fb.0 lvds_lane_1.tp.0 pfet_03v3 ad=1.248p pd=5.32u as=1.248p ps=5.32u w=4.8u l=0.4u
X495 lvds_lane_1.ob.0 lvds_lane_0.VREF.0 lvds_lane_1.tn.0 VSS nfet_03v3 ad=1.235p pd=5.27u as=1.235p ps=5.27u w=4.75u l=0.5u
X496 VSS lvds_lane_0.VBN.0 lvds_lane_0.VBN.0 VSS nfet_03v3 ad=0.65p pd=3.02u as=0.65p ps=3.02u w=2.5u l=1u
X497 lvds_lane_0.fa.0 lvds_lane_0.gp.0 lvds_lane_0.tp.0 lvds_lane_0.tp.0 pfet_03v3 ad=1.248p pd=5.32u as=1.248p ps=5.32u w=4.8u l=0.4u
X498 lvds_lane_2.tp.0 lvds_lane_2.gn.0 lvds_lane_2.fb.0 lvds_lane_2.tp.0 pfet_03v3 ad=1.248p pd=5.32u as=1.248p ps=5.32u w=4.8u l=0.4u
X499 lvds_lane_0.fa.0 lvds_lane_0.VBN.0 VSS VSS nfet_03v3 ad=0.65p pd=3.02u as=0.65p ps=3.02u w=2.5u l=1u
X500 lvds_lane_1.nd.0 VDD VDD VDD pfet_03v3 ad=0.78p pd=3.52u as=1.32p ps=6.88u w=3u l=0.28u
X501 VDD lvds_lane_0.d2a.0 lvds_lane_0.d2a.0 VDD pfet_03v3 ad=0.481p pd=2.37u as=0.481p ps=2.37u w=1.85u l=0.28u
X502 VSS VSS VSS VSS nfet_03v3 ad=0.39p pd=2.02u as=0 ps=0 w=1.5u l=0.28u
X503 VDD lvds_lane_1.d2a.0 lvds_lane_1.n3a.0 VDD pfet_03v3 ad=0.481p pd=2.37u as=0.481p ps=2.37u w=1.85u l=0.28u
X504 lvds_lane_0.tp.0 lvds_lane_0.VBP.0 VDD VDD pfet_03v3 ad=1.3p pd=5.52u as=1.3p ps=5.52u w=5u l=1u
X505 lvds_lane_1.fa.0 lvds_lane_0.VBN.0 VSS VSS nfet_03v3 ad=0.65p pd=3.02u as=0.65p ps=3.02u w=2.5u l=1u
X506 lvds_bias_0.nrb.0 lvds_bias_0.enb.0 VDD VDD pfet_03v3 ad=1.3p pd=5.52u as=1.3p ps=5.52u w=5u l=0.5u
X507 VDD lvds_lane_0.d2a.0 lvds_lane_0.d2b.0 VDD pfet_03v3 ad=0.481p pd=2.37u as=0.481p ps=2.37u w=1.85u l=0.28u
X508 lvds_lane_2.tn.0 lvds_lane_0.VREF.0 lvds_lane_2.oa.0 VSS nfet_03v3 ad=1.235p pd=5.27u as=1.235p ps=5.27u w=4.75u l=0.5u
X509 lvds_lane_1.tp.0 lvds_lane_0.VBP.0 VDD VDD pfet_03v3 ad=1.3p pd=5.52u as=1.3p ps=5.52u w=5u l=1u
X510 lvds_lane_0.fa.0 lvds_lane_0.VREF.0 lvds_lane_0.tp.0 lvds_lane_0.tp.0 pfet_03v3 ad=1.248p pd=5.32u as=1.248p ps=5.32u w=4.8u l=0.4u
X511 lvds_lane_1.fa.0 lvds_lane_0.VREF.0 lvds_lane_1.tp.0 lvds_lane_1.tp.0 pfet_03v3 ad=1.248p pd=5.32u as=1.248p ps=5.32u w=4.8u l=0.4u
X512 lvds_lane_1.tp.0 lvds_lane_1.gp.0 lvds_lane_1.fa.0 lvds_lane_1.tp.0 pfet_03v3 ad=1.248p pd=5.32u as=1.248p ps=5.32u w=4.8u l=0.4u
X513 lvds_lane_1.fb.0 lvds_lane_0.VBN.0 VSS VSS nfet_03v3 ad=0.65p pd=3.02u as=0.65p ps=3.02u w=2.5u l=1u
X514 VSS lvds_lane_0.VBN.0 lvds_lane_0.tn.0 VSS nfet_03v3 ad=0.65p pd=3.02u as=0.65p ps=3.02u w=2.5u l=1u
X515 lvds_lane_2.ts.0 VSS VSS VSS nfet_03v3 ad=0.65p pd=3.02u as=1.1p ps=5.88u w=2.5u l=1u
X516 VDD lvds_lane_0.VBP.0 lvds_lane_0.VBP.0 VDD pfet_03v3 ad=1.3p pd=5.52u as=1.3p ps=5.52u w=5u l=1u
X517 lvds_lane_0.ob.0 lvds_lane_0.VREF.0 lvds_lane_0.tn.0 VSS nfet_03v3 ad=2.09p pd=10.38u as=1.235p ps=5.27u w=4.75u l=0.5u
X518 lvds_lane_1.tn.0 lvds_lane_1.gn.0 lvds_lane_1.ob.0 VSS nfet_03v3 ad=1.235p pd=5.27u as=1.235p ps=5.27u w=4.75u l=0.5u
X519 VDD lvds_lane_0.VBP.0 lvds_lane_2.tp.0 VDD pfet_03v3 ad=1.3p pd=5.52u as=1.3p ps=5.52u w=5u l=1u
X520 VSS lvds_lane_0.VBN.0 lvds_lane_0.ts.0 VSS nfet_03v3 ad=0.65p pd=3.02u as=0.65p ps=3.02u w=2.5u l=1u
X521 lvds_lane_2.n3a.0 lvds_lane_2.d2a.0 VDD VDD pfet_03v3 ad=0.481p pd=2.37u as=0.481p ps=2.37u w=1.85u l=0.28u
X522 lvds_bias_0.rb_m1.0 lvds_bias_0.rb_m2.0 VSS ppolyf_u_1k r_width=2u r_length=22.27u
X523 lvds_lane_1.fa.0 lvds_lane_0.VREF.0 lvds_lane_1.tp.0 lvds_lane_1.tp.0 pfet_03v3 ad=1.248p pd=5.32u as=1.248p ps=5.32u w=4.8u l=0.4u
X524 lvds_lane_1.oa.0 lvds_lane_0.VB2.0 lvds_lane_1.fa.0 VSS nfet_03v3 ad=1.1752p pd=5.04u as=1.1752p ps=5.04u w=4.52u l=0.5u
X525 VDD lvds_lane_2.d2a.0 lvds_lane_2.d2a.0 VDD pfet_03v3 ad=0.481p pd=2.37u as=0.481p ps=2.37u w=1.85u l=0.28u
X526 lvds_lane_0.n3a.0 VDD VDD VDD pfet_03v3 ad=0.481p pd=2.37u as=0.814p ps=4.58u w=1.85u l=0.28u
X527 VDD VDD lvds_lane_1.nd.0 VDD pfet_03v3 ad=1.32p pd=6.88u as=0.78p ps=3.52u w=3u l=0.28u
X528 lvds_lane_0.fb.0 lvds_lane_0.gn.0 lvds_lane_0.tp.0 lvds_lane_0.tp.0 pfet_03v3 ad=1.248p pd=5.32u as=1.248p ps=5.32u w=4.8u l=0.4u
X529 lvds_lane_2.tp.0 lvds_lane_2.gp.0 lvds_lane_2.fa.0 lvds_lane_2.tp.0 pfet_03v3 ad=1.248p pd=5.32u as=1.248p ps=5.32u w=4.8u l=0.4u
X530 VSS lvds_lane_0.VBN.0 lvds_lane_0.fa.0 VSS nfet_03v3 ad=0.65p pd=3.02u as=0.65p ps=3.02u w=2.5u l=1u
X531 lvds_lane_0.ts.0 lvds_lane_0.VBN.0 VSS VSS nfet_03v3 ad=0.65p pd=3.02u as=0.65p ps=3.02u w=2.5u l=1u
X532 lvds_lane_2.d2a.0 lvds_lane_2.d2a.0 VDD VDD pfet_03v3 ad=0.481p pd=2.37u as=0.481p ps=2.37u w=1.85u l=0.28u
X533 lvds_lane_1.ts.0 lvds_lane_1.sa.0 VSS ppolyf_u_1k r_width=5u r_length=1.64u
X534 VSS VSS VSS ppolyf_u_1k r_width=5u r_length=1.64u
X535 lvds_lane_1.fa.0 lvds_lane_0.VREF.0 lvds_lane_1.tp.0 lvds_lane_1.tp.0 pfet_03v3 ad=1.248p pd=5.32u as=1.248p ps=5.32u w=4.8u l=0.4u
X536 lvds_lane_2.fa.0 lvds_lane_2.gp.0 lvds_lane_2.tp.0 lvds_lane_2.tp.0 pfet_03v3 ad=1.248p pd=5.32u as=1.248p ps=5.32u w=4.8u l=0.4u
X537 VSS lvds_lane_0.VBN.0 lvds_lane_1.fb.0 VSS nfet_03v3 ad=0.65p pd=3.02u as=0.65p ps=3.02u w=2.5u l=1u
X538 VDD lvds_lane_0.d2a.0 lvds_lane_0.n3a.0 VDD pfet_03v3 ad=0.481p pd=2.37u as=0.481p ps=2.37u w=1.85u l=0.28u
X539 lvds_lane_0.fb.0 lvds_lane_0.VREF.0 lvds_lane_0.tp.0 lvds_lane_0.tp.0 pfet_03v3 ad=2.112p pd=10.48u as=1.248p ps=5.32u w=4.8u l=0.4u
X540 lvds_lane_2.fa.0 lvds_lane_2.gp.0 lvds_lane_2.tp.0 lvds_lane_2.tp.0 pfet_03v3 ad=1.248p pd=5.32u as=1.248p ps=5.32u w=4.8u l=0.4u
X541 lvds_lane_2.tp.0 lvds_lane_2.gn.0 lvds_lane_2.fb.0 lvds_lane_2.tp.0 pfet_03v3 ad=1.248p pd=5.32u as=1.248p ps=5.32u w=4.8u l=0.4u
X542 lvds_lane_0.oa.0 lvds_lane_0.gp.0 lvds_lane_0.tn.0 VSS nfet_03v3 ad=1.235p pd=5.27u as=1.235p ps=5.27u w=4.75u l=0.5u
X543 lvds_lane_1.tn.0 lvds_lane_0.VREF.0 lvds_lane_1.oa.0 VSS nfet_03v3 ad=1.235p pd=5.27u as=1.235p ps=5.27u w=4.75u l=0.5u
X544 VDD lvds_lane_0.VBP.0 lvds_lane_1.tp.0 VDD pfet_03v3 ad=1.3p pd=5.52u as=1.3p ps=5.52u w=5u l=1u
X545 lvds_lane_0.fb.0 lvds_lane_0.VREF.0 lvds_lane_0.tp.0 lvds_lane_0.tp.0 pfet_03v3 ad=1.248p pd=5.32u as=1.248p ps=5.32u w=4.8u l=0.4u
X546 lvds_lane_0.ob.0 lvds_lane_0.gn.0 lvds_lane_0.tn.0 VSS nfet_03v3 ad=1.235p pd=5.27u as=1.235p ps=5.27u w=4.75u l=0.5u
X547 lvds_lane_0.tn.0 lvds_lane_0.VBN.0 VSS VSS nfet_03v3 ad=0.65p pd=3.02u as=0.65p ps=3.02u w=2.5u l=1u
X548 VSS VSS lvds_lane_0.d2b.0 VSS nfet_03v3 ad=1.9228p pd=9.62u as=1.1362p ps=4.89u w=4.37u l=0.5u
X549 VSS lvds_lane_0.VBN.0 lvds_lane_2.ts.0 VSS nfet_03v3 ad=0.65p pd=3.02u as=0.65p ps=3.02u w=2.5u l=1u
X550 lvds_lane_0.tp.0 lvds_lane_0.VBP.0 VDD VDD pfet_03v3 ad=1.3p pd=5.52u as=1.3p ps=5.52u w=5u l=1u
X551 lvds_lane_1.fa.0 VSS VSS VSS nfet_03v3 ad=0.65p pd=3.02u as=1.1p ps=5.88u w=2.5u l=1u
X552 lvds_lane_1.fb.0 lvds_lane_0.VB2.0 lvds_lane_1.ob.0 VSS nfet_03v3 ad=1.1752p pd=5.04u as=1.1752p ps=5.04u w=4.52u l=0.5u
X553 lvds_lane_2.nd.0 EN VDD VDD pfet_03v3 ad=0.78p pd=3.52u as=0.78p ps=3.52u w=3u l=0.28u
X554 lvds_lane_2.fa.0 lvds_lane_2.gp.0 lvds_lane_2.tp.0 lvds_lane_2.tp.0 pfet_03v3 ad=1.248p pd=5.32u as=1.248p ps=5.32u w=4.8u l=0.4u
X555 lvds_lane_1.tn.0 lvds_lane_0.VBN.0 VSS VSS nfet_03v3 ad=0.65p pd=3.02u as=0.65p ps=3.02u w=2.5u l=1u
X556 VDD lvds_lane_2.d2b.0 lvds_lane_2.d3.0 VDD pfet_03v3 ad=0.481p pd=2.37u as=0.481p ps=2.37u w=1.85u l=0.28u
X557 lvds_lane_1.gp.0 RX1_P VDD ppolyf_u r_width=5u r_length=1.8u
X558 lvds_lane_0.fb.0 lvds_lane_0.gn.0 lvds_lane_0.tp.0 lvds_lane_0.tp.0 pfet_03v3 ad=1.248p pd=5.32u as=1.248p ps=5.32u w=4.8u l=0.4u
X559 lvds_lane_0.ob.0 lvds_lane_0.VREF.0 lvds_lane_0.tn.0 VSS nfet_03v3 ad=1.235p pd=5.27u as=1.235p ps=5.27u w=4.75u l=0.5u
X560 VSS lvds_lane_0.VBN.0 lvds_lane_0.ts.0 VSS nfet_03v3 ad=0.65p pd=3.02u as=0.65p ps=3.02u w=2.5u l=1u
X561 lvds_lane_1.d2a.0 VSS VSS VSS nfet_03v3 ad=1.1362p pd=4.89u as=1.9228p ps=9.62u w=4.37u l=0.5u
X562 lvds_lane_2.ob.0 lvds_lane_2.gn.0 lvds_lane_2.tn.0 VSS nfet_03v3 ad=1.235p pd=5.27u as=1.235p ps=5.27u w=4.75u l=0.5u
X563 lvds_lane_2.i1.0 VSS VSS VSS nfet_03v3 ad=0.39p pd=2.02u as=0.66p ps=3.88u w=1.5u l=0.28u
X564 lvds_lane_1.tp.0 lvds_lane_0.VBP.0 VDD VDD pfet_03v3 ad=1.3p pd=5.52u as=1.3p ps=5.52u w=5u l=1u
X565 VDD lvds_lane_1.d2b.0 lvds_lane_1.d2a.0 VDD pfet_03v3 ad=0.481p pd=2.37u as=0.481p ps=2.37u w=1.85u l=0.28u
X566 VDD VDD VDD VDD pfet_03v3 ad=0.52p pd=2.52u as=0 ps=0 w=2u l=0.5u
X567 lvds_lane_0.n3a.0 VSS VSS VSS nfet_03v3 ad=1.2116p pd=5.18u as=2.0504p ps=10.2u w=4.66u l=0.28u
X568 lvds_lane_2.ob.0 lvds_lane_2.gn.0 lvds_lane_2.tn.0 VSS nfet_03v3 ad=1.235p pd=5.27u as=1.235p ps=5.27u w=4.75u l=0.5u
X569 VSS lvds_bias_0.enb.0 lvds_lane_0.VBN.0 VSS nfet_03v3 ad=0.52p pd=2.52u as=0.52p ps=2.52u w=2u l=0.5u
X570 VSS lvds_lane_0.VBN.0 lvds_lane_0.ts.0 VSS nfet_03v3 ad=0.65p pd=3.02u as=0.65p ps=3.02u w=2.5u l=1u
X571 VSS VSS VSS ppolyf_u_1k r_width=2u r_length=9.11u
X572 lvds_lane_0.fb.0 lvds_lane_0.VREF.0 lvds_lane_0.tp.0 lvds_lane_0.tp.0 pfet_03v3 ad=1.248p pd=5.32u as=1.248p ps=5.32u w=4.8u l=0.4u
X573 lvds_lane_1.fb.0 lvds_lane_0.VREF.0 lvds_lane_1.tp.0 lvds_lane_1.tp.0 pfet_03v3 ad=1.248p pd=5.32u as=1.248p ps=5.32u w=4.8u l=0.4u
X574 lvds_lane_0.tn.0 lvds_lane_0.gn.0 lvds_lane_0.ob.0 VSS nfet_03v3 ad=1.235p pd=5.27u as=1.235p ps=5.27u w=4.75u l=0.5u
X575 VSS VSS VSS VSS nfet_03v3 ad=0.52p pd=2.52u as=0 ps=0 w=2u l=0.28u
X576 lvds_lane_1.d2a.0 VDD VDD VDD pfet_03v3 ad=0.52p pd=2.52u as=0.88p ps=4.88u w=2u l=0.5u
X577 lvds_lane_1.fa.0 lvds_lane_0.VBN.0 VSS VSS nfet_03v3 ad=0.65p pd=3.02u as=0.65p ps=3.02u w=2.5u l=1u
X578 lvds_lane_2.fa.0 lvds_lane_0.VBN.0 VSS VSS nfet_03v3 ad=0.65p pd=3.02u as=0.65p ps=3.02u w=2.5u l=1u
X579 lvds_lane_0.fa.0 lvds_lane_0.VREF.0 lvds_lane_0.tp.0 lvds_lane_0.tp.0 pfet_03v3 ad=1.248p pd=5.32u as=1.248p ps=5.32u w=4.8u l=0.4u
X580 VSS lvds_lane_0.VBN.0 lvds_lane_1.ts.0 VSS nfet_03v3 ad=0.65p pd=3.02u as=0.65p ps=3.02u w=2.5u l=1u
X581 lvds_lane_2.oa.0 lvds_lane_2.gp.0 lvds_lane_2.tn.0 VSS nfet_03v3 ad=1.235p pd=5.27u as=1.235p ps=5.27u w=4.75u l=0.5u
X582 lvds_lane_1.tp.0 lvds_lane_1.gp.0 lvds_lane_1.fa.0 lvds_lane_1.tp.0 pfet_03v3 ad=1.248p pd=5.32u as=1.248p ps=5.32u w=4.8u l=0.4u
X583 lvds_lane_2.tp.0 lvds_lane_2.gp.0 lvds_lane_2.fa.0 lvds_lane_2.tp.0 pfet_03v3 ad=1.248p pd=5.32u as=1.248p ps=5.32u w=4.8u l=0.4u
X584 lvds_lane_0.tn.0 lvds_lane_0.gp.0 lvds_lane_0.oa.0 VSS nfet_03v3 ad=1.235p pd=5.27u as=1.235p ps=5.27u w=4.75u l=0.5u
X585 lvds_lane_1.d3.0 lvds_lane_1.d2b.0 VDD VDD pfet_03v3 ad=0.481p pd=2.37u as=0.481p ps=2.37u w=1.85u l=0.28u
X586 VSS VSS lvds_lane_0.fa.0 VSS nfet_03v3 ad=1.9888p pd=9.92u as=1.1752p ps=5.04u w=4.52u l=0.5u
X587 VDD lvds_lane_0.nd.0 lvds_lane_0.i1.0 VDD pfet_03v3 ad=0.962p pd=4.22u as=0.962p ps=4.22u w=3.7u l=0.28u
X588 lvds_lane_2.d2b.0 lvds_lane_2.d2a.0 VDD VDD pfet_03v3 ad=0.481p pd=2.37u as=0.481p ps=2.37u w=1.85u l=0.28u
X589 VDD lvds_lane_0.VBP.0 lvds_lane_0.tp.0 VDD pfet_03v3 ad=1.3p pd=5.52u as=1.3p ps=5.52u w=5u l=1u
D6 lvds_lane_0.gn.0 VDD diode_pd2nw_03v3 pj=26u area=40p
X590 lvds_bias_0.rdt_m2.0 lvds_bias_0.rdt_m1.0 VSS ppolyf_u_1k r_width=2u r_length=21.01u
X591 lvds_lane_0.tp.0 lvds_lane_0.VREF.0 lvds_lane_0.fb.0 lvds_lane_0.tp.0 pfet_03v3 ad=1.248p pd=5.32u as=1.248p ps=5.32u w=4.8u l=0.4u
X592 VSS lvds_lane_0.VBN.0 lvds_lane_1.fa.0 VSS nfet_03v3 ad=0.65p pd=3.02u as=0.65p ps=3.02u w=2.5u l=1u
X593 lvds_lane_2.fa.0 lvds_lane_0.VB2.0 lvds_lane_2.oa.0 VSS nfet_03v3 ad=1.1752p pd=5.04u as=1.1752p ps=5.04u w=4.52u l=0.5u
X594 VDD VDD lvds_lane_2.i2.0 VDD pfet_03v3 ad=1.65p pd=8.38u as=0.975p ps=4.27u w=3.75u l=0.28u
X595 lvds_lane_0.fa.0 lvds_lane_0.gp.0 lvds_lane_0.tp.0 lvds_lane_0.tp.0 pfet_03v3 ad=1.248p pd=5.32u as=1.248p ps=5.32u w=4.8u l=0.4u
X596 lvds_lane_0.oa.0 lvds_lane_0.VB2.0 lvds_lane_0.fa.0 VSS nfet_03v3 ad=1.1752p pd=5.04u as=1.1752p ps=5.04u w=4.52u l=0.5u
X597 VSS VSS lvds_lane_1.tn.0 VSS nfet_03v3 ad=1.1p pd=5.88u as=0.65p ps=3.02u w=2.5u l=1u
X598 VDD lvds_lane_2.rla_m1.0 VSS ppolyf_u_1k r_width=2u r_length=9.11u
X599 lvds_lane_2.tp.0 lvds_lane_0.VREF.0 lvds_lane_2.fa.0 lvds_lane_2.tp.0 pfet_03v3 ad=1.248p pd=5.32u as=1.248p ps=5.32u w=4.8u l=0.4u
X600 VSS lvds_lane_0.VBN.0 lvds_lane_2.fb.0 VSS nfet_03v3 ad=0.65p pd=3.02u as=0.65p ps=3.02u w=2.5u l=1u
X601 lvds_lane_1.tn.0 lvds_lane_0.VREF.0 lvds_lane_1.ob.0 VSS nfet_03v3 ad=1.235p pd=5.27u as=1.235p ps=5.27u w=4.75u l=0.5u
X602 lvds_lane_1.tp.0 lvds_lane_1.gn.0 lvds_lane_1.fb.0 lvds_lane_1.tp.0 pfet_03v3 ad=1.248p pd=5.32u as=1.248p ps=5.32u w=4.8u l=0.4u
X603 VSS lvds_lane_0.VBN.0 lvds_lane_2.fa.0 VSS nfet_03v3 ad=0.65p pd=3.02u as=0.65p ps=3.02u w=2.5u l=1u
X604 lvds_lane_1.ob.0 lvds_lane_1.gn.0 lvds_lane_1.tn.0 VSS nfet_03v3 ad=1.235p pd=5.27u as=1.235p ps=5.27u w=4.75u l=0.5u
X605 lvds_lane_2.tn.0 lvds_lane_0.VREF.0 lvds_lane_2.ob.0 VSS nfet_03v3 ad=1.235p pd=5.27u as=1.235p ps=5.27u w=4.75u l=0.5u
X606 lvds_lane_2.nd.0 VSS VSS VSS nfet_03v3 ad=0.52p pd=2.52u as=0.88p ps=4.88u w=2u l=0.28u
X607 lvds_lane_2.fa.0 lvds_lane_0.VB2.0 lvds_lane_2.oa.0 VSS nfet_03v3 ad=1.1752p pd=5.04u as=1.1752p ps=5.04u w=4.52u l=0.5u
X608 VDD lvds_lane_2.rlb_m1.0 VSS ppolyf_u_1k r_width=2u r_length=9.11u
X609 lvds_lane_0.tp.0 lvds_lane_0.gp.0 lvds_lane_0.fa.0 lvds_lane_0.tp.0 pfet_03v3 ad=1.248p pd=5.32u as=1.248p ps=5.32u w=4.8u l=0.4u
X610 lvds_lane_2.fa.0 lvds_lane_2.gp.0 lvds_lane_2.tp.0 lvds_lane_2.tp.0 pfet_03v3 ad=1.248p pd=5.32u as=1.248p ps=5.32u w=4.8u l=0.4u
X611 VDD lvds_lane_2.d2a.0 lvds_lane_2.n3a.0 VDD pfet_03v3 ad=0.481p pd=2.37u as=0.481p ps=2.37u w=1.85u l=0.28u
X612 lvds_lane_1.i1.0 VDD VDD VDD pfet_03v3 ad=0.962p pd=4.22u as=1.628p ps=8.28u w=3.7u l=0.28u
D7 VSS lvds_lane_0.gn.0 diode_nd2ps_03v3 pj=26u area=40p
X613 VSS EN lvds_lane_2.nm.0 VSS nfet_03v3 ad=0.52p pd=2.52u as=0.52p ps=2.52u w=2u l=0.28u
X614 VSS lvds_lane_2.nd.0 lvds_lane_2.i1.0 VSS nfet_03v3 ad=0.39p pd=2.02u as=0.39p ps=2.02u w=1.5u l=0.28u
X615 lvds_lane_1.ts.0 lvds_lane_0.VBN.0 VSS VSS nfet_03v3 ad=0.65p pd=3.02u as=0.65p ps=3.02u w=2.5u l=1u
X616 lvds_lane_1.fb.0 lvds_lane_0.VBN.0 VSS VSS nfet_03v3 ad=0.65p pd=3.02u as=0.65p ps=3.02u w=2.5u l=1u
X617 lvds_lane_1.oa.0 lvds_lane_0.VREF.0 lvds_lane_1.tn.0 VSS nfet_03v3 ad=1.235p pd=5.27u as=1.235p ps=5.27u w=4.75u l=0.5u
X618 VSS VSS VSS ppolyf_u_1k r_width=5u r_length=1.64u
X619 VDD lvds_lane_2.d2b.0 lvds_lane_2.d2a.0 VDD pfet_03v3 ad=0.481p pd=2.37u as=0.481p ps=2.37u w=1.85u l=0.28u
X620 lvds_lane_1.fb.0 lvds_lane_1.gn.0 lvds_lane_1.tp.0 lvds_lane_1.tp.0 pfet_03v3 ad=1.248p pd=5.32u as=1.248p ps=5.32u w=4.8u l=0.4u
X621 VSS lvds_lane_0.VBN.0 lvds_lane_0.fa.0 VSS nfet_03v3 ad=0.65p pd=3.02u as=0.65p ps=3.02u w=2.5u l=1u
X622 lvds_lane_1.d2b.0 lvds_lane_1.d2b.0 VDD VDD pfet_03v3 ad=0.481p pd=2.37u as=0.481p ps=2.37u w=1.85u l=0.28u
X623 lvds_lane_1.tp.0 lvds_lane_0.VREF.0 lvds_lane_1.fb.0 lvds_lane_1.tp.0 pfet_03v3 ad=1.248p pd=5.32u as=1.248p ps=5.32u w=4.8u l=0.4u
X624 lvds_lane_2.tp.0 lvds_lane_0.VREF.0 lvds_lane_2.fb.0 lvds_lane_2.tp.0 pfet_03v3 ad=1.248p pd=5.32u as=1.248p ps=5.32u w=4.8u l=0.4u
X625 RX1_O VDD VDD VDD pfet_03v3 ad=1.3p pd=5.52u as=2.2p ps=10.88u w=5u l=0.28u
X626 lvds_lane_1.tp.0 lvds_lane_0.VBP.0 VDD VDD pfet_03v3 ad=1.3p pd=5.52u as=1.3p ps=5.52u w=5u l=1u
X627 lvds_lane_0.fb.0 lvds_lane_0.gn.0 lvds_lane_0.tp.0 lvds_lane_0.tp.0 pfet_03v3 ad=1.248p pd=5.32u as=1.248p ps=5.32u w=4.8u l=0.4u
X628 lvds_lane_2.fa.0 lvds_lane_0.VBN.0 VSS VSS nfet_03v3 ad=0.65p pd=3.02u as=0.65p ps=3.02u w=2.5u l=1u
X629 VSS lvds_lane_0.VBN.0 lvds_lane_1.tn.0 VSS nfet_03v3 ad=0.65p pd=3.02u as=0.65p ps=3.02u w=2.5u l=1u
X630 VDD lvds_lane_2.d2b.0 lvds_lane_2.d3.0 VDD pfet_03v3 ad=0.481p pd=2.37u as=0.481p ps=2.37u w=1.85u l=0.28u
X631 lvds_lane_0.tp.0 lvds_lane_0.gp.0 lvds_lane_0.fa.0 lvds_lane_0.tp.0 pfet_03v3 ad=1.248p pd=5.32u as=1.248p ps=5.32u w=4.8u l=0.4u
X632 lvds_lane_0.tp.0 lvds_lane_0.gp.0 lvds_lane_0.fa.0 lvds_lane_0.tp.0 pfet_03v3 ad=1.248p pd=5.32u as=1.248p ps=5.32u w=4.8u l=0.4u
X633 lvds_lane_1.tp.0 lvds_lane_0.VREF.0 lvds_lane_1.fa.0 lvds_lane_1.tp.0 pfet_03v3 ad=1.248p pd=5.32u as=1.248p ps=5.32u w=4.8u l=0.4u
X634 lvds_lane_2.fb.0 lvds_lane_0.VBN.0 VSS VSS nfet_03v3 ad=0.65p pd=3.02u as=0.65p ps=3.02u w=2.5u l=1u
X635 lvds_lane_0.fa.0 lvds_lane_0.gp.0 lvds_lane_0.tp.0 lvds_lane_0.tp.0 pfet_03v3 ad=1.248p pd=5.32u as=1.248p ps=5.32u w=4.8u l=0.4u
X636 lvds_lane_1.tp.0 lvds_lane_0.VREF.0 lvds_lane_1.fa.0 lvds_lane_1.tp.0 pfet_03v3 ad=1.248p pd=5.32u as=1.248p ps=5.32u w=4.8u l=0.4u
X637 VSS VSS lvds_lane_0.ts.0 VSS nfet_03v3 ad=1.1p pd=5.88u as=0.65p ps=3.02u w=2.5u l=1u
X638 VDD lvds_lane_0.d2a.0 lvds_lane_0.d2b.0 VDD pfet_03v3 ad=0.481p pd=2.37u as=0.481p ps=2.37u w=1.85u l=0.28u
X639 VSS lvds_lane_0.VBN.0 lvds_lane_2.tn.0 VSS nfet_03v3 ad=0.65p pd=3.02u as=0.65p ps=3.02u w=2.5u l=1u
X640 VDD EN lvds_lane_0.d2b.0 VDD pfet_03v3 ad=0.52p pd=2.52u as=0.52p ps=2.52u w=2u l=0.5u
X641 VSS lvds_lane_0.VBN.0 lvds_lane_2.fb.0 VSS nfet_03v3 ad=0.65p pd=3.02u as=0.65p ps=3.02u w=2.5u l=1u
X642 lvds_lane_1.ts.0 lvds_lane_0.VBN.0 VSS VSS nfet_03v3 ad=0.65p pd=3.02u as=0.65p ps=3.02u w=2.5u l=1u
X643 lvds_lane_1.i1.0 VSS VSS VSS nfet_03v3 ad=0.39p pd=2.02u as=0.66p ps=3.88u w=1.5u l=0.28u
X644 lvds_lane_0.i2.0 lvds_lane_0.i1.0 VDD VDD pfet_03v3 ad=0.975p pd=4.27u as=0.975p ps=4.27u w=3.75u l=0.28u
X645 lvds_lane_0.tp.0 lvds_lane_0.VREF.0 lvds_lane_0.fb.0 lvds_lane_0.tp.0 pfet_03v3 ad=1.248p pd=5.32u as=1.248p ps=5.32u w=4.8u l=0.4u
X646 lvds_lane_1.fa.0 lvds_lane_1.gp.0 lvds_lane_1.tp.0 lvds_lane_1.tp.0 pfet_03v3 ad=1.248p pd=5.32u as=1.248p ps=5.32u w=4.8u l=0.4u
X647 lvds_lane_1.d2b.0 lvds_lane_1.ob.0 lvds_lane_1.sb.0 VSS nfet_03v3 ad=1.1362p pd=4.89u as=1.1362p ps=4.89u w=4.37u l=0.5u
X648 lvds_lane_1.tp.0 lvds_lane_0.VREF.0 lvds_lane_1.fa.0 lvds_lane_1.tp.0 pfet_03v3 ad=1.248p pd=5.32u as=1.248p ps=5.32u w=4.8u l=0.4u
X649 lvds_bias_0.rb_m3.0 lvds_bias_0.rb_m2.0 VSS ppolyf_u_1k r_width=2u r_length=22.27u
X650 lvds_lane_1.fa.0 lvds_lane_0.VBN.0 VSS VSS nfet_03v3 ad=0.65p pd=3.02u as=0.65p ps=3.02u w=2.5u l=1u
X651 VSS VSS VSS VSS nfet_03v3 ad=0.52p pd=2.52u as=0 ps=0 w=2u l=0.28u
X652 lvds_lane_1.d3.0 lvds_lane_1.d2b.0 VDD VDD pfet_03v3 ad=0.481p pd=2.37u as=0.481p ps=2.37u w=1.85u l=0.28u
X653 lvds_lane_1.oa.0 lvds_lane_1.rla_m1.0 VSS ppolyf_u_1k r_width=2u r_length=9.11u
X654 lvds_lane_2.tp.0 lvds_lane_2.gp.0 lvds_lane_2.fa.0 lvds_lane_2.tp.0 pfet_03v3 ad=1.248p pd=5.32u as=1.248p ps=5.32u w=4.8u l=0.4u
X655 lvds_lane_1.tn.0 lvds_lane_0.VREF.0 lvds_lane_1.ob.0 VSS nfet_03v3 ad=1.235p pd=5.27u as=2.09p ps=10.38u w=4.75u l=0.5u
X656 lvds_lane_1.tn.0 lvds_lane_0.VREF.0 lvds_lane_1.oa.0 VSS nfet_03v3 ad=1.235p pd=5.27u as=1.235p ps=5.27u w=4.75u l=0.5u
X657 VDD VDD VDD VDD pfet_03v3 ad=0.962p pd=4.22u as=0 ps=0 w=3.7u l=0.28u
X658 lvds_lane_1.fa.0 lvds_lane_0.VREF.0 lvds_lane_1.tp.0 lvds_lane_1.tp.0 pfet_03v3 ad=1.248p pd=5.32u as=1.248p ps=5.32u w=4.8u l=0.4u
X659 lvds_lane_1.fb.0 lvds_lane_0.VB2.0 lvds_lane_1.ob.0 VSS nfet_03v3 ad=1.1752p pd=5.04u as=1.1752p ps=5.04u w=4.52u l=0.5u
X660 lvds_lane_1.tp.0 VDD VDD VDD pfet_03v3 ad=1.3p pd=5.52u as=2.2p ps=10.88u w=5u l=1u
X661 VDD lvds_lane_0.VBP.0 lvds_lane_0.VB2.0 VDD pfet_03v3 ad=1.3p pd=5.52u as=1.3p ps=5.52u w=5u l=1u
X662 lvds_lane_0.oa.0 lvds_lane_0.gp.0 lvds_lane_0.tn.0 VSS nfet_03v3 ad=1.235p pd=5.27u as=1.235p ps=5.27u w=4.75u l=0.5u
X663 lvds_lane_1.d2b.0 lvds_lane_1.d2a.0 VDD VDD pfet_03v3 ad=0.481p pd=2.37u as=0.481p ps=2.37u w=1.85u l=0.28u
X664 lvds_lane_1.fa.0 lvds_lane_0.VREF.0 lvds_lane_1.tp.0 lvds_lane_1.tp.0 pfet_03v3 ad=1.248p pd=5.32u as=1.248p ps=5.32u w=4.8u l=0.4u
X665 lvds_lane_2.tn.0 lvds_lane_0.VBN.0 VSS VSS nfet_03v3 ad=0.65p pd=3.02u as=0.65p ps=3.02u w=2.5u l=1u
X666 VDD lvds_lane_0.VBP.0 lvds_lane_0.tp.0 VDD pfet_03v3 ad=1.3p pd=5.52u as=1.3p ps=5.52u w=5u l=1u
X667 lvds_lane_1.fb.0 lvds_lane_0.VB2.0 lvds_lane_1.ob.0 VSS nfet_03v3 ad=1.1752p pd=5.04u as=1.1752p ps=5.04u w=4.52u l=0.5u
D8 lvds_lane_2.gp.0 VDD diode_pd2nw_03v3 pj=26u area=40p
X668 lvds_lane_2.tn.0 lvds_lane_2.gn.0 lvds_lane_2.ob.0 VSS nfet_03v3 ad=1.235p pd=5.27u as=1.235p ps=5.27u w=4.75u l=0.5u
X669 VDD lvds_lane_1.i1.0 lvds_lane_1.i2.0 VDD pfet_03v3 ad=0.975p pd=4.27u as=0.975p ps=4.27u w=3.75u l=0.28u
X670 VSS EN lvds_bias_0.enb.0 VSS nfet_03v3 ad=0.44p pd=2.88u as=0.44p ps=2.88u w=1u l=0.28u
X671 lvds_lane_0.fb.0 lvds_lane_0.VREF.0 lvds_lane_0.tp.0 lvds_lane_0.tp.0 pfet_03v3 ad=1.248p pd=5.32u as=1.248p ps=5.32u w=4.8u l=0.4u
X672 lvds_lane_1.tp.0 lvds_lane_0.VREF.0 lvds_lane_1.fb.0 lvds_lane_1.tp.0 pfet_03v3 ad=1.248p pd=5.32u as=1.248p ps=5.32u w=4.8u l=0.4u
X673 lvds_lane_0.ob.0 lvds_lane_0.VREF.0 lvds_lane_0.tn.0 VSS nfet_03v3 ad=1.235p pd=5.27u as=1.235p ps=5.27u w=4.75u l=0.5u
X674 lvds_lane_0.tp.0 lvds_lane_0.VREF.0 lvds_lane_0.fb.0 lvds_lane_0.tp.0 pfet_03v3 ad=1.248p pd=5.32u as=1.248p ps=5.32u w=4.8u l=0.4u
X675 lvds_lane_1.ob.0 lvds_lane_1.rlb_m1.0 VSS ppolyf_u_1k r_width=2u r_length=9.11u
X676 lvds_lane_2.oa.0 lvds_lane_2.gp.0 lvds_lane_2.tn.0 VSS nfet_03v3 ad=1.235p pd=5.27u as=1.235p ps=5.27u w=4.75u l=0.5u
X677 lvds_lane_2.tp.0 lvds_lane_2.gn.0 lvds_lane_2.fb.0 lvds_lane_2.tp.0 pfet_03v3 ad=1.248p pd=5.32u as=1.248p ps=5.32u w=4.8u l=0.4u
X678 VDD VDD RX1_O VDD pfet_03v3 ad=2.2p pd=10.88u as=1.3p ps=5.52u w=5u l=0.28u
X679 lvds_lane_0.nd.0 VDD VDD VDD pfet_03v3 ad=0.78p pd=3.52u as=1.32p ps=6.88u w=3u l=0.28u
X680 VDD lvds_lane_2.d2a.0 lvds_lane_2.n3a.0 VDD pfet_03v3 ad=0.481p pd=2.37u as=0.481p ps=2.37u w=1.85u l=0.28u
X681 lvds_lane_2.tp.0 lvds_lane_0.VREF.0 lvds_lane_2.fb.0 lvds_lane_2.tp.0 pfet_03v3 ad=1.248p pd=5.32u as=1.248p ps=5.32u w=4.8u l=0.4u
X682 lvds_lane_2.tn.0 lvds_lane_0.VREF.0 lvds_lane_2.oa.0 VSS nfet_03v3 ad=1.235p pd=5.27u as=1.235p ps=5.27u w=4.75u l=0.5u
X683 VDD lvds_lane_0.d2a.0 lvds_lane_0.n3a.0 VDD pfet_03v3 ad=0.481p pd=2.37u as=0.481p ps=2.37u w=1.85u l=0.28u
X684 lvds_lane_1.nd.0 VSS VSS VSS nfet_03v3 ad=0.52p pd=2.52u as=0.88p ps=4.88u w=2u l=0.28u
X685 lvds_lane_2.d2b.0 lvds_lane_2.d2a.0 VDD VDD pfet_03v3 ad=0.481p pd=2.37u as=0.481p ps=2.37u w=1.85u l=0.28u
X686 lvds_lane_2.tp.0 lvds_lane_0.VBP.0 VDD VDD pfet_03v3 ad=1.3p pd=5.52u as=1.3p ps=5.52u w=5u l=1u
X687 lvds_lane_0.fa.0 lvds_lane_0.VBN.0 VSS VSS nfet_03v3 ad=0.65p pd=3.02u as=0.65p ps=3.02u w=2.5u l=1u
X688 lvds_lane_0.d3.0 lvds_lane_0.n3a.0 VSS VSS nfet_03v3 ad=1.2116p pd=5.18u as=1.2116p ps=5.18u w=4.66u l=0.28u
X689 lvds_lane_0.tp.0 lvds_lane_0.VBP.0 VDD VDD pfet_03v3 ad=1.3p pd=5.52u as=1.3p ps=5.52u w=5u l=1u
X690 lvds_lane_0.fa.0 lvds_lane_0.VREF.0 lvds_lane_0.tp.0 lvds_lane_0.tp.0 pfet_03v3 ad=1.248p pd=5.32u as=1.248p ps=5.32u w=4.8u l=0.4u
X691 VSS VSS lvds_bias_0.nmid.0 VSS nfet_03v3 ad=2.2p pd=10.88u as=1.3p ps=5.52u w=5u l=0.5u
X692 lvds_lane_0.tp.0 lvds_lane_0.gp.0 lvds_lane_0.fa.0 lvds_lane_0.tp.0 pfet_03v3 ad=1.248p pd=5.32u as=1.248p ps=5.32u w=4.8u l=0.4u
X693 lvds_lane_1.fb.0 lvds_lane_0.VREF.0 lvds_lane_1.tp.0 lvds_lane_1.tp.0 pfet_03v3 ad=1.248p pd=5.32u as=1.248p ps=5.32u w=4.8u l=0.4u
X694 lvds_lane_0.fb.0 lvds_lane_0.VBN.0 VSS VSS nfet_03v3 ad=0.65p pd=3.02u as=0.65p ps=3.02u w=2.5u l=1u
X695 lvds_lane_1.fb.0 lvds_lane_0.VBN.0 VSS VSS nfet_03v3 ad=0.65p pd=3.02u as=0.65p ps=3.02u w=2.5u l=1u
X696 VSS EN lvds_lane_1.nm.0 VSS nfet_03v3 ad=0.52p pd=2.52u as=0.52p ps=2.52u w=2u l=0.28u
X697 VSS lvds_lane_1.nd.0 lvds_lane_1.i1.0 VSS nfet_03v3 ad=0.39p pd=2.02u as=0.39p ps=2.02u w=1.5u l=0.28u
X698 lvds_lane_2.fb.0 lvds_lane_0.VREF.0 lvds_lane_2.tp.0 lvds_lane_2.tp.0 pfet_03v3 ad=1.248p pd=5.32u as=1.248p ps=5.32u w=4.8u l=0.4u
X699 lvds_lane_0.tn.0 lvds_lane_0.gn.0 lvds_lane_0.ob.0 VSS nfet_03v3 ad=1.235p pd=5.27u as=1.235p ps=5.27u w=4.75u l=0.5u
X700 VDD lvds_lane_1.d2a.0 lvds_lane_1.d2b.0 VDD pfet_03v3 ad=0.481p pd=2.37u as=0.481p ps=2.37u w=1.85u l=0.28u
X701 lvds_lane_2.d2a.0 lvds_lane_2.oa.0 lvds_lane_2.sa.0 VSS nfet_03v3 ad=1.1362p pd=4.89u as=1.1362p ps=4.89u w=4.37u l=0.5u
X702 VDD lvds_lane_0.VBP.0 lvds_lane_1.tp.0 VDD pfet_03v3 ad=1.3p pd=5.52u as=1.3p ps=5.52u w=5u l=1u
X703 lvds_lane_2.tp.0 lvds_lane_2.gp.0 lvds_lane_2.fa.0 lvds_lane_2.tp.0 pfet_03v3 ad=1.248p pd=5.32u as=1.248p ps=5.32u w=4.8u l=0.4u
X704 VSS EN lvds_bias_0.nmid.0 VSS nfet_03v3 ad=1.3p pd=5.52u as=1.3p ps=5.52u w=5u l=0.5u
X705 lvds_lane_1.tn.0 lvds_lane_0.VREF.0 lvds_lane_1.oa.0 VSS nfet_03v3 ad=1.235p pd=5.27u as=1.235p ps=5.27u w=4.75u l=0.5u
X706 VSS lvds_lane_0.VBN.0 lvds_lane_2.tn.0 VSS nfet_03v3 ad=0.65p pd=3.02u as=0.65p ps=3.02u w=2.5u l=1u
X707 VDD lvds_lane_0.VBP.0 lvds_lane_2.tp.0 VDD pfet_03v3 ad=1.3p pd=5.52u as=1.3p ps=5.52u w=5u l=1u
X708 lvds_lane_1.n3a.0 lvds_lane_1.d2a.0 VDD VDD pfet_03v3 ad=0.481p pd=2.37u as=0.481p ps=2.37u w=1.85u l=0.28u
X709 lvds_lane_0.fa.0 lvds_lane_0.VREF.0 lvds_lane_0.tp.0 lvds_lane_0.tp.0 pfet_03v3 ad=1.248p pd=5.32u as=1.248p ps=5.32u w=4.8u l=0.4u
X710 lvds_lane_0.oa.0 lvds_lane_0.VB2.0 lvds_lane_0.fa.0 VSS nfet_03v3 ad=1.1752p pd=5.04u as=1.1752p ps=5.04u w=4.52u l=0.5u
X711 VDD lvds_lane_1.d2a.0 lvds_lane_1.d2a.0 VDD pfet_03v3 ad=0.481p pd=2.37u as=0.481p ps=2.37u w=1.85u l=0.28u
X712 lvds_lane_1.tp.0 lvds_lane_0.VBP.0 VDD VDD pfet_03v3 ad=1.3p pd=5.52u as=1.3p ps=5.52u w=5u l=1u
X713 lvds_bias_0.vf.0 lvds_lane_0.VB2.0 lvds_lane_0.VB2.0 VSS nfet_03v3 ad=2.0566p pd=8.43u as=2.0566p ps=8.43u w=7.91u l=0.5u
X714 RX0_O VDD VDD VDD pfet_03v3 ad=1.3p pd=5.52u as=2.2p ps=10.88u w=5u l=0.28u
X715 VDD VDD lvds_lane_0.nd.0 VDD pfet_03v3 ad=1.32p pd=6.88u as=0.78p ps=3.52u w=3u l=0.28u
X716 lvds_lane_2.n3a.0 lvds_lane_2.d2a.0 VDD VDD pfet_03v3 ad=0.481p pd=2.37u as=0.481p ps=2.37u w=1.85u l=0.28u
X717 lvds_lane_1.fb.0 lvds_lane_1.gn.0 lvds_lane_1.tp.0 lvds_lane_1.tp.0 pfet_03v3 ad=1.248p pd=5.32u as=1.248p ps=5.32u w=4.8u l=0.4u
X718 lvds_lane_2.ob.0 lvds_lane_0.VB2.0 lvds_lane_2.fb.0 VSS nfet_03v3 ad=1.1752p pd=5.04u as=1.1752p ps=5.04u w=4.52u l=0.5u
X719 lvds_lane_1.tn.0 lvds_lane_0.VREF.0 lvds_lane_1.ob.0 VSS nfet_03v3 ad=1.235p pd=5.27u as=1.235p ps=5.27u w=4.75u l=0.5u
X720 lvds_lane_0.ts.0 lvds_lane_0.sa.0 VSS ppolyf_u_1k r_width=5u r_length=1.64u
X721 lvds_lane_0.fa.0 lvds_lane_0.VREF.0 lvds_lane_0.tp.0 lvds_lane_0.tp.0 pfet_03v3 ad=1.248p pd=5.32u as=1.248p ps=5.32u w=4.8u l=0.4u
X722 lvds_lane_1.fa.0 lvds_lane_1.gp.0 lvds_lane_1.tp.0 lvds_lane_1.tp.0 pfet_03v3 ad=1.248p pd=5.32u as=1.248p ps=5.32u w=4.8u l=0.4u
X723 lvds_lane_2.fa.0 lvds_lane_0.VB2.0 lvds_lane_2.oa.0 VSS nfet_03v3 ad=1.1752p pd=5.04u as=1.1752p ps=5.04u w=4.52u l=0.5u
X724 RX1_O lvds_lane_1.i2.0 VDD VDD pfet_03v3 ad=1.3p pd=5.52u as=1.3p ps=5.52u w=5u l=0.28u
X725 lvds_lane_2.tp.0 lvds_lane_0.VREF.0 lvds_lane_2.fa.0 lvds_lane_2.tp.0 pfet_03v3 ad=1.248p pd=5.32u as=1.248p ps=5.32u w=4.8u l=0.4u
X726 VSS lvds_lane_0.VBN.0 lvds_lane_0.fb.0 VSS nfet_03v3 ad=0.65p pd=3.02u as=0.65p ps=3.02u w=2.5u l=1u
X727 lvds_lane_2.tn.0 lvds_lane_0.VBN.0 VSS VSS nfet_03v3 ad=0.65p pd=3.02u as=0.65p ps=3.02u w=2.5u l=1u
X728 lvds_lane_1.tp.0 lvds_lane_1.gn.0 lvds_lane_1.fb.0 lvds_lane_1.tp.0 pfet_03v3 ad=1.248p pd=5.32u as=1.248p ps=5.32u w=4.8u l=0.4u
X729 lvds_lane_0.tn.0 lvds_lane_0.VREF.0 lvds_lane_0.oa.0 VSS nfet_03v3 ad=1.235p pd=5.27u as=1.235p ps=5.27u w=4.75u l=0.5u
X730 lvds_lane_2.fa.0 lvds_lane_0.VB2.0 lvds_lane_2.oa.0 VSS nfet_03v3 ad=1.1752p pd=5.04u as=1.1752p ps=5.04u w=4.52u l=0.5u
X731 lvds_lane_2.fa.0 lvds_lane_0.VREF.0 lvds_lane_2.tp.0 lvds_lane_2.tp.0 pfet_03v3 ad=1.248p pd=5.32u as=1.248p ps=5.32u w=4.8u l=0.4u
X732 RX2_O VDD VDD VDD pfet_03v3 ad=1.3p pd=5.52u as=2.2p ps=10.88u w=5u l=0.28u
X733 lvds_bias_0.enb.0 VDD VDD VDD pfet_03v3 ad=0.65p pd=3.02u as=1.1p ps=5.88u w=2.5u l=0.28u
X734 VDD lvds_lane_0.VBP.0 lvds_lane_0.tp.0 VDD pfet_03v3 ad=1.3p pd=5.52u as=1.3p ps=5.52u w=5u l=1u
X735 lvds_lane_1.gn.0 RX1_N VDD ppolyf_u r_width=5u r_length=1.8u
X736 VSS lvds_lane_0.VBN.0 lvds_lane_1.fb.0 VSS nfet_03v3 ad=0.65p pd=3.02u as=0.65p ps=3.02u w=2.5u l=1u
X737 VDD lvds_lane_2.d2b.0 lvds_lane_2.d3.0 VDD pfet_03v3 ad=0.481p pd=2.37u as=0.481p ps=2.37u w=1.85u l=0.28u
X738 lvds_lane_0.fa.0 VSS VSS VSS nfet_03v3 ad=0.65p pd=3.02u as=1.1p ps=5.88u w=2.5u l=1u
X739 lvds_lane_0.fb.0 lvds_lane_0.VB2.0 lvds_lane_0.ob.0 VSS nfet_03v3 ad=1.1752p pd=5.04u as=1.1752p ps=5.04u w=4.52u l=0.5u
X740 lvds_lane_1.nd.0 EN VDD VDD pfet_03v3 ad=0.78p pd=3.52u as=0.78p ps=3.52u w=3u l=0.28u
X741 lvds_lane_2.d2a.0 lvds_lane_2.d2a.0 VDD VDD pfet_03v3 ad=0.481p pd=2.37u as=0.481p ps=2.37u w=1.85u l=0.28u
X742 lvds_lane_0.tn.0 lvds_lane_0.VBN.0 VSS VSS nfet_03v3 ad=0.65p pd=3.02u as=0.65p ps=3.02u w=2.5u l=1u
X743 VSS lvds_lane_0.VBN.0 lvds_lane_0.VBN.0 VSS nfet_03v3 ad=0.65p pd=3.02u as=0.65p ps=3.02u w=2.5u l=1u
X744 lvds_lane_0.i1.0 VSS VSS VSS nfet_03v3 ad=0.39p pd=2.02u as=0.66p ps=3.88u w=1.5u l=0.28u
X745 VSS lvds_lane_0.VBN.0 lvds_lane_2.ts.0 VSS nfet_03v3 ad=0.65p pd=3.02u as=0.65p ps=3.02u w=2.5u l=1u
X746 lvds_lane_2.tp.0 lvds_lane_0.VREF.0 lvds_lane_2.fb.0 lvds_lane_2.tp.0 pfet_03v3 ad=1.248p pd=5.32u as=2.112p ps=10.48u w=4.8u l=0.4u
X747 lvds_lane_0.VBP.0 lvds_lane_0.VBN.0 VSS VSS nfet_03v3 ad=0.65p pd=3.02u as=0.65p ps=3.02u w=2.5u l=1u
X748 VDD lvds_lane_1.d2b.0 lvds_lane_1.d3.0 VDD pfet_03v3 ad=0.481p pd=2.37u as=0.481p ps=2.37u w=1.85u l=0.28u
X749 lvds_lane_0.VB2.0 lvds_lane_0.VBP.0 VDD VDD pfet_03v3 ad=1.3p pd=5.52u as=1.3p ps=5.52u w=5u l=1u
X750 VDD lvds_lane_2.d2b.0 lvds_lane_2.d2b.0 VDD pfet_03v3 ad=0.481p pd=2.37u as=0.481p ps=2.37u w=1.85u l=0.28u
X751 lvds_lane_2.tp.0 lvds_lane_0.VBP.0 VDD VDD pfet_03v3 ad=1.3p pd=5.52u as=1.3p ps=5.52u w=5u l=1u
X752 lvds_lane_0.d2a.0 VSS VSS VSS nfet_03v3 ad=1.1362p pd=4.89u as=1.9228p ps=9.62u w=4.37u l=0.5u
X753 lvds_lane_2.fa.0 lvds_lane_0.VREF.0 lvds_lane_2.tp.0 lvds_lane_2.tp.0 pfet_03v3 ad=1.248p pd=5.32u as=1.248p ps=5.32u w=4.8u l=0.4u
X754 lvds_lane_0.tp.0 lvds_lane_0.VBP.0 VDD VDD pfet_03v3 ad=1.3p pd=5.52u as=1.3p ps=5.52u w=5u l=1u
X755 VSS VSS VSS VSS nfet_03v3 ad=0.52p pd=2.52u as=0 ps=0 w=2u l=0.28u
X756 VDD VDD VDD VDD pfet_03v3 ad=0.52p pd=2.52u as=0 ps=0 w=2u l=0.5u
X757 VDD lvds_lane_0.d2b.0 lvds_lane_0.d2a.0 VDD pfet_03v3 ad=0.481p pd=2.37u as=0.481p ps=2.37u w=1.85u l=0.28u
X758 VSS VSS VSS ppolyf_u_1k r_width=2u r_length=21.01u
X759 lvds_lane_1.tp.0 lvds_lane_0.VBP.0 VDD VDD pfet_03v3 ad=1.3p pd=5.52u as=1.3p ps=5.52u w=5u l=1u
X760 lvds_lane_2.tp.0 lvds_lane_0.VREF.0 lvds_lane_2.fb.0 lvds_lane_2.tp.0 pfet_03v3 ad=1.248p pd=5.32u as=1.248p ps=5.32u w=4.8u l=0.4u
X761 VDD VDD VDD VDD pfet_03v3 ad=0.52p pd=2.52u as=0 ps=0 w=2u l=0.5u
X762 lvds_lane_0.fb.0 lvds_lane_0.VREF.0 lvds_lane_0.tp.0 lvds_lane_0.tp.0 pfet_03v3 ad=1.248p pd=5.32u as=1.248p ps=5.32u w=4.8u l=0.4u
X763 VDD lvds_bias_0.enb.0 lvds_bias_0.nrb.0 VDD pfet_03v3 ad=1.3p pd=5.52u as=1.3p ps=5.52u w=5u l=0.5u
X764 lvds_lane_0.d2a.0 VDD VDD VDD pfet_03v3 ad=0.52p pd=2.52u as=0.88p ps=4.88u w=2u l=0.5u
X765 lvds_lane_0.VREF.0 lvds_bias_0.rdb_m1.0 VSS ppolyf_u_1k r_width=2u r_length=19.26u
X766 lvds_lane_2.tp.0 lvds_lane_0.VREF.0 lvds_lane_2.fb.0 lvds_lane_2.tp.0 pfet_03v3 ad=1.248p pd=5.32u as=1.248p ps=5.32u w=4.8u l=0.4u
X767 lvds_lane_0.fa.0 lvds_lane_0.VBN.0 VSS VSS nfet_03v3 ad=0.65p pd=3.02u as=0.65p ps=3.02u w=2.5u l=1u
X768 lvds_lane_2.oa.0 lvds_lane_0.VREF.0 lvds_lane_2.tn.0 VSS nfet_03v3 ad=1.235p pd=5.27u as=1.235p ps=5.27u w=4.75u l=0.5u
X769 VSS lvds_lane_0.VBN.0 lvds_lane_0.ts.0 VSS nfet_03v3 ad=0.65p pd=3.02u as=0.65p ps=3.02u w=2.5u l=1u
X770 lvds_lane_0.tp.0 lvds_lane_0.gp.0 lvds_lane_0.fa.0 lvds_lane_0.tp.0 pfet_03v3 ad=1.248p pd=5.32u as=1.248p ps=5.32u w=4.8u l=0.4u
X771 lvds_lane_1.tp.0 lvds_lane_1.gp.0 lvds_lane_1.fa.0 lvds_lane_1.tp.0 pfet_03v3 ad=1.248p pd=5.32u as=1.248p ps=5.32u w=4.8u l=0.4u
X772 lvds_lane_2.fb.0 lvds_lane_0.VREF.0 lvds_lane_2.tp.0 lvds_lane_2.tp.0 pfet_03v3 ad=1.248p pd=5.32u as=1.248p ps=5.32u w=4.8u l=0.4u
X773 lvds_lane_1.fb.0 lvds_lane_0.VREF.0 lvds_lane_1.tp.0 lvds_lane_1.tp.0 pfet_03v3 ad=1.248p pd=5.32u as=1.248p ps=5.32u w=4.8u l=0.4u
X774 lvds_lane_1.ob.0 lvds_lane_1.gn.0 lvds_lane_1.tn.0 VSS nfet_03v3 ad=1.235p pd=5.27u as=1.235p ps=5.27u w=4.75u l=0.5u
X775 lvds_lane_2.d3.0 lvds_lane_2.d2b.0 VDD VDD pfet_03v3 ad=0.481p pd=2.37u as=0.481p ps=2.37u w=1.85u l=0.28u
X776 VDD lvds_lane_0.VBP.0 lvds_lane_2.tp.0 VDD pfet_03v3 ad=1.3p pd=5.52u as=1.3p ps=5.52u w=5u l=1u
X777 lvds_lane_2.fb.0 lvds_lane_2.gn.0 lvds_lane_2.tp.0 lvds_lane_2.tp.0 pfet_03v3 ad=1.248p pd=5.32u as=1.248p ps=5.32u w=4.8u l=0.4u
X778 lvds_lane_0.d3.0 lvds_lane_0.d2b.0 VDD VDD pfet_03v3 ad=0.481p pd=2.37u as=0.481p ps=2.37u w=1.85u l=0.28u
X779 lvds_lane_2.ob.0 lvds_lane_0.VREF.0 lvds_lane_2.tn.0 VSS nfet_03v3 ad=1.235p pd=5.27u as=1.235p ps=5.27u w=4.75u l=0.5u
X780 VDD lvds_lane_2.d2b.0 lvds_lane_2.d2b.0 VDD pfet_03v3 ad=0.481p pd=2.37u as=0.481p ps=2.37u w=1.85u l=0.28u
X781 VDD VDD RX0_O VDD pfet_03v3 ad=2.2p pd=10.88u as=1.3p ps=5.52u w=5u l=0.28u
D9 VSS lvds_lane_2.gp.0 diode_nd2ps_03v3 pj=26u area=40p
X782 lvds_lane_1.oa.0 lvds_lane_1.gp.0 lvds_lane_1.tn.0 VSS nfet_03v3 ad=1.235p pd=5.27u as=1.235p ps=5.27u w=4.75u l=0.5u
X783 VSS lvds_lane_0.VBN.0 lvds_lane_0.fa.0 VSS nfet_03v3 ad=0.65p pd=3.02u as=0.65p ps=3.02u w=2.5u l=1u
X784 lvds_lane_1.fa.0 lvds_lane_0.VB2.0 lvds_lane_1.oa.0 VSS nfet_03v3 ad=1.1752p pd=5.04u as=1.1752p ps=5.04u w=4.52u l=0.5u
X785 VDD VDD VDD VDD pfet_03v3 ad=0.481p pd=2.37u as=0 ps=0 w=1.85u l=0.28u
X786 VSS VSS lvds_lane_0.tn.0 VSS nfet_03v3 ad=1.1p pd=5.88u as=0.65p ps=3.02u w=2.5u l=1u
X787 lvds_lane_0.nd.0 VSS VSS VSS nfet_03v3 ad=0.52p pd=2.52u as=0.88p ps=4.88u w=2u l=0.28u
X788 lvds_lane_1.d2b.0 VSS VSS VSS nfet_03v3 ad=1.1362p pd=4.89u as=1.9228p ps=9.62u w=4.37u l=0.5u
X789 lvds_lane_2.ts.0 lvds_lane_0.VBN.0 VSS VSS nfet_03v3 ad=0.65p pd=3.02u as=0.65p ps=3.02u w=2.5u l=1u
X790 lvds_lane_1.tp.0 lvds_lane_0.VREF.0 lvds_lane_1.fa.0 lvds_lane_1.tp.0 pfet_03v3 ad=1.248p pd=5.32u as=1.248p ps=5.32u w=4.8u l=0.4u
X791 VSS lvds_lane_0.VBN.0 lvds_lane_1.fb.0 VSS nfet_03v3 ad=0.65p pd=3.02u as=0.65p ps=3.02u w=2.5u l=1u
X792 lvds_lane_0.tn.0 lvds_lane_0.VREF.0 lvds_lane_0.ob.0 VSS nfet_03v3 ad=1.235p pd=5.27u as=1.235p ps=5.27u w=4.75u l=0.5u
X793 lvds_lane_0.ob.0 lvds_lane_0.gn.0 lvds_lane_0.tn.0 VSS nfet_03v3 ad=1.235p pd=5.27u as=1.235p ps=5.27u w=4.75u l=0.5u
X794 lvds_lane_1.tn.0 lvds_lane_0.VREF.0 lvds_lane_1.ob.0 VSS nfet_03v3 ad=1.235p pd=5.27u as=1.235p ps=5.27u w=4.75u l=0.5u
X795 lvds_lane_0.tp.0 lvds_lane_0.gn.0 lvds_lane_0.fb.0 lvds_lane_0.tp.0 pfet_03v3 ad=1.248p pd=5.32u as=1.248p ps=5.32u w=4.8u l=0.4u
X796 lvds_lane_1.fa.0 lvds_lane_0.VB2.0 lvds_lane_1.oa.0 VSS nfet_03v3 ad=1.1752p pd=5.04u as=1.1752p ps=5.04u w=4.52u l=0.5u
X797 lvds_lane_2.ts.0 lvds_lane_2.sb.0 VSS ppolyf_u_1k r_width=5u r_length=1.64u
X798 VDD VDD RX2_O VDD pfet_03v3 ad=2.2p pd=10.88u as=1.3p ps=5.52u w=5u l=0.28u
X799 VDD lvds_lane_1.rlb_m1.0 VSS ppolyf_u_1k r_width=2u r_length=9.11u
X800 lvds_lane_2.tp.0 lvds_lane_0.VREF.0 lvds_lane_2.fa.0 lvds_lane_2.tp.0 pfet_03v3 ad=1.248p pd=5.32u as=1.248p ps=5.32u w=4.8u l=0.4u
X801 lvds_lane_2.tn.0 lvds_lane_2.gp.0 lvds_lane_2.oa.0 VSS nfet_03v3 ad=1.235p pd=5.27u as=1.235p ps=5.27u w=4.75u l=0.5u
X802 VSS lvds_lane_0.nd.0 lvds_lane_0.i1.0 VSS nfet_03v3 ad=0.39p pd=2.02u as=0.39p ps=2.02u w=1.5u l=0.28u
X803 VSS EN lvds_lane_0.nm.0 VSS nfet_03v3 ad=0.52p pd=2.52u as=0.52p ps=2.52u w=2u l=0.28u
X804 VDD lvds_lane_0.VBP.0 lvds_lane_1.tp.0 VDD pfet_03v3 ad=1.3p pd=5.52u as=1.3p ps=5.52u w=5u l=1u
X805 VDD lvds_lane_1.d2a.0 lvds_lane_1.n3a.0 VDD pfet_03v3 ad=0.481p pd=2.37u as=0.481p ps=2.37u w=1.85u l=0.28u
X806 lvds_lane_0.i1.0 VDD VDD VDD pfet_03v3 ad=0.962p pd=4.22u as=1.628p ps=8.28u w=3.7u l=0.28u
X807 lvds_lane_1.fb.0 lvds_lane_0.VB2.0 lvds_lane_1.ob.0 VSS nfet_03v3 ad=1.1752p pd=5.04u as=1.1752p ps=5.04u w=4.52u l=0.5u
X808 lvds_lane_0.fb.0 lvds_lane_0.VBN.0 VSS VSS nfet_03v3 ad=0.65p pd=3.02u as=0.65p ps=3.02u w=2.5u l=1u
X809 lvds_lane_0.oa.0 lvds_lane_0.VREF.0 lvds_lane_0.tn.0 VSS nfet_03v3 ad=1.235p pd=5.27u as=1.235p ps=5.27u w=4.75u l=0.5u
X810 lvds_lane_0.ts.0 lvds_lane_0.VBN.0 VSS VSS nfet_03v3 ad=0.65p pd=3.02u as=0.65p ps=3.02u w=2.5u l=1u
X811 lvds_lane_2.tn.0 lvds_lane_2.gn.0 lvds_lane_2.ob.0 VSS nfet_03v3 ad=1.235p pd=5.27u as=1.235p ps=5.27u w=4.75u l=0.5u
X812 VSS VSS VSS ppolyf_u_1k r_width=5u r_length=1.64u
X813 VSS lvds_lane_0.VBN.0 lvds_lane_2.fb.0 VSS nfet_03v3 ad=0.65p pd=3.02u as=0.65p ps=3.02u w=2.5u l=1u
X814 lvds_lane_1.tp.0 lvds_lane_0.VREF.0 lvds_lane_1.fa.0 lvds_lane_1.tp.0 pfet_03v3 ad=1.248p pd=5.32u as=1.248p ps=5.32u w=4.8u l=0.4u
X815 lvds_lane_1.ts.0 lvds_lane_0.VBN.0 VSS VSS nfet_03v3 ad=0.65p pd=3.02u as=0.65p ps=3.02u w=2.5u l=1u
X816 lvds_lane_0.fb.0 lvds_lane_0.gn.0 lvds_lane_0.tp.0 lvds_lane_0.tp.0 pfet_03v3 ad=1.248p pd=5.32u as=1.248p ps=5.32u w=4.8u l=0.4u
X817 lvds_lane_0.tp.0 lvds_lane_0.VREF.0 lvds_lane_0.fb.0 lvds_lane_0.tp.0 pfet_03v3 ad=1.248p pd=5.32u as=1.248p ps=5.32u w=4.8u l=0.4u
X818 lvds_lane_1.tp.0 lvds_lane_0.VREF.0 lvds_lane_1.fb.0 lvds_lane_1.tp.0 pfet_03v3 ad=1.248p pd=5.32u as=1.248p ps=5.32u w=4.8u l=0.4u
X819 lvds_lane_2.tp.0 lvds_lane_2.gp.0 lvds_lane_2.fa.0 lvds_lane_2.tp.0 pfet_03v3 ad=1.248p pd=5.32u as=1.248p ps=5.32u w=4.8u l=0.4u
X820 lvds_lane_2.tn.0 lvds_lane_0.VREF.0 lvds_lane_2.ob.0 VSS nfet_03v3 ad=1.235p pd=5.27u as=1.235p ps=5.27u w=4.75u l=0.5u
X821 lvds_lane_0.d2b.0 lvds_lane_0.d2b.0 VDD VDD pfet_03v3 ad=0.481p pd=2.37u as=0.481p ps=2.37u w=1.85u l=0.28u
X822 lvds_lane_2.tp.0 lvds_lane_2.gn.0 lvds_lane_2.fb.0 lvds_lane_2.tp.0 pfet_03v3 ad=1.248p pd=5.32u as=1.248p ps=5.32u w=4.8u l=0.4u
X823 RX0_O lvds_lane_0.i2.0 VDD VDD pfet_03v3 ad=1.3p pd=5.52u as=1.3p ps=5.52u w=5u l=0.28u
X824 lvds_lane_2.fb.0 lvds_lane_2.gn.0 lvds_lane_2.tp.0 lvds_lane_2.tp.0 pfet_03v3 ad=1.248p pd=5.32u as=1.248p ps=5.32u w=4.8u l=0.4u
X825 lvds_lane_0.tp.0 lvds_lane_0.VBP.0 VDD VDD pfet_03v3 ad=1.3p pd=5.52u as=1.3p ps=5.52u w=5u l=1u
X826 lvds_lane_1.fa.0 lvds_lane_0.VBN.0 VSS VSS nfet_03v3 ad=0.65p pd=3.02u as=0.65p ps=3.02u w=2.5u l=1u
X827 VSS lvds_lane_0.VBN.0 lvds_lane_0.tn.0 VSS nfet_03v3 ad=0.65p pd=3.02u as=0.65p ps=3.02u w=2.5u l=1u
X828 VDD lvds_lane_1.d2b.0 lvds_lane_1.d3.0 VDD pfet_03v3 ad=0.481p pd=2.37u as=0.481p ps=2.37u w=1.85u l=0.28u
X829 lvds_lane_0.tp.0 lvds_lane_0.VREF.0 lvds_lane_0.fa.0 lvds_lane_0.tp.0 pfet_03v3 ad=1.248p pd=5.32u as=1.248p ps=5.32u w=4.8u l=0.4u
X830 lvds_lane_2.sb.0 lvds_lane_2.ob.0 lvds_lane_2.d2b.0 VSS nfet_03v3 ad=1.1362p pd=4.89u as=1.1362p ps=4.89u w=4.37u l=0.5u
X831 lvds_lane_1.tp.0 lvds_lane_1.gn.0 lvds_lane_1.fb.0 lvds_lane_1.tp.0 pfet_03v3 ad=1.248p pd=5.32u as=1.248p ps=5.32u w=4.8u l=0.4u
X832 lvds_lane_2.d2a.0 lvds_lane_2.d2b.0 VDD VDD pfet_03v3 ad=0.481p pd=2.37u as=0.481p ps=2.37u w=1.85u l=0.28u
X833 RX2_O lvds_lane_2.i2.0 VDD VDD pfet_03v3 ad=1.3p pd=5.52u as=1.3p ps=5.52u w=5u l=0.28u
X834 lvds_lane_0.tp.0 lvds_lane_0.VREF.0 lvds_lane_0.fa.0 lvds_lane_0.tp.0 pfet_03v3 ad=1.248p pd=5.32u as=1.248p ps=5.32u w=4.8u l=0.4u
X835 lvds_lane_2.fb.0 lvds_lane_0.VREF.0 lvds_lane_2.tp.0 lvds_lane_2.tp.0 pfet_03v3 ad=1.248p pd=5.32u as=1.248p ps=5.32u w=4.8u l=0.4u
X836 VSS lvds_lane_0.VBN.0 lvds_lane_1.tn.0 VSS nfet_03v3 ad=0.65p pd=3.02u as=0.65p ps=3.02u w=2.5u l=1u
X837 lvds_lane_0.VBP.0 lvds_lane_0.VBN.0 VSS VSS nfet_03v3 ad=0.65p pd=3.02u as=0.65p ps=3.02u w=2.5u l=1u
X838 lvds_lane_2.ob.0 lvds_lane_0.VB2.0 lvds_lane_2.fb.0 VSS nfet_03v3 ad=1.1752p pd=5.04u as=1.1752p ps=5.04u w=4.52u l=0.5u
X839 lvds_lane_0.ts.0 lvds_lane_0.VBN.0 VSS VSS nfet_03v3 ad=0.65p pd=3.02u as=0.65p ps=3.02u w=2.5u l=1u
X840 lvds_lane_1.tn.0 lvds_lane_0.VREF.0 lvds_lane_1.oa.0 VSS nfet_03v3 ad=1.235p pd=5.27u as=1.235p ps=5.27u w=4.75u l=0.5u
X841 lvds_bias_0.rf_m1.0 lvds_bias_0.vf.0 VSS ppolyf_u_1k r_width=2u r_length=23.07u
X842 VSS lvds_lane_0.VBN.0 lvds_lane_2.fa.0 VSS nfet_03v3 ad=0.65p pd=3.02u as=0.65p ps=3.02u w=2.5u l=1u
X843 lvds_lane_0.fa.0 lvds_lane_0.gp.0 lvds_lane_0.tp.0 lvds_lane_0.tp.0 pfet_03v3 ad=1.248p pd=5.32u as=1.248p ps=5.32u w=4.8u l=0.4u
X844 lvds_lane_1.ts.0 VSS VSS VSS nfet_03v3 ad=0.65p pd=3.02u as=1.1p ps=5.88u w=2.5u l=1u
X845 lvds_lane_0.d2b.0 lvds_lane_0.ob.0 lvds_lane_0.sb.0 VSS nfet_03v3 ad=1.1362p pd=4.89u as=1.1362p ps=4.89u w=4.37u l=0.5u
X846 lvds_lane_0.tp.0 lvds_lane_0.VREF.0 lvds_lane_0.fa.0 lvds_lane_0.tp.0 pfet_03v3 ad=1.248p pd=5.32u as=1.248p ps=5.32u w=4.8u l=0.4u
X847 lvds_lane_2.tp.0 lvds_lane_2.gn.0 lvds_lane_2.fb.0 lvds_lane_2.tp.0 pfet_03v3 ad=1.248p pd=5.32u as=1.248p ps=5.32u w=4.8u l=0.4u
X848 lvds_lane_0.fa.0 lvds_lane_0.VBN.0 VSS VSS nfet_03v3 ad=0.65p pd=3.02u as=0.65p ps=3.02u w=2.5u l=1u
X849 lvds_lane_2.ob.0 lvds_lane_0.VB2.0 lvds_lane_2.fb.0 VSS nfet_03v3 ad=1.1752p pd=5.04u as=1.1752p ps=5.04u w=4.52u l=0.5u
X850 lvds_lane_0.d3.0 lvds_lane_0.d2b.0 VDD VDD pfet_03v3 ad=0.481p pd=2.37u as=0.481p ps=2.37u w=1.85u l=0.28u
X851 lvds_lane_0.tn.0 lvds_lane_0.VREF.0 lvds_lane_0.ob.0 VSS nfet_03v3 ad=1.235p pd=5.27u as=2.09p ps=10.38u w=4.75u l=0.5u
X852 lvds_lane_0.tn.0 lvds_lane_0.VREF.0 lvds_lane_0.oa.0 VSS nfet_03v3 ad=1.235p pd=5.27u as=1.235p ps=5.27u w=4.75u l=0.5u
X853 lvds_lane_0.oa.0 lvds_lane_0.rla_m1.0 VSS ppolyf_u_1k r_width=2u r_length=9.11u
X854 lvds_lane_0.fa.0 lvds_lane_0.VREF.0 lvds_lane_0.tp.0 lvds_lane_0.tp.0 pfet_03v3 ad=1.248p pd=5.32u as=1.248p ps=5.32u w=4.8u l=0.4u
X855 VDD VDD VDD VDD pfet_03v3 ad=0.962p pd=4.22u as=0 ps=0 w=3.7u l=0.28u
X856 lvds_lane_2.tp.0 lvds_lane_2.gp.0 lvds_lane_2.fa.0 lvds_lane_2.tp.0 pfet_03v3 ad=1.248p pd=5.32u as=1.248p ps=5.32u w=4.8u l=0.4u
X857 lvds_lane_0.fb.0 lvds_lane_0.VB2.0 lvds_lane_0.ob.0 VSS nfet_03v3 ad=1.1752p pd=5.04u as=1.1752p ps=5.04u w=4.52u l=0.5u
X858 lvds_lane_2.ob.0 VSS VSS VSS nfet_03v3 ad=1.1752p pd=5.04u as=1.9888p ps=9.92u w=4.52u l=0.5u
X859 lvds_lane_0.tp.0 VDD VDD VDD pfet_03v3 ad=1.3p pd=5.52u as=2.2p ps=10.88u w=5u l=1u
X860 lvds_lane_2.tp.0 lvds_lane_0.VREF.0 lvds_lane_2.fa.0 lvds_lane_2.tp.0 pfet_03v3 ad=1.248p pd=5.32u as=1.248p ps=5.32u w=4.8u l=0.4u
X861 lvds_lane_0.d2b.0 lvds_lane_0.d2a.0 VDD VDD pfet_03v3 ad=0.481p pd=2.37u as=0.481p ps=2.37u w=1.85u l=0.28u
X862 VSS lvds_lane_0.VBN.0 lvds_lane_2.fb.0 VSS nfet_03v3 ad=0.65p pd=3.02u as=0.65p ps=3.02u w=2.5u l=1u
X863 lvds_lane_1.tn.0 lvds_lane_0.VBN.0 VSS VSS nfet_03v3 ad=0.65p pd=3.02u as=0.65p ps=3.02u w=2.5u l=1u
X864 lvds_lane_0.fa.0 lvds_lane_0.VREF.0 lvds_lane_0.tp.0 lvds_lane_0.tp.0 pfet_03v3 ad=1.248p pd=5.32u as=1.248p ps=5.32u w=4.8u l=0.4u
X865 lvds_lane_1.tp.0 lvds_lane_1.gp.0 lvds_lane_1.fa.0 lvds_lane_1.tp.0 pfet_03v3 ad=1.248p pd=5.32u as=1.248p ps=5.32u w=4.8u l=0.4u
X866 lvds_lane_0.fb.0 lvds_lane_0.VB2.0 lvds_lane_0.ob.0 VSS nfet_03v3 ad=1.1752p pd=5.04u as=1.1752p ps=5.04u w=4.52u l=0.5u
D10 lvds_lane_1.gp.0 VDD diode_pd2nw_03v3 pj=26u area=40p
X867 VDD lvds_lane_0.VBP.0 lvds_lane_0.VBP.0 VDD pfet_03v3 ad=1.3p pd=5.52u as=1.3p ps=5.52u w=5u l=1u
X868 lvds_lane_1.d2a.0 lvds_lane_1.d2a.0 VDD VDD pfet_03v3 ad=0.481p pd=2.37u as=0.481p ps=2.37u w=1.85u l=0.28u
X869 lvds_lane_1.tn.0 lvds_lane_1.gn.0 lvds_lane_1.ob.0 VSS nfet_03v3 ad=1.235p pd=5.27u as=1.235p ps=5.27u w=4.75u l=0.5u
X870 VDD lvds_lane_0.i1.0 lvds_lane_0.i2.0 VDD pfet_03v3 ad=0.975p pd=4.27u as=0.975p ps=4.27u w=3.75u l=0.28u
X871 lvds_lane_0.tp.0 lvds_lane_0.VREF.0 lvds_lane_0.fb.0 lvds_lane_0.tp.0 pfet_03v3 ad=1.248p pd=5.32u as=1.248p ps=5.32u w=4.8u l=0.4u
X872 lvds_lane_1.fa.0 lvds_lane_1.gp.0 lvds_lane_1.tp.0 lvds_lane_1.tp.0 pfet_03v3 ad=1.248p pd=5.32u as=1.248p ps=5.32u w=4.8u l=0.4u
X873 lvds_lane_2.fa.0 lvds_lane_0.VREF.0 lvds_lane_2.tp.0 lvds_lane_2.tp.0 pfet_03v3 ad=1.248p pd=5.32u as=1.248p ps=5.32u w=4.8u l=0.4u
X874 lvds_lane_0.ob.0 lvds_lane_0.rlb_m1.0 VSS ppolyf_u_1k r_width=2u r_length=9.11u
X875 VDD lvds_lane_1.d2a.0 lvds_lane_1.n3a.0 VDD pfet_03v3 ad=0.481p pd=2.37u as=0.481p ps=2.37u w=1.85u l=0.28u
X876 lvds_lane_1.tp.0 lvds_lane_0.VREF.0 lvds_lane_1.fb.0 lvds_lane_1.tp.0 pfet_03v3 ad=1.248p pd=5.32u as=1.248p ps=5.32u w=4.8u l=0.4u
X877 lvds_lane_1.tn.0 lvds_lane_0.VREF.0 lvds_lane_1.oa.0 VSS nfet_03v3 ad=1.235p pd=5.27u as=1.235p ps=5.27u w=4.75u l=0.5u
X878 lvds_lane_1.d2b.0 lvds_lane_1.d2a.0 VDD VDD pfet_03v3 ad=0.481p pd=2.37u as=0.481p ps=2.37u w=1.85u l=0.28u
X879 VSS VSS VSS VSS nfet_03v3 ad=0.52p pd=2.52u as=0 ps=0 w=2u l=0.5u
X880 lvds_lane_2.tn.0 lvds_lane_0.VBN.0 VSS VSS nfet_03v3 ad=0.65p pd=3.02u as=0.65p ps=3.02u w=2.5u l=1u
X881 VDD VDD lvds_lane_2.n3a.0 VDD pfet_03v3 ad=0.814p pd=4.58u as=0.481p ps=2.37u w=1.85u l=0.28u
X882 lvds_lane_2.fb.0 lvds_lane_0.VBN.0 VSS VSS nfet_03v3 ad=0.65p pd=3.02u as=0.65p ps=3.02u w=2.5u l=1u
X883 lvds_lane_2.d2b.0 VDD VDD VDD pfet_03v3 ad=0.52p pd=2.52u as=0.88p ps=4.88u w=2u l=0.5u
X884 VSS lvds_lane_0.VBN.0 lvds_lane_1.ts.0 VSS nfet_03v3 ad=0.65p pd=3.02u as=0.65p ps=3.02u w=2.5u l=1u
X885 lvds_lane_1.fa.0 lvds_lane_1.gp.0 lvds_lane_1.tp.0 lvds_lane_1.tp.0 pfet_03v3 ad=1.248p pd=5.32u as=1.248p ps=5.32u w=4.8u l=0.4u
X886 VDD lvds_bias_0.enb.0 lvds_bias_0.nrb.0 VDD pfet_03v3 ad=1.3p pd=5.52u as=1.3p ps=5.52u w=5u l=0.5u
X887 VDD VDD lvds_bias_0.nrb.0 VDD pfet_03v3 ad=2.2p pd=10.88u as=1.3p ps=5.52u w=5u l=0.5u
X888 VSS VSS lvds_lane_2.d3.0 VSS nfet_03v3 ad=2.0504p pd=10.2u as=1.2116p ps=5.18u w=4.66u l=0.28u
X889 lvds_lane_0.VB2.0 VSS VSS VSS nfet_03v3 ad=0.52p pd=2.52u as=0.88p ps=4.88u w=2u l=0.5u
X890 lvds_lane_0.fb.0 lvds_lane_0.VBN.0 VSS VSS nfet_03v3 ad=0.65p pd=3.02u as=0.65p ps=3.02u w=2.5u l=1u
X891 lvds_lane_0.VREF.0 lvds_bias_0.rdt_m3.0 VSS ppolyf_u_1k r_width=2u r_length=21.01u
X892 lvds_lane_0.fb.0 lvds_lane_0.VREF.0 lvds_lane_0.tp.0 lvds_lane_0.tp.0 pfet_03v3 ad=1.248p pd=5.32u as=1.248p ps=5.32u w=4.8u l=0.4u
X893 lvds_lane_1.fb.0 lvds_lane_0.VREF.0 lvds_lane_1.tp.0 lvds_lane_1.tp.0 pfet_03v3 ad=1.248p pd=5.32u as=1.248p ps=5.32u w=4.8u l=0.4u
X894 lvds_lane_2.tp.0 lvds_lane_2.gn.0 lvds_lane_2.fb.0 lvds_lane_2.tp.0 pfet_03v3 ad=1.248p pd=5.32u as=1.248p ps=5.32u w=4.8u l=0.4u
X895 lvds_lane_1.ob.0 lvds_lane_1.gn.0 lvds_lane_1.tn.0 VSS nfet_03v3 ad=1.235p pd=5.27u as=1.235p ps=5.27u w=4.75u l=0.5u
X896 VDD lvds_lane_0.d2a.0 lvds_lane_0.d2b.0 VDD pfet_03v3 ad=0.481p pd=2.37u as=0.481p ps=2.37u w=1.85u l=0.28u
X897 VDD lvds_bias_0.enb.0 lvds_bias_0.nrb.0 VDD pfet_03v3 ad=1.3p pd=5.52u as=1.3p ps=5.52u w=5u l=0.5u
X898 lvds_lane_2.oa.0 lvds_lane_0.VREF.0 lvds_lane_2.tn.0 VSS nfet_03v3 ad=1.235p pd=5.27u as=1.235p ps=5.27u w=4.75u l=0.5u
X899 lvds_lane_1.d2a.0 lvds_lane_1.oa.0 lvds_lane_1.sa.0 VSS nfet_03v3 ad=1.1362p pd=4.89u as=1.1362p ps=4.89u w=4.37u l=0.5u
X900 VDD lvds_lane_0.VBP.0 lvds_lane_0.tp.0 VDD pfet_03v3 ad=1.3p pd=5.52u as=1.3p ps=5.52u w=5u l=1u
X901 lvds_lane_1.tp.0 lvds_lane_1.gp.0 lvds_lane_1.fa.0 lvds_lane_1.tp.0 pfet_03v3 ad=1.248p pd=5.32u as=1.248p ps=5.32u w=4.8u l=0.4u
X902 lvds_lane_0.tn.0 lvds_lane_0.VREF.0 lvds_lane_0.oa.0 VSS nfet_03v3 ad=1.235p pd=5.27u as=1.235p ps=5.27u w=4.75u l=0.5u
X903 VSS lvds_lane_0.VBN.0 lvds_lane_1.tn.0 VSS nfet_03v3 ad=0.65p pd=3.02u as=0.65p ps=3.02u w=2.5u l=1u
X904 lvds_lane_1.ob.0 lvds_lane_1.gn.0 lvds_lane_1.tn.0 VSS nfet_03v3 ad=1.235p pd=5.27u as=1.235p ps=5.27u w=4.75u l=0.5u
X905 lvds_lane_0.VBN.0 VSS VSS VSS nfet_03v3 ad=0.65p pd=3.02u as=1.1p ps=5.88u w=2.5u l=1u
X906 VDD lvds_lane_0.VBP.0 lvds_lane_1.tp.0 VDD pfet_03v3 ad=1.3p pd=5.52u as=1.3p ps=5.52u w=5u l=1u
X907 lvds_lane_2.fb.0 lvds_lane_0.VREF.0 lvds_lane_2.tp.0 lvds_lane_2.tp.0 pfet_03v3 ad=1.248p pd=5.32u as=1.248p ps=5.32u w=4.8u l=0.4u
X908 VSS lvds_lane_0.VBN.0 lvds_lane_2.fa.0 VSS nfet_03v3 ad=0.65p pd=3.02u as=0.65p ps=3.02u w=2.5u l=1u
X909 VDD lvds_lane_2.d2b.0 lvds_lane_2.d2a.0 VDD pfet_03v3 ad=0.481p pd=2.37u as=0.481p ps=2.37u w=1.85u l=0.28u
X910 lvds_lane_0.n3a.0 lvds_lane_0.d2a.0 VDD VDD pfet_03v3 ad=0.481p pd=2.37u as=0.481p ps=2.37u w=1.85u l=0.28u
X911 VSS VSS VSS ppolyf_u_1k r_width=2u r_length=9.11u
X912 lvds_lane_0.VBP.0 lvds_lane_0.VBP.0 VDD VDD pfet_03v3 ad=1.3p pd=5.52u as=1.3p ps=5.52u w=5u l=1u
X913 lvds_lane_2.nm.0 lvds_lane_2.d3.0 lvds_lane_2.nd.0 VSS nfet_03v3 ad=0.52p pd=2.52u as=0.52p ps=2.52u w=2u l=0.28u
X914 lvds_lane_2.i2.0 VDD VDD VDD pfet_03v3 ad=0.975p pd=4.27u as=1.65p ps=8.38u w=3.75u l=0.28u
X915 lvds_lane_0.tp.0 lvds_lane_0.VBP.0 VDD VDD pfet_03v3 ad=1.3p pd=5.52u as=1.3p ps=5.52u w=5u l=1u
X916 lvds_lane_1.n3a.0 lvds_lane_1.d2a.0 VDD VDD pfet_03v3 ad=0.481p pd=2.37u as=0.481p ps=2.37u w=1.85u l=0.28u
X917 VDD lvds_lane_0.d2a.0 lvds_lane_0.d2a.0 VDD pfet_03v3 ad=0.481p pd=2.37u as=0.481p ps=2.37u w=1.85u l=0.28u
X918 lvds_lane_0.fb.0 lvds_lane_0.gn.0 lvds_lane_0.tp.0 lvds_lane_0.tp.0 pfet_03v3 ad=1.248p pd=5.32u as=1.248p ps=5.32u w=4.8u l=0.4u
X919 lvds_lane_1.fa.0 lvds_lane_0.VBN.0 VSS VSS nfet_03v3 ad=0.65p pd=3.02u as=0.65p ps=3.02u w=2.5u l=1u
X920 lvds_lane_0.tn.0 lvds_lane_0.VREF.0 lvds_lane_0.ob.0 VSS nfet_03v3 ad=1.235p pd=5.27u as=1.235p ps=5.27u w=4.75u l=0.5u
X921 lvds_lane_1.oa.0 lvds_lane_1.gp.0 lvds_lane_1.tn.0 VSS nfet_03v3 ad=1.235p pd=5.27u as=1.235p ps=5.27u w=4.75u l=0.5u
X922 VSS lvds_lane_0.n3a.0 lvds_lane_0.n3a.0 VSS nfet_03v3 ad=1.2116p pd=5.18u as=1.2116p ps=5.18u w=4.66u l=0.28u
X923 lvds_lane_1.fa.0 lvds_lane_0.VB2.0 lvds_lane_1.oa.0 VSS nfet_03v3 ad=1.1752p pd=5.04u as=1.1752p ps=5.04u w=4.52u l=0.5u
X924 lvds_lane_0.fa.0 lvds_lane_0.gp.0 lvds_lane_0.tp.0 lvds_lane_0.tp.0 pfet_03v3 ad=1.248p pd=5.32u as=1.248p ps=5.32u w=4.8u l=0.4u
X925 lvds_lane_1.tp.0 lvds_lane_0.VREF.0 lvds_lane_1.fa.0 lvds_lane_1.tp.0 pfet_03v3 ad=1.248p pd=5.32u as=1.248p ps=5.32u w=4.8u l=0.4u
X926 lvds_lane_2.tp.0 lvds_lane_0.VREF.0 lvds_lane_2.fa.0 lvds_lane_2.tp.0 pfet_03v3 ad=1.248p pd=5.32u as=1.248p ps=5.32u w=4.8u l=0.4u
X927 lvds_lane_1.tn.0 lvds_lane_0.VBN.0 VSS VSS nfet_03v3 ad=0.65p pd=3.02u as=0.65p ps=3.02u w=2.5u l=1u
X928 lvds_lane_0.tp.0 lvds_lane_0.gn.0 lvds_lane_0.fb.0 lvds_lane_0.tp.0 pfet_03v3 ad=1.248p pd=5.32u as=1.248p ps=5.32u w=4.8u l=0.4u
X929 lvds_lane_1.d2b.0 lvds_lane_1.d2a.0 VDD VDD pfet_03v3 ad=0.481p pd=2.37u as=0.481p ps=2.37u w=1.85u l=0.28u
X930 VDD lvds_lane_0.VBP.0 lvds_lane_2.tp.0 VDD pfet_03v3 ad=1.3p pd=5.52u as=1.3p ps=5.52u w=5u l=1u
X931 lvds_lane_2.fb.0 lvds_lane_2.gn.0 lvds_lane_2.tp.0 lvds_lane_2.tp.0 pfet_03v3 ad=1.248p pd=5.32u as=1.248p ps=5.32u w=4.8u l=0.4u
X932 lvds_lane_1.fa.0 lvds_lane_0.VB2.0 lvds_lane_1.oa.0 VSS nfet_03v3 ad=1.1752p pd=5.04u as=1.1752p ps=5.04u w=4.52u l=0.5u
X933 lvds_lane_2.tn.0 VSS VSS VSS nfet_03v3 ad=0.65p pd=3.02u as=1.1p ps=5.88u w=2.5u l=1u
X934 VDD VDD lvds_lane_2.tp.0 VDD pfet_03v3 ad=2.2p pd=10.88u as=1.3p ps=5.52u w=5u l=1u
X935 lvds_lane_2.tp.0 lvds_lane_0.VREF.0 lvds_lane_2.fa.0 lvds_lane_2.tp.0 pfet_03v3 ad=1.248p pd=5.32u as=1.248p ps=5.32u w=4.8u l=0.4u
X936 VDD VDD lvds_lane_1.i2.0 VDD pfet_03v3 ad=1.65p pd=8.38u as=0.975p ps=4.27u w=3.75u l=0.28u
X937 lvds_lane_0.gn.0 RX0_N VDD ppolyf_u r_width=5u r_length=1.8u
X938 lvds_lane_2.tn.0 lvds_lane_2.gp.0 lvds_lane_2.oa.0 VSS nfet_03v3 ad=1.235p pd=5.27u as=1.235p ps=5.27u w=4.75u l=0.5u
X939 VDD lvds_lane_1.d2b.0 lvds_lane_1.d3.0 VDD pfet_03v3 ad=0.481p pd=2.37u as=0.481p ps=2.37u w=1.85u l=0.28u
X940 VDD lvds_lane_1.rla_m1.0 VSS ppolyf_u_1k r_width=2u r_length=9.11u
X941 VSS lvds_lane_0.VBN.0 lvds_lane_0.fb.0 VSS nfet_03v3 ad=0.65p pd=3.02u as=0.65p ps=3.02u w=2.5u l=1u
X942 lvds_lane_0.nd.0 EN VDD VDD pfet_03v3 ad=0.78p pd=3.52u as=0.78p ps=3.52u w=3u l=0.28u
X943 lvds_lane_1.d2a.0 lvds_lane_1.d2a.0 VDD VDD pfet_03v3 ad=0.481p pd=2.37u as=0.481p ps=2.37u w=1.85u l=0.28u
X944 VSS lvds_lane_0.VBN.0 lvds_lane_1.fa.0 VSS nfet_03v3 ad=0.65p pd=3.02u as=0.65p ps=3.02u w=2.5u l=1u
X945 VDD lvds_lane_2.d2b.0 lvds_lane_2.d3.0 VDD pfet_03v3 ad=0.481p pd=2.37u as=0.481p ps=2.37u w=1.85u l=0.28u
X946 lvds_lane_0.VBN.0 lvds_lane_0.VBN.0 VSS VSS nfet_03v3 ad=0.65p pd=3.02u as=0.65p ps=3.02u w=2.5u l=1u
X947 lvds_lane_2.d2a.0 lvds_lane_2.d2b.0 VDD VDD pfet_03v3 ad=0.481p pd=2.37u as=0.481p ps=2.37u w=1.85u l=0.28u
X948 VDD lvds_lane_0.d2b.0 lvds_lane_0.d3.0 VDD pfet_03v3 ad=0.481p pd=2.37u as=0.481p ps=2.37u w=1.85u l=0.28u
X949 lvds_lane_1.tp.0 lvds_lane_0.VREF.0 lvds_lane_1.fb.0 lvds_lane_1.tp.0 pfet_03v3 ad=1.248p pd=5.32u as=2.112p ps=10.48u w=4.8u l=0.4u
X950 lvds_lane_1.fa.0 lvds_lane_1.gp.0 lvds_lane_1.tp.0 lvds_lane_1.tp.0 pfet_03v3 ad=1.248p pd=5.32u as=1.248p ps=5.32u w=4.8u l=0.4u
X951 lvds_lane_1.tp.0 lvds_lane_0.VBP.0 VDD VDD pfet_03v3 ad=1.3p pd=5.52u as=1.3p ps=5.52u w=5u l=1u
X952 lvds_lane_0.VBP.0 lvds_lane_0.VBP.0 VDD VDD pfet_03v3 ad=1.3p pd=5.52u as=1.3p ps=5.52u w=5u l=1u
X953 lvds_lane_2.fa.0 lvds_lane_0.VREF.0 lvds_lane_2.tp.0 lvds_lane_2.tp.0 pfet_03v3 ad=1.248p pd=5.32u as=1.248p ps=5.32u w=4.8u l=0.4u
X954 lvds_lane_2.fb.0 lvds_lane_0.VBN.0 VSS VSS nfet_03v3 ad=0.65p pd=3.02u as=0.65p ps=3.02u w=2.5u l=1u
X955 lvds_lane_2.tp.0 lvds_lane_0.VBP.0 VDD VDD pfet_03v3 ad=1.3p pd=5.52u as=1.3p ps=5.52u w=5u l=1u
X956 lvds_lane_2.fa.0 lvds_lane_2.gp.0 lvds_lane_2.tp.0 lvds_lane_2.tp.0 pfet_03v3 ad=1.248p pd=5.32u as=1.248p ps=5.32u w=4.8u l=0.4u
X957 lvds_lane_2.tn.0 lvds_lane_2.gp.0 lvds_lane_2.oa.0 VSS nfet_03v3 ad=1.235p pd=5.27u as=1.235p ps=5.27u w=4.75u l=0.5u
X958 lvds_lane_0.tp.0 lvds_lane_0.VBP.0 VDD VDD pfet_03v3 ad=1.3p pd=5.52u as=1.3p ps=5.52u w=5u l=1u
X959 VDD VDD VDD VDD pfet_03v3 ad=0.52p pd=2.52u as=0 ps=0 w=2u l=0.5u
X960 VDD lvds_lane_1.d2b.0 lvds_lane_1.d2a.0 VDD pfet_03v3 ad=0.481p pd=2.37u as=0.481p ps=2.37u w=1.85u l=0.28u
X961 lvds_lane_1.tp.0 lvds_lane_0.VREF.0 lvds_lane_1.fb.0 lvds_lane_1.tp.0 pfet_03v3 ad=1.248p pd=5.32u as=1.248p ps=5.32u w=4.8u l=0.4u
X962 lvds_lane_2.tn.0 lvds_lane_2.gp.0 lvds_lane_2.oa.0 VSS nfet_03v3 ad=1.235p pd=5.27u as=1.235p ps=5.27u w=4.75u l=0.5u
X963 VDD VDD VDD VDD pfet_03v3 ad=0.814p pd=4.58u as=0 ps=0 w=1.85u l=0.28u
X964 lvds_lane_0.VBP.0 lvds_lane_0.VBP.0 VDD VDD pfet_03v3 ad=1.3p pd=5.52u as=1.3p ps=5.52u w=5u l=1u
X965 lvds_lane_0.tp.0 lvds_lane_0.gp.0 lvds_lane_0.fa.0 lvds_lane_0.tp.0 pfet_03v3 ad=1.248p pd=5.32u as=1.248p ps=5.32u w=4.8u l=0.4u
X966 lvds_lane_2.fa.0 lvds_lane_2.gp.0 lvds_lane_2.tp.0 lvds_lane_2.tp.0 pfet_03v3 ad=1.248p pd=5.32u as=1.248p ps=5.32u w=4.8u l=0.4u
X967 VSS VSS lvds_lane_2.fa.0 VSS nfet_03v3 ad=1.1p pd=5.88u as=0.65p ps=3.02u w=2.5u l=1u
X968 lvds_lane_0.fb.0 lvds_lane_0.VREF.0 lvds_lane_0.tp.0 lvds_lane_0.tp.0 pfet_03v3 ad=1.248p pd=5.32u as=1.248p ps=5.32u w=4.8u l=0.4u
X969 lvds_lane_1.fb.0 lvds_lane_0.VREF.0 lvds_lane_1.tp.0 lvds_lane_1.tp.0 pfet_03v3 ad=1.248p pd=5.32u as=1.248p ps=5.32u w=4.8u l=0.4u
X970 lvds_lane_0.ob.0 lvds_lane_0.gn.0 lvds_lane_0.tn.0 VSS nfet_03v3 ad=1.235p pd=5.27u as=1.235p ps=5.27u w=4.75u l=0.5u
X971 VSS lvds_lane_0.VBN.0 lvds_lane_2.tn.0 VSS nfet_03v3 ad=0.65p pd=3.02u as=0.65p ps=3.02u w=2.5u l=1u
X972 lvds_lane_1.d3.0 lvds_lane_1.d2b.0 VDD VDD pfet_03v3 ad=0.481p pd=2.37u as=0.481p ps=2.37u w=1.85u l=0.28u
X973 lvds_lane_1.tp.0 lvds_lane_0.VREF.0 lvds_lane_1.fb.0 lvds_lane_1.tp.0 pfet_03v3 ad=1.248p pd=5.32u as=1.248p ps=5.32u w=4.8u l=0.4u
X974 lvds_lane_2.tp.0 lvds_lane_2.gn.0 lvds_lane_2.fb.0 lvds_lane_2.tp.0 pfet_03v3 ad=1.248p pd=5.32u as=1.248p ps=5.32u w=4.8u l=0.4u
X975 lvds_lane_0.VBP.0 VDD VDD VDD pfet_03v3 ad=0.52p pd=2.52u as=0.88p ps=4.88u w=2u l=0.5u
X976 lvds_lane_2.tn.0 lvds_lane_2.gn.0 lvds_lane_2.ob.0 VSS nfet_03v3 ad=1.235p pd=5.27u as=1.235p ps=5.27u w=4.75u l=0.5u
X977 VDD lvds_lane_1.d2b.0 lvds_lane_1.d2b.0 VDD pfet_03v3 ad=0.481p pd=2.37u as=0.481p ps=2.37u w=1.85u l=0.28u
X978 VDD lvds_lane_0.VBP.0 lvds_lane_2.tp.0 VDD pfet_03v3 ad=1.3p pd=5.52u as=1.3p ps=5.52u w=5u l=1u
X979 lvds_lane_2.d3.0 lvds_lane_2.d2b.0 VDD VDD pfet_03v3 ad=0.481p pd=2.37u as=0.481p ps=2.37u w=1.85u l=0.28u
D11 VSS lvds_lane_1.gp.0 diode_nd2ps_03v3 pj=26u area=40p
X980 lvds_lane_2.fb.0 lvds_lane_2.gn.0 lvds_lane_2.tp.0 lvds_lane_2.tp.0 pfet_03v3 ad=1.248p pd=5.32u as=1.248p ps=5.32u w=4.8u l=0.4u
X981 VSS VSS lvds_lane_2.fb.0 VSS nfet_03v3 ad=1.9888p pd=9.92u as=1.1752p ps=5.04u w=4.52u l=0.5u
X982 lvds_lane_0.oa.0 lvds_lane_0.gp.0 lvds_lane_0.tn.0 VSS nfet_03v3 ad=1.235p pd=5.27u as=1.235p ps=5.27u w=4.75u l=0.5u
X983 lvds_lane_2.n3a.0 VSS VSS VSS nfet_03v3 ad=1.2116p pd=5.18u as=2.0504p ps=10.2u w=4.66u l=0.28u
X984 VSS VSS lvds_lane_2.d2a.0 VSS nfet_03v3 ad=1.9228p pd=9.62u as=1.1362p ps=4.89u w=4.37u l=0.5u
X985 lvds_lane_0.fa.0 lvds_lane_0.VB2.0 lvds_lane_0.oa.0 VSS nfet_03v3 ad=1.1752p pd=5.04u as=1.1752p ps=5.04u w=4.52u l=0.5u
X986 lvds_lane_1.fb.0 lvds_lane_0.VBN.0 VSS VSS nfet_03v3 ad=0.65p pd=3.02u as=0.65p ps=3.02u w=2.5u l=1u
X987 lvds_lane_0.d2b.0 VSS VSS VSS nfet_03v3 ad=1.1362p pd=4.89u as=1.9228p ps=9.62u w=4.37u l=0.5u
X988 lvds_lane_0.tp.0 lvds_lane_0.VREF.0 lvds_lane_0.fa.0 lvds_lane_0.tp.0 pfet_03v3 ad=1.248p pd=5.32u as=1.248p ps=5.32u w=4.8u l=0.4u
X989 VSS lvds_lane_0.VBN.0 lvds_lane_0.fb.0 VSS nfet_03v3 ad=0.65p pd=3.02u as=0.65p ps=3.02u w=2.5u l=1u
X990 lvds_lane_2.oa.0 lvds_lane_0.VREF.0 lvds_lane_2.tn.0 VSS nfet_03v3 ad=1.235p pd=5.27u as=1.235p ps=5.27u w=4.75u l=0.5u
X991 lvds_lane_0.tn.0 lvds_lane_0.VREF.0 lvds_lane_0.ob.0 VSS nfet_03v3 ad=1.235p pd=5.27u as=1.235p ps=5.27u w=4.75u l=0.5u
X992 lvds_lane_2.ts.0 lvds_lane_0.VBN.0 VSS VSS nfet_03v3 ad=0.65p pd=3.02u as=0.65p ps=3.02u w=2.5u l=1u
X993 VDD lvds_lane_0.VBP.0 lvds_lane_0.VBP.0 VDD pfet_03v3 ad=1.3p pd=5.52u as=1.3p ps=5.52u w=5u l=1u
X994 lvds_lane_2.tp.0 lvds_lane_2.gn.0 lvds_lane_2.fb.0 lvds_lane_2.tp.0 pfet_03v3 ad=1.248p pd=5.32u as=1.248p ps=5.32u w=4.8u l=0.4u
X995 lvds_lane_0.fa.0 lvds_lane_0.VB2.0 lvds_lane_0.oa.0 VSS nfet_03v3 ad=1.1752p pd=5.04u as=1.1752p ps=5.04u w=4.52u l=0.5u
X996 VDD VDD VDD VDD pfet_03v3 ad=0.65p pd=3.02u as=0 ps=0 w=2.5u l=0.28u
X997 VDD lvds_lane_0.rlb_m1.0 VSS ppolyf_u_1k r_width=2u r_length=9.11u
X998 lvds_lane_0.gp.0 RX0_P VDD ppolyf_u r_width=5u r_length=1.8u
X999 VDD lvds_lane_0.VBP.0 lvds_lane_2.tp.0 VDD pfet_03v3 ad=1.3p pd=5.52u as=1.3p ps=5.52u w=5u l=1u
X1000 lvds_lane_2.fb.0 lvds_lane_2.gn.0 lvds_lane_2.tp.0 lvds_lane_2.tp.0 pfet_03v3 ad=1.248p pd=5.32u as=1.248p ps=5.32u w=4.8u l=0.4u
X1001 lvds_lane_1.tn.0 lvds_lane_1.gp.0 lvds_lane_1.oa.0 VSS nfet_03v3 ad=1.235p pd=5.27u as=1.235p ps=5.27u w=4.75u l=0.5u
X1002 VDD lvds_lane_0.VBP.0 lvds_lane_0.tp.0 VDD pfet_03v3 ad=1.3p pd=5.52u as=1.3p ps=5.52u w=5u l=1u
X1003 lvds_lane_2.ob.0 lvds_lane_0.VREF.0 lvds_lane_2.tn.0 VSS nfet_03v3 ad=1.235p pd=5.27u as=1.235p ps=5.27u w=4.75u l=0.5u
X1004 VSS lvds_lane_0.VBN.0 lvds_lane_1.fb.0 VSS nfet_03v3 ad=0.65p pd=3.02u as=0.65p ps=3.02u w=2.5u l=1u
X1005 lvds_lane_2.d2b.0 lvds_lane_2.d2b.0 VDD VDD pfet_03v3 ad=0.481p pd=2.37u as=0.481p ps=2.37u w=1.85u l=0.28u
X1006 VDD lvds_lane_0.d2a.0 lvds_lane_0.n3a.0 VDD pfet_03v3 ad=0.481p pd=2.37u as=0.481p ps=2.37u w=1.85u l=0.28u
X1007 lvds_lane_0.fb.0 lvds_lane_0.VB2.0 lvds_lane_0.ob.0 VSS nfet_03v3 ad=1.1752p pd=5.04u as=1.1752p ps=5.04u w=4.52u l=0.5u
X1008 lvds_lane_1.tn.0 lvds_lane_1.gn.0 lvds_lane_1.ob.0 VSS nfet_03v3 ad=1.235p pd=5.27u as=1.235p ps=5.27u w=4.75u l=0.5u
X1009 lvds_lane_2.oa.0 lvds_lane_0.VREF.0 lvds_lane_2.tn.0 VSS nfet_03v3 ad=1.235p pd=5.27u as=1.235p ps=5.27u w=4.75u l=0.5u
X1010 VDD lvds_lane_2.d2a.0 lvds_lane_2.d2a.0 VDD pfet_03v3 ad=0.481p pd=2.37u as=0.481p ps=2.37u w=1.85u l=0.28u
X1011 lvds_lane_0.VBN.0 lvds_lane_0.VBN.0 VSS VSS nfet_03v3 ad=0.65p pd=3.02u as=0.65p ps=3.02u w=2.5u l=1u
X1012 lvds_lane_0.tp.0 lvds_lane_0.VREF.0 lvds_lane_0.fa.0 lvds_lane_0.tp.0 pfet_03v3 ad=1.248p pd=5.32u as=1.248p ps=5.32u w=4.8u l=0.4u
X1013 lvds_lane_1.tp.0 lvds_lane_1.gp.0 lvds_lane_1.fa.0 lvds_lane_1.tp.0 pfet_03v3 ad=1.248p pd=5.32u as=1.248p ps=5.32u w=4.8u l=0.4u
X1014 lvds_lane_0.ts.0 lvds_lane_0.VBN.0 VSS VSS nfet_03v3 ad=0.65p pd=3.02u as=0.65p ps=3.02u w=2.5u l=1u
X1015 lvds_lane_1.nm.0 lvds_lane_1.d3.0 lvds_lane_1.nd.0 VSS nfet_03v3 ad=0.52p pd=2.52u as=0.52p ps=2.52u w=2u l=0.28u
X1016 lvds_lane_2.tp.0 lvds_lane_0.VBP.0 VDD VDD pfet_03v3 ad=1.3p pd=5.52u as=1.3p ps=5.52u w=5u l=1u
X1017 RX1_O lvds_lane_1.i2.0 VSS VSS nfet_03v3 ad=1.04p pd=4.52u as=1.04p ps=4.52u w=4u l=0.28u
X1018 lvds_lane_1.tn.0 lvds_lane_0.VREF.0 lvds_lane_1.ob.0 VSS nfet_03v3 ad=1.235p pd=5.27u as=1.235p ps=5.27u w=4.75u l=0.5u
X1019 lvds_lane_2.tp.0 lvds_lane_0.VBP.0 VDD VDD pfet_03v3 ad=1.3p pd=5.52u as=1.3p ps=5.52u w=5u l=1u
X1020 lvds_lane_0.tp.0 lvds_lane_0.VREF.0 lvds_lane_0.fb.0 lvds_lane_0.tp.0 pfet_03v3 ad=1.248p pd=5.32u as=1.248p ps=5.32u w=4.8u l=0.4u
X1021 lvds_lane_2.fa.0 lvds_lane_2.gp.0 lvds_lane_2.tp.0 lvds_lane_2.tp.0 pfet_03v3 ad=1.248p pd=5.32u as=1.248p ps=5.32u w=4.8u l=0.4u
X1022 lvds_lane_1.fb.0 lvds_lane_1.gn.0 lvds_lane_1.tp.0 lvds_lane_1.tp.0 pfet_03v3 ad=1.248p pd=5.32u as=1.248p ps=5.32u w=4.8u l=0.4u
X1023 lvds_lane_0.fa.0 lvds_lane_0.VBN.0 VSS VSS nfet_03v3 ad=0.65p pd=3.02u as=0.65p ps=3.02u w=2.5u l=1u
X1024 VDD lvds_bias_0.enb.0 lvds_bias_0.nrb.0 VDD pfet_03v3 ad=1.3p pd=5.52u as=1.3p ps=5.52u w=5u l=0.5u
X1025 lvds_lane_2.ob.0 lvds_lane_0.VREF.0 lvds_lane_2.tn.0 VSS nfet_03v3 ad=2.09p pd=10.38u as=1.235p ps=5.27u w=4.75u l=0.5u
X1026 lvds_lane_2.n3a.0 lvds_lane_2.d2a.0 VDD VDD pfet_03v3 ad=0.481p pd=2.37u as=0.481p ps=2.37u w=1.85u l=0.28u
X1027 VDD lvds_lane_0.d2b.0 lvds_lane_0.d3.0 VDD pfet_03v3 ad=0.481p pd=2.37u as=0.481p ps=2.37u w=1.85u l=0.28u
X1028 VSS lvds_lane_0.VBN.0 lvds_lane_2.ts.0 VSS nfet_03v3 ad=0.65p pd=3.02u as=0.65p ps=3.02u w=2.5u l=1u
X1029 lvds_lane_1.oa.0 lvds_lane_1.gp.0 lvds_lane_1.tn.0 VSS nfet_03v3 ad=1.235p pd=5.27u as=1.235p ps=5.27u w=4.75u l=0.5u
X1030 VDD EN lvds_lane_2.d2a.0 VDD pfet_03v3 ad=0.52p pd=2.52u as=0.52p ps=2.52u w=2u l=0.5u
X1031 lvds_lane_0.tp.0 lvds_lane_0.gn.0 lvds_lane_0.fb.0 lvds_lane_0.tp.0 pfet_03v3 ad=1.248p pd=5.32u as=1.248p ps=5.32u w=4.8u l=0.4u
X1032 lvds_lane_1.tp.0 lvds_lane_1.gn.0 lvds_lane_1.fb.0 lvds_lane_1.tp.0 pfet_03v3 ad=1.248p pd=5.32u as=1.248p ps=5.32u w=4.8u l=0.4u
X1033 VDD lvds_lane_1.i2.0 RX1_O VDD pfet_03v3 ad=1.3p pd=5.52u as=1.3p ps=5.52u w=5u l=0.28u
X1034 VDD lvds_lane_0.VBP.0 lvds_lane_2.tp.0 VDD pfet_03v3 ad=1.3p pd=5.52u as=1.3p ps=5.52u w=5u l=1u
X1035 lvds_lane_0.VBP.0 lvds_lane_0.VBP.0 VDD VDD pfet_03v3 ad=1.3p pd=5.52u as=1.3p ps=5.52u w=5u l=1u
X1036 lvds_lane_1.fb.0 lvds_lane_0.VREF.0 lvds_lane_1.tp.0 lvds_lane_1.tp.0 pfet_03v3 ad=1.248p pd=5.32u as=1.248p ps=5.32u w=4.8u l=0.4u
X1037 lvds_lane_2.tp.0 lvds_lane_2.gn.0 lvds_lane_2.fb.0 lvds_lane_2.tp.0 pfet_03v3 ad=1.248p pd=5.32u as=1.248p ps=5.32u w=4.8u l=0.4u
X1038 lvds_lane_1.tp.0 lvds_lane_0.VBP.0 VDD VDD pfet_03v3 ad=1.3p pd=5.52u as=1.3p ps=5.52u w=5u l=1u
X1039 VSS lvds_lane_0.VBN.0 lvds_lane_0.tn.0 VSS nfet_03v3 ad=0.65p pd=3.02u as=0.65p ps=3.02u w=2.5u l=1u
X1040 VSS VSS VSS ppolyf_u_1k r_width=5u r_length=1.64u
X1041 lvds_lane_2.ts.0 lvds_lane_0.VBN.0 VSS VSS nfet_03v3 ad=0.65p pd=3.02u as=0.65p ps=3.02u w=2.5u l=1u
X1042 lvds_lane_0.tn.0 lvds_lane_0.VREF.0 lvds_lane_0.oa.0 VSS nfet_03v3 ad=1.235p pd=5.27u as=1.235p ps=5.27u w=4.75u l=0.5u
X1043 lvds_lane_2.fb.0 lvds_lane_0.VREF.0 lvds_lane_2.tp.0 lvds_lane_2.tp.0 pfet_03v3 ad=2.112p pd=10.48u as=1.248p ps=5.32u w=4.8u l=0.4u
X1044 lvds_lane_0.ts.0 VSS VSS VSS nfet_03v3 ad=0.65p pd=3.02u as=1.1p ps=5.88u w=2.5u l=1u
X1045 lvds_lane_2.fb.0 lvds_lane_2.gn.0 lvds_lane_2.tp.0 lvds_lane_2.tp.0 pfet_03v3 ad=1.248p pd=5.32u as=1.248p ps=5.32u w=4.8u l=0.4u
X1046 VDD VDD VDD VDD pfet_03v3 ad=0.962p pd=4.22u as=0 ps=0 w=3.7u l=0.28u
C0 VDD lvds_lane_0.gp.0 4.52291f
C1 lvds_lane_0.VB2.0 lvds_lane_0.VBP.0 5.49406f
C2 EN lvds_lane_1.d2b.0 0.31138f
C3 lvds_lane_2.d2a.0 lvds_lane_2.d3.0 0.63055f
C4 EN lvds_lane_1.nm.0 0.02238f
C5 lvds_lane_2.oa.0 lvds_lane_2.fa.0 2.94526f
C6 lvds_lane_0.VBP.0 RX1_P 0.03967f
C7 lvds_bias_0.vf.0 lvds_bias_0.rb_m2.0 0.08519f
C8 lvds_lane_0.sa.0 lvds_lane_0.d2a.0 1.67001f
C9 lvds_lane_1.ob.0 lvds_lane_0.VB2.0 0.58885f
C10 lvds_lane_0.tp.0 lvds_lane_0.VREF.0 14.9051f
C11 lvds_lane_1.ob.0 lvds_lane_1.fb.0 2.91705f
C12 lvds_lane_1.sa.0 lvds_lane_1.rlb_m1.0 0
C13 lvds_lane_1.tn.0 lvds_lane_1.gp.0 1.20295f
C14 lvds_lane_2.tn.0 lvds_lane_2.oa.0 9.87791f
C15 lvds_lane_0.VBN.0 lvds_lane_0.gn.0 0.27781f
C16 VDD RX0_O 3.99882f
C17 lvds_lane_0.nm.0 lvds_lane_0.nd.0 0.2193f
C18 lvds_lane_0.ob.0 lvds_lane_0.oa.0 0.59251f
C19 VDD RX2_N 2.56543f
C20 lvds_lane_2.nm.0 EN 0.02238f
C21 lvds_lane_0.VB2.0 lvds_lane_1.fb.0 2.09462f
C22 lvds_lane_0.oa.0 lvds_lane_0.tn.0 9.87791f
C23 EN lvds_lane_0.VBP.0 0.30881f
C24 RX0_N VDD 2.56543f
C25 lvds_lane_0.ob.0 lvds_lane_0.fb.0 2.91705f
C26 lvds_lane_2.ob.0 VDD 1.95948f
C27 lvds_lane_0.sb.0 lvds_lane_0.ts.0 0.20041f
C28 lvds_lane_0.VBN.0 lvds_lane_0.gp.0 0.57567f
C29 lvds_lane_1.gn.0 lvds_lane_1.gp.0 2.07546f
C30 lvds_lane_1.fa.0 lvds_lane_1.tp.0 25.37f
C31 EN lvds_lane_2.d2b.0 0.31138f
C32 lvds_lane_2.i1.0 lvds_lane_2.nd.0 0.21598f
C33 lvds_lane_0.gn.0 lvds_lane_0.VREF.0 2.83689f
C34 lvds_lane_1.rla_m1.0 lvds_lane_1.rlb_m1.0 0.39394f
C35 RX0_P VDD 2.27023f
C36 lvds_lane_0.sa.0 lvds_lane_0.ob.0 0.00738f
C37 EN lvds_lane_0.VB2.0 2.209f
C38 lvds_lane_0.VBN.0 lvds_bias_0.rb_m2.0 0.03909f
C39 VDD lvds_lane_0.oa.0 1.56447f
C40 lvds_lane_2.d2a.0 lvds_lane_2.sa.0 1.67001f
C41 lvds_lane_2.n3a.0 lvds_lane_2.d3.0 0.46613f
C42 lvds_lane_0.gp.0 lvds_lane_0.VREF.0 2.30895f
C43 lvds_lane_1.tn.0 lvds_lane_1.oa.0 9.87791f
C44 lvds_lane_1.i1.0 RX1_O 0
C45 lvds_lane_0.tp.0 lvds_lane_0.fa.0 25.37f
C46 lvds_lane_1.i1.0 lvds_lane_1.nd.0 0.21598f
C47 lvds_lane_2.ob.0 lvds_lane_2.gp.0 0.36334f
C48 lvds_lane_0.d2b.0 lvds_lane_0.d3.0 0.22886f
C49 lvds_bias_0.rdt_m1.0 lvds_bias_0.rdb_m3.0 0.41833f
C50 VDD lvds_lane_1.d2b.0 10.8442f
C51 lvds_lane_0.VBN.0 lvds_lane_1.fa.0 2.18465f
C52 lvds_lane_0.VBN.0 lvds_lane_2.ob.0 0.17663f
C53 lvds_lane_1.n3a.0 lvds_lane_1.d2b.0 0.17133f
C54 lvds_bias_0.rdt_m1.0 lvds_bias_0.rdt_m3.0 0.08167f
C55 RX1_N VDD 2.56543f
C56 lvds_lane_2.gn.0 RX2_N 0.14621f
C57 lvds_lane_1.gn.0 lvds_lane_1.oa.0 0.30476f
C58 EN RX2_O 0.005f
C59 lvds_lane_2.ob.0 lvds_lane_2.gn.0 1.01627f
C60 lvds_lane_0.d2a.0 EN 0.19588f
C61 lvds_lane_0.d2b.0 lvds_lane_0.sb.0 0.68313f
C62 lvds_lane_0.ob.0 lvds_lane_0.VB2.0 0.58885f
C63 lvds_lane_0.VBN.0 lvds_lane_0.oa.0 0.31902f
C64 lvds_lane_0.gn.0 lvds_lane_0.fa.0 0.66886f
C65 lvds_bias_0.vf.0 lvds_lane_0.VBP.0 0.19894f
C66 lvds_lane_1.fa.0 lvds_lane_0.VREF.0 2.48886f
C67 lvds_lane_2.ob.0 lvds_lane_0.VREF.0 2.70252f
C68 lvds_lane_0.VBN.0 lvds_lane_0.fb.0 1.50358f
C69 lvds_lane_0.VBP.0 VDD 0.11403p
C70 lvds_lane_0.VBP.0 lvds_lane_1.tp.0 3.37779f
C71 lvds_bias_0.nrb.0 lvds_bias_0.rb_m2.0 0.03837f
C72 lvds_lane_0.fa.0 lvds_lane_0.gp.0 2.42263f
C73 lvds_bias_0.rb_m1.0 lvds_lane_0.VBP.0 0
C74 VDD lvds_lane_2.d2b.0 10.8442f
C75 lvds_lane_1.ob.0 VDD 1.95948f
C76 lvds_lane_0.VREF.0 lvds_lane_0.oa.0 2.14744f
C77 lvds_bias_0.vf.0 lvds_lane_0.VB2.0 0.92426f
C78 lvds_lane_1.d2a.0 lvds_lane_1.oa.0 0.16422f
C79 lvds_lane_0.VB2.0 VDD 6.74394f
C80 lvds_lane_0.fb.0 lvds_lane_0.VREF.0 2.62815f
C81 lvds_lane_1.gp.0 lvds_lane_1.oa.0 1.26032f
C82 RX0_O lvds_lane_0.i1.0 0
C83 lvds_lane_2.d2a.0 lvds_lane_2.d2b.0 4.0714f
C84 lvds_lane_0.n3a.0 lvds_lane_0.d2b.0 0.17133f
C85 lvds_lane_2.gp.0 lvds_lane_0.VBP.0 0.26446f
C86 lvds_lane_0.VB2.0 lvds_lane_1.tp.0 0.05309f
C87 VDD RX1_P 2.27847f
C88 lvds_lane_1.tp.0 lvds_lane_1.fb.0 25.7432f
C89 lvds_lane_0.VBN.0 lvds_lane_0.VBP.0 7.55653f
C90 lvds_lane_1.d2a.0 lvds_lane_1.d3.0 0.63055f
C91 lvds_lane_0.VBP.0 lvds_bias_0.nmid.0 0.03404f
C92 EN lvds_lane_0.nd.0 0.90578f
C93 lvds_lane_2.ob.0 lvds_lane_2.fa.0 0
C94 lvds_lane_2.ob.0 lvds_lane_2.fb.0 2.91705f
C95 lvds_lane_0.VBP.0 lvds_lane_2.gn.0 0.26446f
C96 lvds_bias_0.vf.0 EN 0.02265f
C97 RX2_O VDD 4.00067f
C98 lvds_lane_1.i2.0 lvds_lane_1.i1.0 0.28557f
C99 lvds_lane_1.ob.0 lvds_lane_0.VBN.0 0.17663f
C100 EN VDD 63.801f
C101 lvds_lane_1.d3.0 lvds_lane_1.nd.0 0.22426f
C102 lvds_lane_0.VB2.0 lvds_lane_2.gp.0 0.04355f
C103 lvds_lane_0.d2a.0 VDD 12.736f
C104 EN lvds_lane_1.n3a.0 0.00401f
C105 lvds_lane_0.VBN.0 lvds_lane_0.VB2.0 0.60206f
C106 lvds_lane_2.tn.0 lvds_lane_2.ob.0 9.55392f
C107 lvds_lane_0.VBP.0 lvds_lane_0.VREF.0 0.06866f
C108 lvds_lane_2.ts.0 VDD 0.60574f
C109 lvds_lane_0.fa.0 lvds_lane_0.oa.0 2.94526f
C110 lvds_lane_0.ob.0 lvds_lane_0.tn.0 9.55392f
C111 lvds_lane_0.VBN.0 lvds_lane_1.fb.0 1.50358f
C112 lvds_bias_0.rb_m1.0 EN 0.00905f
C113 lvds_lane_0.VB2.0 lvds_bias_0.nmid.0 0.91956f
C114 EN lvds_lane_2.d2a.0 0.19588f
C115 lvds_lane_0.fb.0 lvds_lane_0.fa.0 0.8011f
C116 lvds_lane_0.n3a.0 lvds_lane_0.d3.0 0.46613f
C117 lvds_lane_0.VB2.0 lvds_lane_2.gn.0 0.04523f
C118 lvds_lane_1.ob.0 lvds_lane_0.VREF.0 2.70252f
C119 lvds_lane_0.VBP.0 lvds_lane_2.tp.0 3.37779f
C120 lvds_lane_1.fa.0 lvds_lane_1.gn.0 0.66886f
C121 lvds_bias_0.rb_m3.0 lvds_bias_0.rb_m1.0 0.06955f
C122 lvds_lane_2.d2b.0 lvds_lane_2.n3a.0 0.17133f
C123 lvds_lane_0.VB2.0 lvds_lane_0.VREF.0 24.575f
C124 lvds_lane_1.i2.0 RX1_O 0.50509f
C125 lvds_bias_0.nrb.0 lvds_lane_0.VBP.0 0.36239f
C126 lvds_lane_0.sa.0 lvds_lane_0.ts.0 0.13628f
C127 RX0_O lvds_lane_0.i2.0 0.50501f
C128 lvds_lane_0.VREF.0 lvds_lane_1.fb.0 2.62815f
C129 lvds_lane_0.VBN.0 EN 0.42317f
C130 lvds_lane_0.ob.0 VDD 1.95948f
C131 VDD lvds_lane_0.tn.0 0.2078f
C132 EN lvds_bias_0.nmid.0 0.59891f
C133 lvds_lane_0.VBN.0 lvds_lane_2.ts.0 1.02135f
C134 lvds_lane_0.VB2.0 lvds_lane_2.tp.0 0.05309f
C135 lvds_bias_0.nrb.0 lvds_lane_0.VB2.0 0.03524f
C136 lvds_lane_2.i2.0 RX2_O 0.50509f
C137 VDD lvds_lane_0.nd.0 2.7235f
C138 lvds_lane_2.i2.0 EN 0.31277f
C139 lvds_lane_1.ts.0 lvds_lane_1.sa.0 0.13628f
C140 lvds_lane_1.sa.0 lvds_lane_1.d2a.0 1.67001f
C141 lvds_bias_0.vf.0 VDD 0.00294f
C142 RX1_N lvds_lane_1.gn.0 0.14621f
C143 EN lvds_lane_2.n3a.0 0.00401f
C144 lvds_lane_2.ts.0 lvds_lane_0.VREF.0 0.00271f
C145 VDD lvds_lane_1.n3a.0 4.03663f
C146 lvds_lane_1.fa.0 lvds_lane_1.gp.0 2.42263f
C147 lvds_lane_0.rla_m1.0 lvds_lane_0.d2b.0 0.00423f
C148 lvds_lane_2.i1.0 RX2_O 0
C149 lvds_lane_2.oa.0 lvds_lane_2.ob.0 0.59251f
C150 lvds_lane_0.ob.0 lvds_lane_0.VBN.0 0.17663f
C151 lvds_lane_1.tp.0 VDD 11.3411f
C152 lvds_lane_0.VB2.0 lvds_lane_0.fa.0 1.71129f
C153 lvds_lane_2.i1.0 EN 0.26447f
C154 lvds_lane_0.VBN.0 lvds_lane_0.tn.0 0.82513f
C155 lvds_lane_2.fa.0 lvds_lane_0.VB2.0 1.71129f
C156 lvds_lane_0.VB2.0 lvds_lane_2.fb.0 2.09462f
C157 VDD lvds_lane_2.d2a.0 12.736f
C158 lvds_lane_0.tp.0 lvds_lane_0.gn.0 13.4751f
C159 lvds_lane_2.oa.0 lvds_lane_2.sa.0 0.14911f
C160 lvds_lane_0.d3.0 lvds_lane_0.nm.0 0.01765f
C161 lvds_bias_0.enb.0 lvds_lane_0.VBP.0 1.14704f
C162 lvds_lane_1.ob.0 lvds_lane_1.tn.0 9.55392f
C163 lvds_bias_0.nrb.0 EN 0.24322f
C164 lvds_lane_0.sa.0 lvds_lane_0.d2b.0 0.20987f
C165 lvds_lane_0.VBP.0 lvds_lane_1.gn.0 0.26446f
C166 lvds_lane_2.rla_m1.0 lvds_lane_2.rlb_m1.0 0.39394f
C167 lvds_lane_1.d2a.0 lvds_lane_1.rla_m1.0 0
C168 lvds_lane_1.ts.0 lvds_lane_1.sb.0 0.20041f
C169 lvds_lane_0.tp.0 lvds_lane_0.gp.0 12.8915f
C170 lvds_lane_0.ob.0 lvds_lane_0.VREF.0 2.70252f
C171 lvds_lane_2.gp.0 VDD 4.52291f
C172 lvds_lane_1.d2a.0 lvds_lane_1.d2b.0 4.0714f
C173 lvds_lane_2.nd.0 lvds_lane_2.d3.0 0.22426f
C174 lvds_lane_0.VBN.0 lvds_bias_0.vf.0 1.55879f
C175 lvds_lane_0.VREF.0 lvds_lane_0.tn.0 1.62411f
C176 EN lvds_lane_0.i1.0 0.26447f
C177 lvds_lane_1.ob.0 lvds_lane_1.gn.0 1.01627f
C178 lvds_lane_0.VBN.0 VDD 3.79441f
C179 lvds_bias_0.enb.0 lvds_lane_0.VB2.0 2.1266f
C180 lvds_lane_1.fa.0 lvds_lane_1.oa.0 2.94526f
C181 lvds_lane_1.sa.0 lvds_lane_1.oa.0 0.14911f
C182 VDD lvds_bias_0.nmid.0 0.17518f
C183 lvds_lane_0.VB2.0 lvds_lane_1.gn.0 0.04523f
C184 lvds_lane_0.VBP.0 RX2_P 0.03967f
C185 VDD lvds_lane_2.gn.0 4.52025f
C186 lvds_lane_1.gn.0 lvds_lane_1.fb.0 2.60941f
C187 lvds_lane_1.nd.0 lvds_lane_1.nm.0 0.2193f
C188 lvds_bias_0.enb.0 lvds_bias_0.rdt_m1.0 0.0052f
C189 lvds_lane_0.gn.0 lvds_lane_0.gp.0 2.07546f
C190 VDD lvds_lane_0.VREF.0 3.50102f
C191 lvds_lane_2.i2.0 VDD 4.28491f
C192 lvds_lane_0.VBN.0 lvds_lane_2.gp.0 0.57567f
C193 lvds_lane_0.VBP.0 lvds_lane_1.gp.0 0.26446f
C194 lvds_lane_1.tp.0 lvds_lane_0.VREF.0 14.9051f
C195 VDD lvds_lane_2.n3a.0 4.03663f
C196 lvds_bias_0.enb.0 EN 4.07467f
C197 VDD lvds_bias_0.rdb_m2.0 0.00594f
C198 lvds_lane_2.tp.0 VDD 11.3411f
C199 lvds_lane_0.ob.0 lvds_lane_0.fa.0 0
C200 lvds_lane_2.i1.0 VDD 2.62233f
C201 lvds_lane_2.rla_m1.0 lvds_lane_2.sa.0 0.30587f
C202 lvds_lane_2.gp.0 lvds_lane_2.gn.0 2.07546f
C203 lvds_lane_0.VBN.0 lvds_bias_0.nmid.0 0.11617f
C204 lvds_lane_1.ob.0 lvds_lane_1.gp.0 0.36334f
C205 lvds_lane_2.d2a.0 lvds_lane_2.n3a.0 0.2367f
C206 lvds_bias_0.vf.0 lvds_bias_0.nrb.0 0.61512f
C207 lvds_lane_0.VBN.0 lvds_lane_2.gn.0 0.27781f
C208 lvds_lane_0.sa.0 lvds_lane_0.sb.0 1.08061f
C209 lvds_bias_0.nrb.0 VDD 5.10108f
C210 RX0_N lvds_lane_0.gn.0 0.14621f
C211 lvds_lane_0.d2b.0 EN 0.31138f
C212 lvds_lane_0.tp.0 lvds_lane_0.fb.0 25.7432f
C213 lvds_lane_1.i1.0 EN 0.26447f
C214 lvds_lane_0.d2a.0 lvds_lane_0.d2b.0 4.0714f
C215 lvds_lane_0.VB2.0 lvds_lane_1.gp.0 0.04355f
C216 lvds_lane_2.gp.0 lvds_lane_0.VREF.0 2.30895f
C217 lvds_lane_2.oa.0 lvds_lane_0.VB2.0 0.59315f
C218 lvds_lane_0.i1.0 lvds_lane_0.nd.0 0.21598f
C219 EN lvds_lane_0.i2.0 0.31277f
C220 lvds_lane_1.gp.0 lvds_lane_1.fb.0 0.89735f
C221 lvds_lane_0.VBN.0 lvds_lane_0.VREF.0 2.80537f
C222 lvds_lane_1.d3.0 lvds_lane_1.d2b.0 0.22886f
C223 lvds_lane_1.d3.0 lvds_lane_1.nm.0 0.01765f
C224 RX1_P lvds_lane_1.gp.0 0.14621f
C225 VDD lvds_lane_0.i1.0 2.62233f
C226 lvds_lane_0.VREF.0 lvds_bias_0.nmid.0 0.97574f
C227 VDD lvds_lane_0.ts.0 0.60574f
C228 lvds_lane_2.rlb_m1.0 lvds_lane_2.sa.0 0
C229 lvds_lane_2.gp.0 lvds_lane_2.tp.0 12.8915f
C230 lvds_lane_2.gn.0 lvds_lane_0.VREF.0 2.83689f
C231 lvds_lane_1.d2a.0 EN 0.19588f
C232 lvds_bias_0.rdb_m2.0 lvds_bias_0.nmid.0 0.04228f
C233 lvds_lane_0.gn.0 lvds_lane_0.oa.0 0.30476f
C234 lvds_lane_2.sb.0 lvds_lane_2.ob.0 0.20964f
C235 lvds_lane_0.fb.0 lvds_lane_0.gn.0 2.60941f
C236 lvds_lane_1.ob.0 lvds_lane_1.oa.0 0.59251f
C237 lvds_lane_0.VBN.0 lvds_bias_0.nrb.0 0.04433f
C238 RX0_P lvds_lane_0.gp.0 0.14621f
C239 lvds_lane_2.tp.0 lvds_lane_2.gn.0 13.4751f
C240 lvds_lane_2.tn.0 VDD 0.2078f
C241 lvds_lane_1.tn.0 VDD 0.2078f
C242 lvds_lane_2.sb.0 lvds_lane_2.sa.0 1.08061f
C243 EN RX1_O 0.00492f
C244 lvds_lane_0.tp.0 lvds_lane_0.VBP.0 3.37779f
C245 EN lvds_lane_1.nd.0 0.90578f
C246 lvds_lane_0.ob.0 lvds_lane_0.d2b.0 0.16374f
C247 lvds_lane_0.gp.0 lvds_lane_0.oa.0 1.26032f
C248 lvds_lane_0.VB2.0 lvds_lane_1.oa.0 0.59315f
C249 EN lvds_lane_0.d3.0 0.4675f
C250 lvds_lane_0.fb.0 lvds_lane_0.gp.0 0.89735f
C251 lvds_lane_0.d2a.0 lvds_lane_0.d3.0 0.63055f
C252 lvds_bias_0.enb.0 lvds_bias_0.vf.0 1.18587f
C253 lvds_lane_0.VREF.0 lvds_bias_0.rdb_m2.0 0.32236f
C254 lvds_lane_2.tp.0 lvds_lane_0.VREF.0 14.9051f
C255 lvds_bias_0.enb.0 VDD 6.07982f
C256 lvds_lane_2.fa.0 lvds_lane_2.gp.0 2.42263f
C257 lvds_lane_2.gp.0 lvds_lane_2.fb.0 0.89735f
C258 lvds_lane_2.nm.0 lvds_lane_2.nd.0 0.2193f
C259 lvds_lane_2.i2.0 lvds_lane_2.i1.0 0.28557f
C260 lvds_lane_0.VBN.0 lvds_lane_0.ts.0 1.02135f
C261 lvds_lane_1.gn.0 VDD 4.52025f
C262 lvds_lane_0.VBN.0 lvds_lane_0.fa.0 2.18465f
C263 lvds_lane_0.VBN.0 lvds_lane_2.fa.0 2.18465f
C264 lvds_lane_0.VBN.0 lvds_lane_2.fb.0 1.50358f
C265 lvds_lane_2.rla_m1.0 lvds_lane_2.d2b.0 0.00423f
C266 lvds_lane_1.tp.0 lvds_lane_1.gn.0 13.4751f
C267 lvds_bias_0.enb.0 lvds_bias_0.rb_m1.0 0
C268 lvds_lane_0.tp.0 lvds_lane_0.VB2.0 0.05309f
C269 lvds_lane_2.ob.0 lvds_lane_2.sa.0 0.00738f
C270 lvds_lane_2.tn.0 lvds_lane_2.gp.0 1.20295f
C271 lvds_lane_2.fa.0 lvds_lane_2.gn.0 0.66886f
C272 lvds_lane_2.fb.0 lvds_lane_2.gn.0 2.60941f
C273 lvds_lane_0.VBP.0 lvds_lane_0.gn.0 0.26446f
C274 lvds_lane_0.d2b.0 VDD 10.8442f
C275 lvds_lane_1.i1.0 VDD 2.62233f
C276 lvds_lane_2.nm.0 lvds_lane_2.d3.0 0.01765f
C277 lvds_lane_0.VBN.0 lvds_lane_2.tn.0 0.82513f
C278 lvds_lane_0.VBN.0 lvds_lane_1.tn.0 0.82513f
C279 VDD lvds_lane_0.i2.0 4.28491f
C280 RX2_P VDD 2.27847f
C281 lvds_lane_0.VREF.0 lvds_lane_0.ts.0 0.00271f
C282 lvds_lane_0.fa.0 lvds_lane_0.VREF.0 2.48886f
C283 lvds_lane_2.fa.0 lvds_lane_0.VREF.0 2.48886f
C284 lvds_lane_2.fb.0 lvds_lane_0.VREF.0 2.62815f
C285 lvds_lane_1.sa.0 lvds_lane_1.rla_m1.0 0.30587f
C286 lvds_lane_0.VBP.0 lvds_lane_0.gp.0 0.26446f
C287 lvds_lane_1.sb.0 lvds_lane_1.sa.0 1.08061f
C288 lvds_lane_2.tn.0 lvds_lane_2.gn.0 0.99696f
C289 lvds_lane_0.VBN.0 lvds_bias_0.enb.0 0.30834f
C290 lvds_lane_2.d2b.0 lvds_lane_2.d3.0 0.22886f
C291 lvds_lane_1.sa.0 lvds_lane_1.d2b.0 0.20987f
C292 lvds_lane_0.VBN.0 lvds_lane_1.gn.0 0.27781f
C293 EN lvds_lane_1.d3.0 0.4675f
C294 lvds_bias_0.enb.0 lvds_bias_0.nmid.0 0.71708f
C295 lvds_lane_0.VB2.0 lvds_lane_0.gn.0 0.04523f
C296 lvds_lane_1.ts.0 VDD 0.60574f
C297 VDD lvds_bias_0.rdt_m2.0 0.00209f
C298 lvds_lane_1.d2a.0 VDD 12.736f
C299 lvds_lane_2.fa.0 lvds_lane_2.tp.0 25.37f
C300 lvds_lane_2.tp.0 lvds_lane_2.fb.0 25.7432f
C301 lvds_lane_1.d2a.0 lvds_lane_1.n3a.0 0.2367f
C302 lvds_lane_2.tn.0 lvds_lane_0.VREF.0 1.62411f
C303 lvds_lane_1.tn.0 lvds_lane_0.VREF.0 1.62411f
C304 VDD lvds_lane_1.gp.0 4.52291f
C305 lvds_lane_2.oa.0 VDD 1.56447f
C306 lvds_lane_0.n3a.0 EN 0.00401f
C307 lvds_lane_0.d3.0 lvds_lane_0.nd.0 0.22426f
C308 lvds_lane_0.d2a.0 lvds_lane_0.n3a.0 0.2367f
C309 lvds_lane_2.nd.0 EN 0.90578f
C310 lvds_lane_0.ob.0 lvds_lane_0.sb.0 0.20964f
C311 lvds_lane_0.VB2.0 lvds_lane_0.gp.0 0.04355f
C312 lvds_lane_2.sb.0 lvds_lane_2.d2b.0 0.68313f
C313 VDD RX1_O 4.00061f
C314 lvds_lane_1.tp.0 lvds_lane_1.gp.0 12.8915f
C315 lvds_lane_2.gp.0 RX2_P 0.14621f
C316 VDD lvds_lane_1.nd.0 2.7235f
C317 lvds_lane_0.VBP.0 RX2_N 0.03712f
C318 lvds_bias_0.enb.0 lvds_lane_0.VREF.0 0.19826f
C319 lvds_lane_0.VBP.0 RX0_N 0.03712f
C320 VDD lvds_lane_0.d3.0 4.26183f
C321 lvds_lane_1.gn.0 lvds_lane_0.VREF.0 2.83689f
C322 lvds_lane_2.oa.0 lvds_lane_2.d2a.0 0.16422f
C323 lvds_lane_1.rla_m1.0 lvds_lane_1.d2b.0 0.00423f
C324 lvds_lane_1.sb.0 lvds_lane_1.d2b.0 0.68313f
C325 lvds_lane_0.sa.0 lvds_lane_0.oa.0 0.14911f
C326 EN lvds_lane_2.d3.0 0.4675f
C327 lvds_lane_1.i2.0 EN 0.31277f
C328 lvds_lane_2.fa.0 lvds_lane_2.fb.0 0.8011f
C329 lvds_lane_0.VBN.0 lvds_lane_1.ts.0 1.02135f
C330 lvds_lane_1.ob.0 lvds_lane_1.fa.0 0
C331 lvds_lane_1.ob.0 lvds_lane_1.sa.0 0.00738f
C332 lvds_lane_2.ob.0 lvds_lane_2.d2b.0 0.16374f
C333 lvds_lane_0.sa.0 lvds_lane_0.rla_m1.0 0.30587f
C334 lvds_lane_2.oa.0 lvds_lane_2.gp.0 1.26032f
C335 RX0_P lvds_lane_0.VBP.0 0.03875f
C336 lvds_bias_0.enb.0 lvds_bias_0.nrb.0 0.83214f
C337 lvds_bias_0.rdt_m2.0 lvds_bias_0.nmid.0 0.00432f
C338 lvds_lane_0.VBN.0 lvds_lane_1.gp.0 0.57567f
C339 lvds_lane_0.VBN.0 lvds_lane_2.oa.0 0.31902f
C340 lvds_lane_1.fa.0 lvds_lane_0.VB2.0 1.71129f
C341 VDD lvds_lane_1.oa.0 1.56447f
C342 lvds_lane_2.d2b.0 lvds_lane_2.sa.0 0.20987f
C343 lvds_lane_2.ob.0 lvds_lane_0.VB2.0 0.58885f
C344 lvds_lane_1.fa.0 lvds_lane_1.fb.0 0.8011f
C345 lvds_lane_2.oa.0 lvds_lane_2.gn.0 0.30476f
C346 lvds_bias_0.rdb_m1.0 lvds_bias_0.rdt_m3.0 0.22342f
C347 lvds_lane_2.sb.0 lvds_lane_2.ts.0 0.20041f
C348 lvds_lane_1.ts.0 lvds_lane_0.VREF.0 0.00271f
C349 lvds_lane_0.VREF.0 lvds_bias_0.rdt_m2.0 0.00293f
C350 RX1_N lvds_lane_0.VBP.0 0.03712f
C351 EN RX0_O 1.94682f
C352 VDD lvds_lane_1.d3.0 4.26183f
C353 lvds_lane_0.tp.0 VDD 11.3411f
C354 lvds_lane_0.ob.0 lvds_lane_0.gn.0 1.01627f
C355 lvds_lane_0.VREF.0 lvds_lane_1.gp.0 2.30895f
C356 lvds_lane_1.n3a.0 lvds_lane_1.d3.0 0.46613f
C357 lvds_lane_1.ob.0 lvds_lane_1.sb.0 0.20964f
C358 lvds_lane_0.VB2.0 lvds_lane_0.oa.0 0.59315f
C359 lvds_lane_0.gn.0 lvds_lane_0.tn.0 0.99696f
C360 lvds_lane_2.oa.0 lvds_lane_0.VREF.0 2.14744f
C361 lvds_lane_1.ob.0 lvds_lane_1.d2b.0 0.16374f
C362 lvds_bias_0.rdt_m2.0 lvds_bias_0.rdb_m2.0 0.37f
C363 lvds_lane_0.fb.0 lvds_lane_0.VB2.0 2.09462f
C364 EN lvds_lane_0.nm.0 0.02238f
C365 lvds_lane_0.rla_m1.0 lvds_lane_0.rlb_m1.0 0.39394f
C366 lvds_lane_0.n3a.0 VDD 4.03663f
C367 lvds_lane_0.ob.0 lvds_lane_0.gp.0 0.36334f
C368 lvds_lane_2.nd.0 VDD 2.7235f
C369 lvds_lane_0.gp.0 lvds_lane_0.tn.0 1.20295f
C370 lvds_lane_0.VBN.0 lvds_lane_1.oa.0 0.31902f
C371 lvds_lane_1.tn.0 lvds_lane_1.gn.0 0.99696f
C372 lvds_lane_2.rla_m1.0 lvds_lane_2.d2a.0 0
C373 lvds_lane_0.i1.0 lvds_lane_0.i2.0 0.28557f
C374 lvds_lane_0.sa.0 lvds_lane_0.rlb_m1.0 0
C375 lvds_lane_2.ts.0 lvds_lane_2.sa.0 0.13628f
C376 lvds_lane_0.gn.0 VDD 4.52025f
C377 lvds_lane_0.d2a.0 lvds_lane_0.oa.0 0.16422f
C378 VDD lvds_lane_2.d3.0 4.26183f
C379 lvds_lane_1.i2.0 VDD 4.28491f
C380 lvds_bias_0.rb_m3.0 lvds_bias_0.rf_m1.0 0.04347f
C381 lvds_lane_0.VREF.0 lvds_lane_1.oa.0 2.14744f
C382 lvds_lane_0.rla_m1.0 lvds_lane_0.d2a.0 0
C383 RX2_O VSS 18.8961f
C384 RX1_O VSS 11.8271f
C385 RX0_O VSS 11.1616f
C386 EN VSS 37.639f
C387 RX2_N VSS 3.34389f
C388 RX2_P VSS 3.63059f
C389 RX1_N VSS 3.34389f
C390 RX1_P VSS 3.63059f
C391 RX0_N VSS 3.34389f
C392 RX0_P VSS 3.63059f
C393 VDD VSS 0.73679p
C394 lvds_bias_0.vf.0 VSS 3.00974f
C395 lvds_bias_0.rb_m3.0 VSS 1.32997f
C396 lvds_bias_0.rb_m2.0 VSS 1.18202f
C397 lvds_bias_0.rb_m1.0 VSS 1.29823f
C398 lvds_bias_0.rf_m1.0 VSS 1.40226f
C399 lvds_bias_0.nrb.0 VSS 1.8844f
C400 lvds_lane_2.i2.0 VSS 4.24421f
C401 lvds_lane_2.i1.0 VSS 3.72118f
C402 lvds_lane_2.nm.0 VSS 0.31567f
C403 lvds_lane_2.nd.0 VSS 3.35368f
C404 lvds_lane_1.i2.0 VSS 4.24421f
C405 lvds_lane_1.i1.0 VSS 3.72118f
C406 lvds_lane_1.nm.0 VSS 0.31567f
C407 lvds_lane_1.nd.0 VSS 3.35368f
C408 lvds_lane_0.i2.0 VSS 4.24421f
C409 lvds_lane_0.i1.0 VSS 3.72118f
C410 lvds_lane_0.nm.0 VSS 0.31567f
C411 lvds_lane_0.nd.0 VSS 3.35368f
C412 lvds_lane_2.d3.0 VSS 4.52287f
C413 lvds_lane_2.n3a.0 VSS 3.27138f
C414 lvds_lane_1.d3.0 VSS 4.52287f
C415 lvds_lane_1.n3a.0 VSS 3.27138f
C416 lvds_lane_0.d3.0 VSS 4.52287f
C417 lvds_lane_0.n3a.0 VSS 3.27138f
C418 lvds_bias_0.rdb_m1.0 VSS 1.12023f
C419 lvds_bias_0.rdt_m3.0 VSS 1.81265f
C420 lvds_bias_0.rdb_m2.0 VSS 1.69441f
C421 lvds_bias_0.rdb_m3.0 VSS 1.13703f
C422 lvds_bias_0.rdt_m1.0 VSS 1.66241f
C423 lvds_bias_0.rdt_m2.0 VSS 1.18196f
C424 lvds_bias_0.nmid.0 VSS 4.17509f
C425 lvds_lane_2.sb.0 VSS 3.38771f
C426 lvds_lane_2.d2b.0 VSS 4.93292f
C427 lvds_lane_2.rlb_m1.0 VSS 1.11225f
C428 lvds_lane_2.rla_m1.0 VSS 1.48222f
C429 lvds_lane_2.sa.0 VSS 5.03563f
C430 lvds_lane_2.d2a.0 VSS 4.01425f
C431 lvds_lane_1.sb.0 VSS 3.38771f
C432 lvds_lane_1.d2b.0 VSS 4.93292f
C433 lvds_lane_1.rlb_m1.0 VSS 1.11225f
C434 lvds_lane_1.rla_m1.0 VSS 1.48222f
C435 lvds_lane_1.sa.0 VSS 5.03563f
C436 lvds_lane_1.d2a.0 VSS 4.01425f
C437 lvds_lane_0.sb.0 VSS 3.38771f
C438 lvds_lane_0.d2b.0 VSS 4.93292f
C439 lvds_lane_0.rlb_m1.0 VSS 1.11225f
C440 lvds_lane_0.rla_m1.0 VSS 1.48222f
C441 lvds_lane_0.sa.0 VSS 5.03563f
C442 lvds_lane_0.d2a.0 VSS 4.01425f
C443 lvds_lane_2.ts.0 VSS 8.96904f
C444 lvds_lane_2.tn.0 VSS 4.38184f
C445 lvds_lane_1.ts.0 VSS 8.96904f
C446 lvds_lane_1.tn.0 VSS 4.38184f
C447 lvds_lane_0.ts.0 VSS 8.96904f
C448 lvds_lane_0.tn.0 VSS 4.38184f
C449 lvds_bias_0.enb.0 VSS 8.45551f
C450 lvds_lane_2.ob.0 VSS 6.96006f
C451 lvds_lane_2.oa.0 VSS 7.17837f
C452 lvds_lane_1.ob.0 VSS 6.96006f
C453 lvds_lane_1.oa.0 VSS 7.17837f
C454 lvds_lane_0.ob.0 VSS 6.96006f
C455 lvds_lane_0.VBN.0 VSS 0.17612p
C456 lvds_lane_0.oa.0 VSS 7.17837f
C457 lvds_lane_2.fa.0 VSS 9.29453f
C458 lvds_lane_2.fb.0 VSS 8.10808f
C459 lvds_lane_1.fa.0 VSS 9.29453f
C460 lvds_lane_1.fb.0 VSS 8.10808f
C461 lvds_lane_0.fa.0 VSS 9.29453f
C462 lvds_lane_0.fb.0 VSS 8.10808f
C463 lvds_lane_0.VREF.0 VSS 58.372f
C464 lvds_lane_0.VB2.0 VSS 40.4227f
C465 lvds_lane_2.gn.0 VSS 13.2934f
C466 lvds_lane_2.gp.0 VSS 13.3739f
C467 lvds_lane_1.gn.0 VSS 13.2934f
C468 lvds_lane_1.gp.0 VSS 13.3739f
C469 lvds_lane_0.gn.0 VSS 13.2934f
C470 lvds_lane_0.VBP.0 VSS 20.9164f
C471 lvds_lane_0.gp.0 VSS 13.3739f
C472 lvds_lane_2.tp.0 VSS 0.1029p
C473 lvds_lane_1.tp.0 VSS 0.1029p
C474 lvds_lane_0.tp.0 VSS 0.1029p
.ends lvds_rx_x3
