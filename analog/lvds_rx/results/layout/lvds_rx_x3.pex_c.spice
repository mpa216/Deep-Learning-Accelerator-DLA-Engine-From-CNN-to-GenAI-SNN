* lvds_rx_x3: parasitic C on all nets (coupling and to substrate, cthresh 0) (flat copy of the hierarchy)
* GENERATED by layout/macro/run_macro.py (T10) from a GDS with sha256 baab0cc55197ce69e5b798f467976b8eb293869bdfe4de7edbe1960bab5eca01 -- do not edit by hand.
* Ports in the order of subckt lvds_rx_x3 of netlist/lvds_rx_lvs_ref.spice (Magic's own order was: RX0_O RX1_O RX2_O EN RX0_P RX0_N RX1_P RX1_N RX2_P RX2_N VDD VSS).
* NGSPICE file created from lvds_rx_x3_flat.ext - technology: gf180mcuD

.subckt lvds_rx_x3 VDD VSS RX0_P RX0_N RX1_P RX1_N RX2_P RX2_N EN RX0_O RX1_O RX2_O
X0 VDD lvds_lane_2.d2b.0 lvds_lane_2.d2b.0 VDD pfet_03v3 ad=0.52p pd=2.52u as=0.52p ps=2.52u w=2u l=0.4u
X1 VSS VSS lvds_lane_2.fa.0 VSS nfet_03v3 ad=1.1p pd=5.88u as=0.65p ps=3.02u w=2.5u l=1u
X2 lvds_lane_2.n3a.0 lvds_lane_2.d2a.0 VDD VDD pfet_03v3 ad=0.52p pd=2.52u as=0.52p ps=2.52u w=2u l=0.4u
X3 VSS VSS RX1_O VSS nfet_03v3 ad=1.76p pd=8.88u as=1.04p ps=4.52u w=4u l=0.28u
X4 lvds_lane_0.tp.0 lvds_lane_0.gn.0 lvds_lane_0.fb.0 lvds_lane_0.tp.0 pfet_03v3 ad=1.248p pd=5.32u as=1.248p ps=5.32u w=4.8u l=0.4u
X5 lvds_lane_0.fb.0 lvds_lane_0.VREF.0 lvds_lane_0.tp.0 lvds_lane_0.tp.0 pfet_03v3 ad=1.248p pd=5.32u as=1.248p ps=5.32u w=4.8u l=0.4u
X6 VDD lvds_lane_0.VBP.0 lvds_lane_2.tp.0 VDD pfet_03v3 ad=1.3p pd=5.52u as=1.3p ps=5.52u w=5u l=1u
X7 lvds_lane_1.tp.0 lvds_lane_1.gn.0 lvds_lane_1.fb.0 lvds_lane_1.tp.0 pfet_03v3 ad=1.248p pd=5.32u as=1.248p ps=5.32u w=4.8u l=0.4u
X8 lvds_lane_1.fb.0 lvds_lane_0.VBN.0 VSS VSS nfet_03v3 ad=0.65p pd=3.02u as=0.65p ps=3.02u w=2.5u l=1u
X9 lvds_lane_0.VBP.0 lvds_lane_0.VBP.0 VDD VDD pfet_03v3 ad=1.3p pd=5.52u as=1.3p ps=5.52u w=5u l=1u
X10 lvds_lane_2.fa.0 lvds_lane_0.VREF.0 lvds_lane_2.tp.0 lvds_lane_2.tp.0 pfet_03v3 ad=1.248p pd=5.32u as=1.248p ps=5.32u w=4.8u l=0.4u
X11 VSS lvds_lane_0.VBN.0 lvds_lane_0.fb.0 VSS nfet_03v3 ad=0.65p pd=3.02u as=0.65p ps=3.02u w=2.5u l=1u
X12 lvds_lane_2.n3a.0 lvds_lane_2.d2a.0 VDD VDD pfet_03v3 ad=0.52p pd=2.52u as=0.52p ps=2.52u w=2u l=0.4u
X13 lvds_lane_1.tp.0 lvds_lane_0.VBP.0 VDD VDD pfet_03v3 ad=1.3p pd=5.52u as=1.3p ps=5.52u w=5u l=1u
X14 VSS VSS lvds_lane_2.fa.0 VSS nfet_03v3 ad=1.9888p pd=9.92u as=1.1752p ps=5.04u w=4.52u l=0.5u
X15 lvds_lane_1.tn.0 lvds_lane_1.gp.0 lvds_lane_1.oa.0 VSS nfet_03v3 ad=1.235p pd=5.27u as=1.235p ps=5.27u w=4.75u l=0.5u
X16 lvds_lane_1.fb.0 lvds_lane_1.gn.0 lvds_lane_1.tp.0 lvds_lane_1.tp.0 pfet_03v3 ad=1.248p pd=5.32u as=1.248p ps=5.32u w=4.8u l=0.4u
X17 lvds_lane_2.tp.0 lvds_lane_0.VREF.0 lvds_lane_2.fb.0 lvds_lane_2.tp.0 pfet_03v3 ad=1.248p pd=5.32u as=1.248p ps=5.32u w=4.8u l=0.4u
X18 VSS lvds_lane_0.VBN.0 lvds_lane_1.fb.0 VSS nfet_03v3 ad=0.65p pd=3.02u as=0.65p ps=3.02u w=2.5u l=1u
X19 lvds_lane_2.tn.0 lvds_lane_0.VREF.0 lvds_lane_2.ob.0 VSS nfet_03v3 ad=1.235p pd=5.27u as=1.235p ps=5.27u w=4.75u l=0.5u
X20 lvds_lane_2.oa.0 lvds_lane_0.VB2.0 lvds_lane_2.fa.0 VSS nfet_03v3 ad=1.1752p pd=5.04u as=1.1752p ps=5.04u w=4.52u l=0.5u
X21 lvds_lane_0.tp.0 lvds_lane_0.gp.0 lvds_lane_0.fa.0 lvds_lane_0.tp.0 pfet_03v3 ad=1.248p pd=5.32u as=1.248p ps=5.32u w=4.8u l=0.4u
X22 lvds_lane_0.oa.0 lvds_lane_0.VREF.0 lvds_lane_0.tn.0 VSS nfet_03v3 ad=1.235p pd=5.27u as=1.235p ps=5.27u w=4.75u l=0.5u
X23 lvds_lane_1.fb.0 lvds_lane_0.VREF.0 lvds_lane_1.tp.0 lvds_lane_1.tp.0 pfet_03v3 ad=1.248p pd=5.32u as=1.248p ps=5.32u w=4.8u l=0.4u
X24 lvds_lane_2.fb.0 lvds_lane_0.VB2.0 lvds_lane_2.ob.0 VSS nfet_03v3 ad=1.1752p pd=5.04u as=1.1752p ps=5.04u w=4.52u l=0.5u
X25 VSS lvds_lane_0.VREF.0 VSS VSS nfet_03v3 ad=8.8p pd=40.88u as=0.24333n ps=1.1905m w=20u l=25.13u
X26 lvds_lane_1.tn.0 lvds_lane_1.gp.0 lvds_lane_1.oa.0 VSS nfet_03v3 ad=1.235p pd=5.27u as=1.235p ps=5.27u w=4.75u l=0.5u
X27 lvds_lane_2.d3.0 lvds_lane_2.d2b.0 VDD VDD pfet_03v3 ad=0.52p pd=2.52u as=0.52p ps=2.52u w=2u l=0.4u
X28 lvds_lane_1.d3.0 lvds_lane_1.d2b.0 VDD VDD pfet_03v3 ad=0.52p pd=2.52u as=0.52p ps=2.52u w=2u l=0.4u
D0 lvds_lane_0.gp.0 VDD diode_pd2nw_03v3 pj=26u area=40p
X29 lvds_lane_2.tp.0 lvds_lane_2.gp.0 lvds_lane_2.fa.0 lvds_lane_2.tp.0 pfet_03v3 ad=1.248p pd=5.32u as=1.248p ps=5.32u w=4.8u l=0.4u
X30 lvds_lane_0.ob.0 lvds_lane_0.VB2.0 lvds_lane_0.fb.0 VSS nfet_03v3 ad=1.1752p pd=5.04u as=1.1752p ps=5.04u w=4.52u l=0.5u
X31 lvds_lane_0.nm.0 lvds_lane_0.d3.0 lvds_lane_0.nd.0 VSS nfet_03v3 ad=0.52p pd=2.52u as=0.52p ps=2.52u w=2u l=0.28u
X32 lvds_lane_1.d2a.0 VDD VDD VDD pfet_03v3 ad=0.52p pd=2.52u as=0.88p ps=4.88u w=2u l=0.4u
X33 lvds_lane_0.ob.0 lvds_lane_0.VREF.0 lvds_lane_0.tn.0 VSS nfet_03v3 ad=1.235p pd=5.27u as=1.235p ps=5.27u w=4.75u l=0.5u
X34 lvds_lane_1.tn.0 lvds_lane_1.gn.0 lvds_lane_1.ob.0 VSS nfet_03v3 ad=1.235p pd=5.27u as=1.235p ps=5.27u w=4.75u l=0.5u
X35 RX0_O lvds_lane_0.i2.0 VSS VSS nfet_03v3 ad=1.04p pd=4.52u as=1.04p ps=4.52u w=4u l=0.28u
X36 VSS lvds_lane_0.VBN.0 lvds_lane_0.VBP.0 VSS nfet_03v3 ad=0.65p pd=3.02u as=0.65p ps=3.02u w=2.5u l=1u
X37 VSS VSS VSS ppolyf_u_1k r_width=2u r_length=8.86u
X38 lvds_lane_0.fa.0 lvds_lane_0.VREF.0 lvds_lane_0.tp.0 lvds_lane_0.tp.0 pfet_03v3 ad=1.248p pd=5.32u as=1.248p ps=5.32u w=4.8u l=0.4u
X39 lvds_lane_1.fb.0 lvds_lane_1.gn.0 lvds_lane_1.tp.0 lvds_lane_1.tp.0 pfet_03v3 ad=1.248p pd=5.32u as=1.248p ps=5.32u w=4.8u l=0.4u
X40 lvds_lane_0.fa.0 lvds_lane_0.VBN.0 VSS VSS nfet_03v3 ad=0.65p pd=3.02u as=0.65p ps=3.02u w=2.5u l=1u
X41 lvds_lane_0.tn.0 lvds_lane_0.gp.0 lvds_lane_0.oa.0 VSS nfet_03v3 ad=1.235p pd=5.27u as=1.235p ps=5.27u w=4.75u l=0.5u
X42 lvds_lane_2.fb.0 lvds_lane_0.VREF.0 lvds_lane_2.tp.0 lvds_lane_2.tp.0 pfet_03v3 ad=1.248p pd=5.32u as=1.248p ps=5.32u w=4.8u l=0.4u
X43 lvds_lane_0.fa.0 lvds_lane_0.VREF.0 lvds_lane_0.tp.0 lvds_lane_0.tp.0 pfet_03v3 ad=1.248p pd=5.32u as=1.248p ps=5.32u w=4.8u l=0.4u
X44 lvds_lane_1.tp.0 lvds_lane_0.VREF.0 lvds_lane_1.fa.0 lvds_lane_1.tp.0 pfet_03v3 ad=1.248p pd=5.32u as=1.248p ps=5.32u w=4.8u l=0.4u
X45 lvds_lane_0.tn.0 lvds_lane_0.VBN.0 VSS VSS nfet_03v3 ad=0.65p pd=3.02u as=0.65p ps=3.02u w=2.5u l=1u
X46 lvds_lane_2.oa.0 lvds_lane_2.gp.0 lvds_lane_2.tn.0 VSS nfet_03v3 ad=1.235p pd=5.27u as=1.235p ps=5.27u w=4.75u l=0.5u
X47 RX2_O lvds_lane_2.i2.0 VSS VSS nfet_03v3 ad=1.04p pd=4.52u as=1.04p ps=4.52u w=4u l=0.28u
X48 VSS VSS lvds_lane_2.ts.0 VSS nfet_03v3 ad=1.1p pd=5.88u as=0.65p ps=3.02u w=2.5u l=1u
X49 VDD lvds_lane_0.i2.0 RX0_O VDD pfet_03v3 ad=1.3p pd=5.52u as=1.3p ps=5.52u w=5u l=0.28u
X50 VSS lvds_bias_0.enb.0 lvds_lane_0.VB2.0 VSS nfet_03v3 ad=0.52p pd=2.52u as=0.52p ps=2.52u w=2u l=0.5u
X51 VDD lvds_lane_2.d3.0 lvds_lane_2.nd.0 VDD pfet_03v3 ad=0.78p pd=3.52u as=0.78p ps=3.52u w=3u l=0.28u
X52 lvds_lane_0.d2b.0 lvds_lane_0.d2b.0 VDD VDD pfet_03v3 ad=0.52p pd=2.52u as=0.52p ps=2.52u w=2u l=0.4u
X53 lvds_lane_0.d3.0 lvds_lane_0.d2b.0 VDD VDD pfet_03v3 ad=0.52p pd=2.52u as=0.52p ps=2.52u w=2u l=0.4u
X54 lvds_lane_1.tp.0 lvds_lane_0.VREF.0 lvds_lane_1.fa.0 lvds_lane_1.tp.0 pfet_03v3 ad=1.248p pd=5.32u as=1.248p ps=5.32u w=4.8u l=0.4u
X55 VSS lvds_lane_0.VBN.0 lvds_lane_0.ts.0 VSS nfet_03v3 ad=0.65p pd=3.02u as=0.65p ps=3.02u w=2.5u l=1u
X56 lvds_lane_2.ob.0 lvds_lane_0.VREF.0 lvds_lane_2.tn.0 VSS nfet_03v3 ad=1.235p pd=5.27u as=1.235p ps=5.27u w=4.75u l=0.5u
X57 VDD VDD lvds_lane_0.i2.0 VDD pfet_03v3 ad=1.65p pd=8.38u as=0.975p ps=4.27u w=3.75u l=0.28u
X58 VDD VDD lvds_lane_2.d2b.0 VDD pfet_03v3 ad=0.88p pd=4.88u as=0.52p ps=2.52u w=2u l=0.4u
X59 lvds_lane_0.d3.0 lvds_lane_0.n3a.0 VSS VSS nfet_03v3 ad=0.6734p pd=3.11u as=0.6734p ps=3.11u w=2.59u l=0.28u
X60 lvds_lane_0.tp.0 lvds_lane_0.gn.0 lvds_lane_0.fb.0 lvds_lane_0.tp.0 pfet_03v3 ad=1.248p pd=5.32u as=1.248p ps=5.32u w=4.8u l=0.4u
X61 lvds_lane_0.fa.0 lvds_lane_0.VREF.0 lvds_lane_0.tp.0 lvds_lane_0.tp.0 pfet_03v3 ad=1.248p pd=5.32u as=1.248p ps=5.32u w=4.8u l=0.4u
X62 lvds_lane_1.fa.0 lvds_lane_0.VREF.0 lvds_lane_1.tp.0 lvds_lane_1.tp.0 pfet_03v3 ad=1.248p pd=5.32u as=1.248p ps=5.32u w=4.8u l=0.4u
X63 lvds_lane_2.tp.0 lvds_lane_2.gp.0 lvds_lane_2.fa.0 lvds_lane_2.tp.0 pfet_03v3 ad=1.248p pd=5.32u as=1.248p ps=5.32u w=4.8u l=0.4u
X64 lvds_lane_2.n3a.0 VDD VDD VDD pfet_03v3 ad=0.52p pd=2.52u as=0.88p ps=4.88u w=2u l=0.4u
X65 lvds_lane_0.tp.0 lvds_lane_0.VREF.0 lvds_lane_0.fb.0 lvds_lane_0.tp.0 pfet_03v3 ad=1.248p pd=5.32u as=1.248p ps=5.32u w=4.8u l=0.4u
X66 lvds_lane_1.tp.0 lvds_lane_1.gn.0 lvds_lane_1.fb.0 lvds_lane_1.tp.0 pfet_03v3 ad=1.248p pd=5.32u as=1.248p ps=5.32u w=4.8u l=0.4u
X67 VDD lvds_lane_2.i2.0 RX2_O VDD pfet_03v3 ad=1.3p pd=5.52u as=1.3p ps=5.52u w=5u l=0.28u
X68 lvds_lane_2.fa.0 lvds_lane_2.gp.0 lvds_lane_2.tp.0 lvds_lane_2.tp.0 pfet_03v3 ad=1.248p pd=5.32u as=1.248p ps=5.32u w=4.8u l=0.4u
X69 lvds_lane_1.d2a.0 lvds_lane_1.oa.0 lvds_lane_1.sa.0 VSS nfet_03v3 ad=1.0036p pd=4.38u as=1.0036p ps=4.38u w=3.86u l=0.5u
X70 VSS VSS VSS ppolyf_u_1k r_width=2u r_length=9.11u
X71 VDD lvds_lane_0.VBP.0 lvds_lane_0.tp.0 VDD pfet_03v3 ad=1.3p pd=5.52u as=1.3p ps=5.52u w=5u l=1u
X72 lvds_lane_1.fa.0 lvds_lane_1.gp.0 lvds_lane_1.tp.0 lvds_lane_1.tp.0 pfet_03v3 ad=1.248p pd=5.32u as=1.248p ps=5.32u w=4.8u l=0.4u
X73 lvds_lane_1.ob.0 lvds_lane_0.VREF.0 lvds_lane_1.tn.0 VSS nfet_03v3 ad=2.09p pd=10.38u as=1.235p ps=5.27u w=4.75u l=0.5u
X74 lvds_lane_0.tp.0 lvds_lane_0.VREF.0 lvds_lane_0.fa.0 lvds_lane_0.tp.0 pfet_03v3 ad=1.248p pd=5.32u as=1.248p ps=5.32u w=4.8u l=0.4u
X75 VSS VSS RX0_O VSS nfet_03v3 ad=1.76p pd=8.88u as=1.04p ps=4.52u w=4u l=0.28u
X76 lvds_lane_0.fb.0 lvds_lane_0.gn.0 lvds_lane_0.tp.0 lvds_lane_0.tp.0 pfet_03v3 ad=1.248p pd=5.32u as=1.248p ps=5.32u w=4.8u l=0.4u
X77 lvds_lane_2.tp.0 lvds_lane_0.VREF.0 lvds_lane_2.fb.0 lvds_lane_2.tp.0 pfet_03v3 ad=1.248p pd=5.32u as=1.248p ps=5.32u w=4.8u l=0.4u
X78 VSS lvds_lane_0.VBN.0 lvds_lane_1.fb.0 VSS nfet_03v3 ad=0.65p pd=3.02u as=0.65p ps=3.02u w=2.5u l=1u
X79 VDD lvds_lane_0.VBP.0 lvds_lane_1.tp.0 VDD pfet_03v3 ad=1.3p pd=5.52u as=1.3p ps=5.52u w=5u l=1u
X80 lvds_lane_1.oa.0 lvds_lane_0.VB2.0 lvds_lane_1.fa.0 VSS nfet_03v3 ad=1.1752p pd=5.04u as=1.1752p ps=5.04u w=4.52u l=0.5u
X81 VSS VSS lvds_lane_1.fb.0 VSS nfet_03v3 ad=1.9888p pd=9.92u as=1.1752p ps=5.04u w=4.52u l=0.5u
X82 lvds_lane_0.tn.0 VSS VSS VSS nfet_03v3 ad=0.65p pd=3.02u as=1.1p ps=5.88u w=2.5u l=1u
X83 VDD lvds_lane_0.VBP.0 lvds_lane_1.tp.0 VDD pfet_03v3 ad=1.3p pd=5.52u as=1.3p ps=5.52u w=5u l=1u
X84 lvds_lane_0.oa.0 lvds_lane_0.VREF.0 lvds_lane_0.tn.0 VSS nfet_03v3 ad=1.235p pd=5.27u as=1.235p ps=5.27u w=4.75u l=0.5u
X85 lvds_lane_0.n3a.0 lvds_lane_0.d2a.0 VDD VDD pfet_03v3 ad=0.52p pd=2.52u as=0.52p ps=2.52u w=2u l=0.4u
X86 lvds_lane_2.i2.0 lvds_lane_2.i1.0 VDD VDD pfet_03v3 ad=0.975p pd=4.27u as=0.975p ps=4.27u w=3.75u l=0.28u
X87 VDD VDD VDD VDD pfet_03v3 ad=0.52p pd=2.52u as=0.29839n ps=1.38742m w=2u l=0.5u
X88 VDD EN lvds_lane_1.d2a.0 VDD pfet_03v3 ad=0.52p pd=2.52u as=0.52p ps=2.52u w=2u l=0.5u
X89 lvds_lane_1.oa.0 VSS VSS VSS nfet_03v3 ad=1.1752p pd=5.04u as=1.9888p ps=9.92u w=4.52u l=0.5u
X90 lvds_lane_2.tp.0 lvds_lane_0.VREF.0 lvds_lane_2.fb.0 lvds_lane_2.tp.0 pfet_03v3 ad=1.248p pd=5.32u as=1.248p ps=5.32u w=4.8u l=0.4u
X91 lvds_lane_1.ts.0 lvds_lane_0.VBN.0 VSS VSS nfet_03v3 ad=0.65p pd=3.02u as=0.65p ps=3.02u w=2.5u l=1u
X92 lvds_lane_1.tp.0 lvds_lane_1.gn.0 lvds_lane_1.fb.0 lvds_lane_1.tp.0 pfet_03v3 ad=1.248p pd=5.32u as=1.248p ps=5.32u w=4.8u l=0.4u
X93 lvds_lane_0.ob.0 lvds_lane_0.VREF.0 lvds_lane_0.tn.0 VSS nfet_03v3 ad=1.235p pd=5.27u as=1.235p ps=5.27u w=4.75u l=0.5u
X94 VSS VSS RX2_O VSS nfet_03v3 ad=1.76p pd=8.88u as=1.04p ps=4.52u w=4u l=0.28u
X95 lvds_lane_0.tp.0 lvds_lane_0.VREF.0 lvds_lane_0.fa.0 lvds_lane_0.tp.0 pfet_03v3 ad=1.248p pd=5.32u as=1.248p ps=5.32u w=4.8u l=0.4u
X96 lvds_lane_2.fb.0 lvds_lane_0.VREF.0 lvds_lane_2.tp.0 lvds_lane_2.tp.0 pfet_03v3 ad=1.248p pd=5.32u as=1.248p ps=5.32u w=4.8u l=0.4u
X97 lvds_lane_1.oa.0 lvds_lane_1.gp.0 lvds_lane_1.tn.0 VSS nfet_03v3 ad=1.235p pd=5.27u as=1.235p ps=5.27u w=4.75u l=0.5u
X98 lvds_lane_2.tn.0 lvds_lane_0.VREF.0 lvds_lane_2.oa.0 VSS nfet_03v3 ad=1.235p pd=5.27u as=1.235p ps=5.27u w=4.75u l=0.5u
X99 lvds_lane_0.oa.0 lvds_lane_0.VREF.0 lvds_lane_0.tn.0 VSS nfet_03v3 ad=1.235p pd=5.27u as=1.235p ps=5.27u w=4.75u l=0.5u
X100 VDD lvds_lane_1.d2a.0 lvds_lane_1.n3a.0 VDD pfet_03v3 ad=0.52p pd=2.52u as=0.52p ps=2.52u w=2u l=0.4u
X101 lvds_lane_0.tp.0 lvds_lane_0.VBP.0 VDD VDD pfet_03v3 ad=1.3p pd=5.52u as=1.3p ps=5.52u w=5u l=1u
X102 VSS VSS VSS ppolyf_u_1k r_width=2u r_length=23.07u
X103 lvds_lane_0.fa.0 lvds_lane_0.gp.0 lvds_lane_0.tp.0 lvds_lane_0.tp.0 pfet_03v3 ad=1.248p pd=5.32u as=1.248p ps=5.32u w=4.8u l=0.4u
X104 lvds_lane_1.fa.0 lvds_lane_1.gp.0 lvds_lane_1.tp.0 lvds_lane_1.tp.0 pfet_03v3 ad=1.248p pd=5.32u as=1.248p ps=5.32u w=4.8u l=0.4u
X105 lvds_lane_1.ob.0 lvds_lane_1.gn.0 lvds_lane_1.tn.0 VSS nfet_03v3 ad=1.235p pd=5.27u as=1.235p ps=5.27u w=4.75u l=0.5u
X106 lvds_lane_1.tp.0 lvds_lane_0.VBP.0 VDD VDD pfet_03v3 ad=1.3p pd=5.52u as=1.3p ps=5.52u w=5u l=1u
X107 lvds_lane_2.tp.0 lvds_lane_0.VREF.0 lvds_lane_2.fa.0 lvds_lane_2.tp.0 pfet_03v3 ad=1.248p pd=5.32u as=1.248p ps=5.32u w=4.8u l=0.4u
X108 VDD VDD lvds_lane_2.n3a.0 VDD pfet_03v3 ad=0.88p pd=4.88u as=0.52p ps=2.52u w=2u l=0.4u
X109 lvds_lane_2.gp.0 RX2_P VDD ppolyf_u r_width=5u r_length=1.8u
X110 lvds_lane_0.tp.0 lvds_lane_0.gp.0 lvds_lane_0.fa.0 lvds_lane_0.tp.0 pfet_03v3 ad=1.248p pd=5.32u as=1.248p ps=5.32u w=4.8u l=0.4u
X111 lvds_lane_1.ob.0 lvds_lane_0.VREF.0 lvds_lane_1.tn.0 VSS nfet_03v3 ad=1.235p pd=5.27u as=1.235p ps=5.27u w=4.75u l=0.5u
X112 VSS lvds_lane_0.VBN.0 lvds_lane_0.tn.0 VSS nfet_03v3 ad=0.65p pd=3.02u as=0.65p ps=3.02u w=2.5u l=1u
X113 lvds_lane_0.tp.0 lvds_lane_0.gn.0 lvds_lane_0.fb.0 lvds_lane_0.tp.0 pfet_03v3 ad=1.248p pd=5.32u as=1.248p ps=5.32u w=4.8u l=0.4u
X114 lvds_lane_0.tp.0 lvds_lane_0.gn.0 lvds_lane_0.fb.0 lvds_lane_0.tp.0 pfet_03v3 ad=1.248p pd=5.32u as=1.248p ps=5.32u w=4.8u l=0.4u
X115 VSS lvds_lane_0.VBN.0 lvds_lane_1.fa.0 VSS nfet_03v3 ad=0.65p pd=3.02u as=0.65p ps=3.02u w=2.5u l=1u
X116 lvds_lane_2.ts.0 lvds_lane_0.VBN.0 VSS VSS nfet_03v3 ad=0.65p pd=3.02u as=0.65p ps=3.02u w=2.5u l=1u
X117 lvds_lane_1.fa.0 lvds_lane_0.VREF.0 lvds_lane_1.tp.0 lvds_lane_1.tp.0 pfet_03v3 ad=1.248p pd=5.32u as=1.248p ps=5.32u w=4.8u l=0.4u
X118 lvds_lane_2.fa.0 lvds_lane_0.VREF.0 lvds_lane_2.tp.0 lvds_lane_2.tp.0 pfet_03v3 ad=1.248p pd=5.32u as=1.248p ps=5.32u w=4.8u l=0.4u
X119 lvds_bias_0.nmid.0 EN VSS VSS nfet_03v3 ad=1.3p pd=5.52u as=1.3p ps=5.52u w=5u l=0.5u
X120 VDD VDD VDD VDD pfet_03v3 ad=1.3p pd=5.52u as=0 ps=0 w=5u l=1u
X121 lvds_lane_0.fa.0 lvds_lane_0.VBN.0 VSS VSS nfet_03v3 ad=0.65p pd=3.02u as=0.65p ps=3.02u w=2.5u l=1u
X122 VSS lvds_lane_0.VBN.0 lvds_lane_1.tn.0 VSS nfet_03v3 ad=0.65p pd=3.02u as=0.65p ps=3.02u w=2.5u l=1u
X123 VSS lvds_lane_0.VBN.0 lvds_lane_0.VBN.0 VSS nfet_03v3 ad=0.65p pd=3.02u as=0.65p ps=3.02u w=2.5u l=1u
X124 lvds_lane_2.d2b.0 lvds_lane_2.ob.0 lvds_lane_2.sb.0 VSS nfet_03v3 ad=1.0036p pd=4.38u as=1.0036p ps=4.38u w=3.86u l=0.5u
X125 lvds_lane_0.VB2.0 lvds_lane_0.VBP.0 VDD VDD pfet_03v3 ad=1.3p pd=5.52u as=1.3p ps=5.52u w=5u l=1u
X126 lvds_lane_0.fb.0 lvds_lane_0.gn.0 lvds_lane_0.tp.0 lvds_lane_0.tp.0 pfet_03v3 ad=1.248p pd=5.32u as=1.248p ps=5.32u w=4.8u l=0.4u
X127 lvds_lane_2.tp.0 lvds_lane_0.VREF.0 lvds_lane_2.fa.0 lvds_lane_2.tp.0 pfet_03v3 ad=1.248p pd=5.32u as=1.248p ps=5.32u w=4.8u l=0.4u
X128 VDD lvds_bias_0.rdt_m1.0 VSS ppolyf_u_1k r_width=2u r_length=21.01u
X129 lvds_lane_2.tn.0 lvds_lane_0.VREF.0 lvds_lane_2.oa.0 VSS nfet_03v3 ad=1.235p pd=5.27u as=1.235p ps=5.27u w=4.75u l=0.5u
X130 lvds_lane_2.d2b.0 lvds_lane_2.d2b.0 VDD VDD pfet_03v3 ad=0.52p pd=2.52u as=0.52p ps=2.52u w=2u l=0.4u
X131 lvds_bias_0.nmid.0 VSS VSS VSS nfet_03v3 ad=1.3p pd=5.52u as=2.2p ps=10.88u w=5u l=0.5u
X132 lvds_lane_0.sb.0 lvds_lane_0.ob.0 lvds_lane_0.d2b.0 VSS nfet_03v3 ad=1.0036p pd=4.38u as=1.0036p ps=4.38u w=3.86u l=0.5u
X133 VSS VSS lvds_lane_0.sa.0 VSS nfet_03v3 ad=1.6984p pd=8.6u as=1.0036p ps=4.38u w=3.86u l=0.5u
X134 lvds_lane_2.fa.0 lvds_lane_0.VREF.0 lvds_lane_2.tp.0 lvds_lane_2.tp.0 pfet_03v3 ad=1.248p pd=5.32u as=1.248p ps=5.32u w=4.8u l=0.4u
X135 lvds_lane_1.tn.0 lvds_lane_1.gn.0 lvds_lane_1.ob.0 VSS nfet_03v3 ad=1.235p pd=5.27u as=1.235p ps=5.27u w=4.75u l=0.5u
X136 VDD EN lvds_bias_0.enb.0 VDD pfet_03v3 ad=0.65p pd=3.02u as=0.65p ps=3.02u w=2.5u l=0.28u
X137 VDD lvds_lane_2.d2b.0 lvds_lane_2.d3.0 VDD pfet_03v3 ad=0.52p pd=2.52u as=0.52p ps=2.52u w=2u l=0.4u
X138 lvds_lane_2.fb.0 lvds_lane_0.VB2.0 lvds_lane_2.ob.0 VSS nfet_03v3 ad=1.1752p pd=5.04u as=1.1752p ps=5.04u w=4.52u l=0.5u
X139 lvds_lane_2.tn.0 lvds_lane_0.VREF.0 lvds_lane_2.ob.0 VSS nfet_03v3 ad=1.235p pd=5.27u as=1.235p ps=5.27u w=4.75u l=0.5u
X140 lvds_lane_2.fa.0 lvds_lane_0.VREF.0 lvds_lane_2.tp.0 lvds_lane_2.tp.0 pfet_03v3 ad=1.248p pd=5.32u as=1.248p ps=5.32u w=4.8u l=0.4u
X141 lvds_lane_2.oa.0 lvds_lane_0.VB2.0 lvds_lane_2.fa.0 VSS nfet_03v3 ad=1.1752p pd=5.04u as=1.1752p ps=5.04u w=4.52u l=0.5u
X142 VDD EN lvds_lane_2.d2b.0 VDD pfet_03v3 ad=0.52p pd=2.52u as=0.52p ps=2.52u w=2u l=0.5u
X143 lvds_lane_0.fb.0 lvds_lane_0.gn.0 lvds_lane_0.tp.0 lvds_lane_0.tp.0 pfet_03v3 ad=1.248p pd=5.32u as=1.248p ps=5.32u w=4.8u l=0.4u
X144 lvds_lane_1.fb.0 lvds_lane_1.gn.0 lvds_lane_1.tp.0 lvds_lane_1.tp.0 pfet_03v3 ad=1.248p pd=5.32u as=1.248p ps=5.32u w=4.8u l=0.4u
X145 VSS lvds_lane_0.VBN.0 lvds_lane_2.fa.0 VSS nfet_03v3 ad=0.65p pd=3.02u as=0.65p ps=3.02u w=2.5u l=1u
X146 lvds_lane_2.fb.0 lvds_lane_0.VB2.0 lvds_lane_2.ob.0 VSS nfet_03v3 ad=1.1752p pd=5.04u as=1.1752p ps=5.04u w=4.52u l=0.5u
X147 lvds_lane_1.tn.0 lvds_lane_1.gp.0 lvds_lane_1.oa.0 VSS nfet_03v3 ad=1.235p pd=5.27u as=1.235p ps=5.27u w=4.75u l=0.5u
X148 lvds_lane_1.ts.0 lvds_lane_0.VBN.0 VSS VSS nfet_03v3 ad=0.65p pd=3.02u as=0.65p ps=3.02u w=2.5u l=1u
X149 VDD lvds_lane_0.VBP.0 lvds_lane_1.tp.0 VDD pfet_03v3 ad=1.3p pd=5.52u as=1.3p ps=5.52u w=5u l=1u
X150 VSS VSS VSS ppolyf_u_1k r_width=2u r_length=21.01u
X151 lvds_bias_0.rdb_m2.0 lvds_bias_0.rdb_m3.0 VSS ppolyf_u_1k r_width=2u r_length=19.26u
D1 lvds_lane_1.gn.0 VDD diode_pd2nw_03v3 pj=26u area=40p
X152 VDD lvds_lane_0.VBP.0 lvds_lane_2.tp.0 VDD pfet_03v3 ad=1.3p pd=5.52u as=1.3p ps=5.52u w=5u l=1u
X153 VDD lvds_lane_0.VBP.0 lvds_lane_0.VB2.0 VDD pfet_03v3 ad=1.3p pd=5.52u as=1.3p ps=5.52u w=5u l=1u
X154 lvds_lane_2.tp.0 lvds_lane_0.VREF.0 lvds_lane_2.fb.0 lvds_lane_2.tp.0 pfet_03v3 ad=1.248p pd=5.32u as=1.248p ps=5.32u w=4.8u l=0.4u
X155 VSS lvds_lane_0.VBN.0 lvds_lane_0.fa.0 VSS nfet_03v3 ad=0.65p pd=3.02u as=0.65p ps=3.02u w=2.5u l=1u
X156 lvds_lane_0.ob.0 lvds_lane_0.VB2.0 lvds_lane_0.fb.0 VSS nfet_03v3 ad=1.1752p pd=5.04u as=1.1752p ps=5.04u w=4.52u l=0.5u
X157 lvds_lane_1.fb.0 lvds_lane_0.VREF.0 lvds_lane_1.tp.0 lvds_lane_1.tp.0 pfet_03v3 ad=2.112p pd=10.48u as=1.248p ps=5.32u w=4.8u l=0.4u
X158 lvds_lane_0.oa.0 lvds_lane_0.VREF.0 lvds_lane_0.tn.0 VSS nfet_03v3 ad=1.235p pd=5.27u as=1.235p ps=5.27u w=4.75u l=0.5u
X159 lvds_lane_2.ob.0 lvds_lane_2.rlb_m1.0 VSS ppolyf_u_1k r_width=2u r_length=9.11u
X160 lvds_lane_2.gn.0 RX2_N VDD ppolyf_u r_width=5u r_length=1.8u
X161 lvds_lane_0.tp.0 lvds_lane_0.gn.0 lvds_lane_0.fb.0 lvds_lane_0.tp.0 pfet_03v3 ad=1.248p pd=5.32u as=1.248p ps=5.32u w=4.8u l=0.4u
X162 VSS VSS lvds_bias_0.vf.0 VSS nfet_03v3 ad=3.4804p pd=16.7u as=2.0566p ps=8.43u w=7.91u l=0.5u
X163 lvds_lane_2.d2b.0 lvds_lane_2.d2a.0 VDD VDD pfet_03v3 ad=0.52p pd=2.52u as=0.52p ps=2.52u w=2u l=0.4u
X164 lvds_lane_2.d3.0 lvds_lane_2.d2b.0 VDD VDD pfet_03v3 ad=0.52p pd=2.52u as=0.52p ps=2.52u w=2u l=0.4u
X165 lvds_lane_0.ob.0 lvds_lane_0.VB2.0 lvds_lane_0.fb.0 VSS nfet_03v3 ad=1.1752p pd=5.04u as=1.1752p ps=5.04u w=4.52u l=0.5u
X166 lvds_lane_1.fb.0 lvds_lane_0.VBN.0 VSS VSS nfet_03v3 ad=0.65p pd=3.02u as=0.65p ps=3.02u w=2.5u l=1u
X167 lvds_lane_2.ob.0 lvds_lane_2.gn.0 lvds_lane_2.tn.0 VSS nfet_03v3 ad=1.235p pd=5.27u as=1.235p ps=5.27u w=4.75u l=0.5u
X168 lvds_lane_1.fb.0 lvds_lane_0.VREF.0 lvds_lane_1.tp.0 lvds_lane_1.tp.0 pfet_03v3 ad=1.248p pd=5.32u as=1.248p ps=5.32u w=4.8u l=0.4u
X169 lvds_lane_1.tn.0 lvds_lane_0.VBN.0 VSS VSS nfet_03v3 ad=0.65p pd=3.02u as=0.65p ps=3.02u w=2.5u l=1u
X170 VDD lvds_lane_2.nd.0 lvds_lane_2.i1.0 VDD pfet_03v3 ad=0.962p pd=4.22u as=0.962p ps=4.22u w=3.7u l=0.28u
X171 lvds_lane_1.tp.0 lvds_lane_0.VBP.0 VDD VDD pfet_03v3 ad=1.3p pd=5.52u as=1.3p ps=5.52u w=5u l=1u
X172 lvds_lane_2.fa.0 lvds_lane_0.VBN.0 VSS VSS nfet_03v3 ad=0.65p pd=3.02u as=0.65p ps=3.02u w=2.5u l=1u
X173 lvds_lane_1.sb.0 lvds_lane_1.ob.0 lvds_lane_1.d2b.0 VSS nfet_03v3 ad=1.0036p pd=4.38u as=1.0036p ps=4.38u w=3.86u l=0.5u
X174 lvds_lane_0.fa.0 lvds_lane_0.gp.0 lvds_lane_0.tp.0 lvds_lane_0.tp.0 pfet_03v3 ad=1.248p pd=5.32u as=1.248p ps=5.32u w=4.8u l=0.4u
X175 lvds_lane_0.tp.0 lvds_lane_0.VREF.0 lvds_lane_0.fa.0 lvds_lane_0.tp.0 pfet_03v3 ad=1.248p pd=5.32u as=1.248p ps=5.32u w=4.8u l=0.4u
X176 lvds_lane_1.fb.0 lvds_lane_1.gn.0 lvds_lane_1.tp.0 lvds_lane_1.tp.0 pfet_03v3 ad=1.248p pd=5.32u as=1.248p ps=5.32u w=4.8u l=0.4u
X177 lvds_lane_0.ob.0 VSS VSS VSS nfet_03v3 ad=1.1752p pd=5.04u as=1.9888p ps=9.92u w=4.52u l=0.5u
X178 VSS lvds_lane_0.VBN.0 lvds_lane_1.fb.0 VSS nfet_03v3 ad=0.65p pd=3.02u as=0.65p ps=3.02u w=2.5u l=1u
X179 lvds_lane_2.tn.0 lvds_lane_0.VBN.0 VSS VSS nfet_03v3 ad=0.65p pd=3.02u as=0.65p ps=3.02u w=2.5u l=1u
X180 VDD lvds_lane_1.d2a.0 lvds_lane_1.d2a.0 VDD pfet_03v3 ad=0.52p pd=2.52u as=0.52p ps=2.52u w=2u l=0.4u
X181 lvds_lane_2.tp.0 lvds_lane_0.VBP.0 VDD VDD pfet_03v3 ad=1.3p pd=5.52u as=1.3p ps=5.52u w=5u l=1u
X182 VDD lvds_lane_1.d2a.0 lvds_lane_1.n3a.0 VDD pfet_03v3 ad=0.52p pd=2.52u as=0.52p ps=2.52u w=2u l=0.4u
D2 VSS lvds_lane_1.gn.0 diode_nd2ps_03v3 pj=26u area=40p
X183 lvds_lane_2.fb.0 lvds_lane_0.VREF.0 lvds_lane_2.tp.0 lvds_lane_2.tp.0 pfet_03v3 ad=1.248p pd=5.32u as=1.248p ps=5.32u w=4.8u l=0.4u
X184 VSS lvds_lane_0.VBN.0 lvds_lane_1.ts.0 VSS nfet_03v3 ad=0.65p pd=3.02u as=0.65p ps=3.02u w=2.5u l=1u
X185 lvds_lane_2.ts.0 lvds_lane_2.sa.0 VSS ppolyf_u_1k r_width=2u r_length=8.86u
X186 lvds_lane_2.sa.0 lvds_lane_2.oa.0 lvds_lane_2.d2a.0 VSS nfet_03v3 ad=1.0036p pd=4.38u as=1.0036p ps=4.38u w=3.86u l=0.5u
X187 lvds_lane_2.tp.0 lvds_lane_0.VBP.0 VDD VDD pfet_03v3 ad=1.3p pd=5.52u as=1.3p ps=5.52u w=5u l=1u
X188 lvds_lane_2.oa.0 lvds_lane_0.VREF.0 lvds_lane_2.tn.0 VSS nfet_03v3 ad=1.235p pd=5.27u as=1.235p ps=5.27u w=4.75u l=0.5u
X189 lvds_lane_1.i2.0 VDD VDD VDD pfet_03v3 ad=0.975p pd=4.27u as=1.65p ps=8.38u w=3.75u l=0.28u
X190 lvds_lane_0.VB2.0 VSS VSS VSS nfet_03v3 ad=2.0566p pd=8.43u as=3.4804p ps=16.7u w=7.91u l=0.5u
X191 lvds_lane_1.n3a.0 lvds_lane_1.d2a.0 VDD VDD pfet_03v3 ad=0.52p pd=2.52u as=0.52p ps=2.52u w=2u l=0.4u
X192 VSS VSS VSS ppolyf_u_1k r_width=2u r_length=9.11u
X193 lvds_lane_1.fb.0 lvds_lane_0.VREF.0 lvds_lane_1.tp.0 lvds_lane_1.tp.0 pfet_03v3 ad=1.248p pd=5.32u as=1.248p ps=5.32u w=4.8u l=0.4u
X194 lvds_lane_0.tp.0 lvds_lane_0.gn.0 lvds_lane_0.fb.0 lvds_lane_0.tp.0 pfet_03v3 ad=1.248p pd=5.32u as=1.248p ps=5.32u w=4.8u l=0.4u
X195 lvds_lane_2.fb.0 lvds_lane_2.gn.0 lvds_lane_2.tp.0 lvds_lane_2.tp.0 pfet_03v3 ad=1.248p pd=5.32u as=1.248p ps=5.32u w=4.8u l=0.4u
X196 lvds_lane_0.fb.0 lvds_lane_0.VBN.0 VSS VSS nfet_03v3 ad=0.65p pd=3.02u as=0.65p ps=3.02u w=2.5u l=1u
X197 lvds_lane_2.ob.0 lvds_lane_2.gn.0 lvds_lane_2.tn.0 VSS nfet_03v3 ad=1.235p pd=5.27u as=1.235p ps=5.27u w=4.75u l=0.5u
X198 VDD lvds_lane_0.VBP.0 lvds_lane_1.tp.0 VDD pfet_03v3 ad=1.3p pd=5.52u as=1.3p ps=5.52u w=5u l=1u
X199 lvds_lane_1.fa.0 lvds_lane_0.VREF.0 lvds_lane_1.tp.0 lvds_lane_1.tp.0 pfet_03v3 ad=1.248p pd=5.32u as=1.248p ps=5.32u w=4.8u l=0.4u
X200 lvds_lane_2.tp.0 lvds_lane_2.gp.0 lvds_lane_2.fa.0 lvds_lane_2.tp.0 pfet_03v3 ad=1.248p pd=5.32u as=1.248p ps=5.32u w=4.8u l=0.4u
X201 lvds_lane_1.n3a.0 lvds_lane_1.d2a.0 VDD VDD pfet_03v3 ad=0.52p pd=2.52u as=0.52p ps=2.52u w=2u l=0.4u
X202 lvds_lane_0.tp.0 lvds_lane_0.VBP.0 VDD VDD pfet_03v3 ad=1.3p pd=5.52u as=1.3p ps=5.52u w=5u l=1u
X203 lvds_lane_0.VBP.0 VDD VDD VDD pfet_03v3 ad=1.3p pd=5.52u as=2.2p ps=10.88u w=5u l=1u
X204 lvds_lane_2.oa.0 lvds_lane_2.gp.0 lvds_lane_2.tn.0 VSS nfet_03v3 ad=1.235p pd=5.27u as=1.235p ps=5.27u w=4.75u l=0.5u
X205 VSS VSS lvds_lane_1.fa.0 VSS nfet_03v3 ad=1.9888p pd=9.92u as=1.1752p ps=5.04u w=4.52u l=0.5u
X206 VSS lvds_lane_0.VBN.0 lvds_lane_2.fa.0 VSS nfet_03v3 ad=0.65p pd=3.02u as=0.65p ps=3.02u w=2.5u l=1u
X207 lvds_lane_0.tn.0 lvds_lane_0.gp.0 lvds_lane_0.oa.0 VSS nfet_03v3 ad=1.235p pd=5.27u as=1.235p ps=5.27u w=4.75u l=0.5u
X208 VDD lvds_lane_0.VBP.0 lvds_lane_0.VBP.0 VDD pfet_03v3 ad=1.3p pd=5.52u as=1.3p ps=5.52u w=5u l=1u
X209 lvds_lane_0.fb.0 lvds_lane_0.gn.0 lvds_lane_0.tp.0 lvds_lane_0.tp.0 pfet_03v3 ad=1.248p pd=5.32u as=1.248p ps=5.32u w=4.8u l=0.4u
X210 lvds_lane_1.tp.0 lvds_lane_0.VREF.0 lvds_lane_1.fb.0 lvds_lane_1.tp.0 pfet_03v3 ad=1.248p pd=5.32u as=1.248p ps=5.32u w=4.8u l=0.4u
X211 VSS lvds_lane_0.VBN.0 lvds_lane_0.fb.0 VSS nfet_03v3 ad=0.65p pd=3.02u as=0.65p ps=3.02u w=2.5u l=1u
X212 VSS VSS VSS ppolyf_u_1k r_width=2u r_length=8.86u
X213 VDD lvds_lane_0.VBP.0 lvds_lane_2.tp.0 VDD pfet_03v3 ad=1.3p pd=5.52u as=1.3p ps=5.52u w=5u l=1u
X214 lvds_lane_1.fa.0 lvds_lane_1.gp.0 lvds_lane_1.tp.0 lvds_lane_1.tp.0 pfet_03v3 ad=1.248p pd=5.32u as=1.248p ps=5.32u w=4.8u l=0.4u
X215 lvds_lane_1.oa.0 lvds_lane_0.VB2.0 lvds_lane_1.fa.0 VSS nfet_03v3 ad=1.1752p pd=5.04u as=1.1752p ps=5.04u w=4.52u l=0.5u
X216 VSS VSS lvds_lane_2.tn.0 VSS nfet_03v3 ad=1.1p pd=5.88u as=0.65p ps=3.02u w=2.5u l=1u
X217 VSS lvds_lane_0.VBN.0 lvds_lane_1.fa.0 VSS nfet_03v3 ad=0.65p pd=3.02u as=0.65p ps=3.02u w=2.5u l=1u
X218 VSS VSS VSS ppolyf_u_1k r_width=2u r_length=22.27u
X219 lvds_lane_0.fb.0 lvds_lane_0.VREF.0 lvds_lane_0.tp.0 lvds_lane_0.tp.0 pfet_03v3 ad=1.248p pd=5.32u as=1.248p ps=5.32u w=4.8u l=0.4u
X220 lvds_lane_0.tn.0 lvds_lane_0.gp.0 lvds_lane_0.oa.0 VSS nfet_03v3 ad=1.235p pd=5.27u as=1.235p ps=5.27u w=4.75u l=0.5u
X221 lvds_lane_2.n3a.0 VSS VSS VSS nfet_03v3 ad=0.6734p pd=3.11u as=1.1396p ps=6.06u w=2.59u l=0.28u
X222 VDD lvds_lane_0.VBP.0 lvds_lane_2.tp.0 VDD pfet_03v3 ad=1.3p pd=5.52u as=1.3p ps=5.52u w=5u l=1u
X223 lvds_lane_2.tp.0 lvds_lane_2.gn.0 lvds_lane_2.fb.0 lvds_lane_2.tp.0 pfet_03v3 ad=1.248p pd=5.32u as=1.248p ps=5.32u w=4.8u l=0.4u
X224 lvds_lane_1.d2b.0 VDD VDD VDD pfet_03v3 ad=0.52p pd=2.52u as=0.88p ps=4.88u w=2u l=0.5u
X225 lvds_lane_1.d3.0 lvds_lane_1.d2b.0 VDD VDD pfet_03v3 ad=0.52p pd=2.52u as=0.52p ps=2.52u w=2u l=0.4u
X226 lvds_lane_0.d3.0 lvds_lane_0.d2b.0 VDD VDD pfet_03v3 ad=0.52p pd=2.52u as=0.52p ps=2.52u w=2u l=0.4u
X227 lvds_lane_1.tp.0 lvds_lane_1.gp.0 lvds_lane_1.fa.0 lvds_lane_1.tp.0 pfet_03v3 ad=1.248p pd=5.32u as=1.248p ps=5.32u w=4.8u l=0.4u
X228 lvds_lane_0.d2a.0 VDD VDD VDD pfet_03v3 ad=0.52p pd=2.52u as=0.88p ps=4.88u w=2u l=0.4u
X229 lvds_lane_0.tn.0 lvds_lane_0.gn.0 lvds_lane_0.ob.0 VSS nfet_03v3 ad=1.235p pd=5.27u as=1.235p ps=5.27u w=4.75u l=0.5u
X230 lvds_bias_0.nrb.0 VDD VDD VDD pfet_03v3 ad=1.3p pd=5.52u as=2.2p ps=10.88u w=5u l=0.5u
X231 VSS VSS VSS ppolyf_u_1k r_width=2u r_length=8.86u
X232 lvds_lane_2.fa.0 lvds_lane_0.VBN.0 VSS VSS nfet_03v3 ad=0.65p pd=3.02u as=0.65p ps=3.02u w=2.5u l=1u
X233 VSS VSS lvds_lane_0.VBP.0 VSS nfet_03v3 ad=1.1p pd=5.88u as=0.65p ps=3.02u w=2.5u l=1u
X234 lvds_lane_2.tn.0 lvds_lane_0.VREF.0 lvds_lane_2.ob.0 VSS nfet_03v3 ad=1.235p pd=5.27u as=2.09p ps=10.38u w=4.75u l=0.5u
X235 lvds_lane_2.tn.0 lvds_lane_0.VREF.0 lvds_lane_2.oa.0 VSS nfet_03v3 ad=1.235p pd=5.27u as=1.235p ps=5.27u w=4.75u l=0.5u
X236 lvds_lane_2.tp.0 lvds_lane_0.VBP.0 VDD VDD pfet_03v3 ad=1.3p pd=5.52u as=1.3p ps=5.52u w=5u l=1u
X237 lvds_lane_0.fb.0 lvds_lane_0.gn.0 lvds_lane_0.tp.0 lvds_lane_0.tp.0 pfet_03v3 ad=1.248p pd=5.32u as=1.248p ps=5.32u w=4.8u l=0.4u
X238 VSS VSS VSS VSS nfet_03v3 ad=0.52p pd=2.52u as=0 ps=0 w=2u l=0.5u
X239 lvds_bias_0.rb_m1.0 lvds_bias_0.nrb.0 VSS ppolyf_u_1k r_width=2u r_length=22.27u
X240 lvds_lane_0.tp.0 lvds_lane_0.VREF.0 lvds_lane_0.fa.0 lvds_lane_0.tp.0 pfet_03v3 ad=1.248p pd=5.32u as=1.248p ps=5.32u w=4.8u l=0.4u
X241 VSS lvds_lane_1.i1.0 lvds_lane_1.i2.0 VSS nfet_03v3 ad=0.78p pd=3.52u as=0.78p ps=3.52u w=3u l=0.28u
X242 VSS lvds_lane_1.i2.0 RX1_O VSS nfet_03v3 ad=1.04p pd=4.52u as=1.04p ps=4.52u w=4u l=0.28u
X243 lvds_lane_2.fb.0 lvds_lane_2.gn.0 lvds_lane_2.tp.0 lvds_lane_2.tp.0 pfet_03v3 ad=1.248p pd=5.32u as=1.248p ps=5.32u w=4.8u l=0.4u
X244 lvds_lane_1.oa.0 lvds_lane_1.gp.0 lvds_lane_1.tn.0 VSS nfet_03v3 ad=1.235p pd=5.27u as=1.235p ps=5.27u w=4.75u l=0.5u
X245 VDD VDD lvds_lane_1.tp.0 VDD pfet_03v3 ad=2.2p pd=10.88u as=1.3p ps=5.52u w=5u l=1u
X246 lvds_lane_2.fb.0 lvds_lane_0.VREF.0 lvds_lane_2.tp.0 lvds_lane_2.tp.0 pfet_03v3 ad=1.248p pd=5.32u as=1.248p ps=5.32u w=4.8u l=0.4u
X247 lvds_lane_0.VBN.0 VSS VSS VSS nfet_03v3 ad=0.52p pd=2.52u as=0.88p ps=4.88u w=2u l=0.5u
X248 VDD lvds_lane_1.d3.0 lvds_lane_1.nd.0 VDD pfet_03v3 ad=0.78p pd=3.52u as=0.78p ps=3.52u w=3u l=0.28u
X249 lvds_lane_0.tp.0 lvds_lane_0.VREF.0 lvds_lane_0.fa.0 lvds_lane_0.tp.0 pfet_03v3 ad=1.248p pd=5.32u as=1.248p ps=5.32u w=4.8u l=0.4u
X250 VSS VSS lvds_lane_2.d3.0 VSS nfet_03v3 ad=1.1396p pd=6.06u as=0.6734p ps=3.11u w=2.59u l=0.28u
X251 lvds_lane_1.fb.0 lvds_lane_1.gn.0 lvds_lane_1.tp.0 lvds_lane_1.tp.0 pfet_03v3 ad=1.248p pd=5.32u as=1.248p ps=5.32u w=4.8u l=0.4u
X252 lvds_lane_1.ob.0 lvds_lane_0.VREF.0 lvds_lane_1.tn.0 VSS nfet_03v3 ad=1.235p pd=5.27u as=1.235p ps=5.27u w=4.75u l=0.5u
X253 lvds_lane_1.fb.0 lvds_lane_0.VBN.0 VSS VSS nfet_03v3 ad=0.65p pd=3.02u as=0.65p ps=3.02u w=2.5u l=1u
X254 VSS lvds_lane_0.VBN.0 lvds_lane_2.tn.0 VSS nfet_03v3 ad=0.65p pd=3.02u as=0.65p ps=3.02u w=2.5u l=1u
X255 lvds_lane_0.fa.0 lvds_lane_0.VREF.0 lvds_lane_0.tp.0 lvds_lane_0.tp.0 pfet_03v3 ad=1.248p pd=5.32u as=1.248p ps=5.32u w=4.8u l=0.4u
X256 lvds_lane_1.tp.0 lvds_lane_1.gp.0 lvds_lane_1.fa.0 lvds_lane_1.tp.0 pfet_03v3 ad=1.248p pd=5.32u as=1.248p ps=5.32u w=4.8u l=0.4u
X257 lvds_lane_1.tp.0 lvds_lane_1.gp.0 lvds_lane_1.fa.0 lvds_lane_1.tp.0 pfet_03v3 ad=1.248p pd=5.32u as=1.248p ps=5.32u w=4.8u l=0.4u
X258 lvds_lane_2.tp.0 lvds_lane_0.VREF.0 lvds_lane_2.fa.0 lvds_lane_2.tp.0 pfet_03v3 ad=1.248p pd=5.32u as=1.248p ps=5.32u w=4.8u l=0.4u
X259 RX1_O lvds_lane_1.i2.0 VDD VDD pfet_03v3 ad=1.3p pd=5.52u as=1.3p ps=5.52u w=5u l=0.28u
X260 lvds_lane_1.n3a.0 VDD VDD VDD pfet_03v3 ad=0.52p pd=2.52u as=0.88p ps=4.88u w=2u l=0.4u
X261 lvds_lane_2.d2b.0 VSS VSS VSS nfet_03v3 ad=1.0036p pd=4.38u as=1.6984p ps=8.6u w=3.86u l=0.5u
X262 lvds_lane_0.tp.0 lvds_lane_0.gn.0 lvds_lane_0.fb.0 lvds_lane_0.tp.0 pfet_03v3 ad=1.248p pd=5.32u as=1.248p ps=5.32u w=4.8u l=0.4u
X263 lvds_lane_1.fa.0 lvds_lane_1.gp.0 lvds_lane_1.tp.0 lvds_lane_1.tp.0 pfet_03v3 ad=1.248p pd=5.32u as=1.248p ps=5.32u w=4.8u l=0.4u
X264 lvds_bias_0.nmid.0 lvds_bias_0.rdb_m3.0 VSS ppolyf_u_1k r_width=2u r_length=19.26u
X265 lvds_lane_0.d2a.0 lvds_lane_0.oa.0 lvds_lane_0.sa.0 VSS nfet_03v3 ad=1.0036p pd=4.38u as=1.0036p ps=4.38u w=3.86u l=0.5u
X266 lvds_lane_2.d2a.0 lvds_lane_2.d2b.0 VDD VDD pfet_03v3 ad=0.52p pd=2.52u as=0.52p ps=2.52u w=2u l=0.4u
X267 lvds_lane_2.tn.0 lvds_lane_0.VREF.0 lvds_lane_2.oa.0 VSS nfet_03v3 ad=1.235p pd=5.27u as=1.235p ps=5.27u w=4.75u l=0.5u
X268 lvds_lane_2.nd.0 VDD VDD VDD pfet_03v3 ad=0.78p pd=3.52u as=1.32p ps=6.88u w=3u l=0.28u
X269 VDD lvds_lane_2.d2b.0 lvds_lane_2.d3.0 VDD pfet_03v3 ad=0.52p pd=2.52u as=0.52p ps=2.52u w=2u l=0.4u
X270 lvds_lane_0.fa.0 lvds_lane_0.gp.0 lvds_lane_0.tp.0 lvds_lane_0.tp.0 pfet_03v3 ad=1.248p pd=5.32u as=1.248p ps=5.32u w=4.8u l=0.4u
X271 VDD lvds_lane_2.d2a.0 lvds_lane_2.d2b.0 VDD pfet_03v3 ad=0.52p pd=2.52u as=0.52p ps=2.52u w=2u l=0.4u
X272 VSS lvds_lane_0.n3a.0 lvds_lane_0.n3a.0 VSS nfet_03v3 ad=0.6734p pd=3.11u as=0.6734p ps=3.11u w=2.59u l=0.28u
X273 lvds_lane_2.fb.0 lvds_lane_0.VB2.0 lvds_lane_2.ob.0 VSS nfet_03v3 ad=1.1752p pd=5.04u as=1.1752p ps=5.04u w=4.52u l=0.5u
X274 lvds_lane_0.ob.0 lvds_lane_0.VREF.0 lvds_lane_0.tn.0 VSS nfet_03v3 ad=2.09p pd=10.38u as=1.235p ps=5.27u w=4.75u l=0.5u
X275 lvds_lane_1.tn.0 lvds_lane_1.gn.0 lvds_lane_1.ob.0 VSS nfet_03v3 ad=1.235p pd=5.27u as=1.235p ps=5.27u w=4.75u l=0.5u
X276 lvds_lane_1.i2.0 VSS VSS VSS nfet_03v3 ad=0.78p pd=3.52u as=1.32p ps=6.88u w=3u l=0.28u
X277 VDD lvds_lane_0.VBP.0 lvds_lane_0.tp.0 VDD pfet_03v3 ad=1.3p pd=5.52u as=1.3p ps=5.52u w=5u l=1u
X278 lvds_lane_1.tp.0 lvds_lane_0.VREF.0 lvds_lane_1.fb.0 lvds_lane_1.tp.0 pfet_03v3 ad=1.248p pd=5.32u as=1.248p ps=5.32u w=4.8u l=0.4u
X279 lvds_lane_2.fa.0 lvds_lane_2.gp.0 lvds_lane_2.tp.0 lvds_lane_2.tp.0 pfet_03v3 ad=1.248p pd=5.32u as=1.248p ps=5.32u w=4.8u l=0.4u
X280 lvds_lane_0.oa.0 lvds_lane_0.VB2.0 lvds_lane_0.fa.0 VSS nfet_03v3 ad=1.1752p pd=5.04u as=1.1752p ps=5.04u w=4.52u l=0.5u
X281 VSS lvds_lane_0.VBN.0 lvds_lane_0.fb.0 VSS nfet_03v3 ad=0.65p pd=3.02u as=0.65p ps=3.02u w=2.5u l=1u
X282 RX1_O VSS VSS VSS nfet_03v3 ad=1.04p pd=4.52u as=1.76p ps=8.88u w=4u l=0.28u
X283 VSS VSS lvds_lane_0.fb.0 VSS nfet_03v3 ad=1.9888p pd=9.92u as=1.1752p ps=5.04u w=4.52u l=0.5u
X284 VSS VSS VSS VSS nfet_03v3 ad=0.39p pd=2.02u as=0 ps=0 w=1.5u l=0.28u
X285 VDD lvds_lane_0.VBP.0 lvds_lane_1.tp.0 VDD pfet_03v3 ad=1.3p pd=5.52u as=1.3p ps=5.52u w=5u l=1u
X286 lvds_bias_0.rb_m1.0 lvds_bias_0.rb_m2.0 VSS ppolyf_u_1k r_width=2u r_length=22.27u
X287 VDD EN lvds_lane_0.VBP.0 VDD pfet_03v3 ad=0.52p pd=2.52u as=0.52p ps=2.52u w=2u l=0.5u
X288 VDD VDD VDD VDD pfet_03v3 ad=0.52p pd=2.52u as=0 ps=0 w=2u l=0.5u
X289 lvds_lane_2.oa.0 lvds_lane_2.rla_m1.0 VSS ppolyf_u_1k r_width=2u r_length=9.11u
X290 VDD lvds_lane_0.VBP.0 lvds_lane_0.tp.0 VDD pfet_03v3 ad=1.3p pd=5.52u as=1.3p ps=5.52u w=5u l=1u
X291 lvds_lane_2.tp.0 lvds_lane_0.VREF.0 lvds_lane_2.fa.0 lvds_lane_2.tp.0 pfet_03v3 ad=1.248p pd=5.32u as=1.248p ps=5.32u w=4.8u l=0.4u
X292 lvds_lane_1.d2b.0 lvds_lane_1.d2a.0 VDD VDD pfet_03v3 ad=0.52p pd=2.52u as=0.52p ps=2.52u w=2u l=0.4u
X293 VDD VDD VDD VDD pfet_03v3 ad=0.52p pd=2.52u as=0 ps=0 w=2u l=0.5u
X294 VDD EN lvds_lane_0.d2a.0 VDD pfet_03v3 ad=0.52p pd=2.52u as=0.52p ps=2.52u w=2u l=0.5u
X295 lvds_lane_0.oa.0 VSS VSS VSS nfet_03v3 ad=1.1752p pd=5.04u as=1.9888p ps=9.92u w=4.52u l=0.5u
X296 lvds_lane_2.tp.0 lvds_lane_0.VREF.0 lvds_lane_2.fb.0 lvds_lane_2.tp.0 pfet_03v3 ad=1.248p pd=5.32u as=1.248p ps=5.32u w=4.8u l=0.4u
X297 VSS VSS VSS VSS nfet_03v3 ad=0.78p pd=3.52u as=0 ps=0 w=3u l=0.28u
X298 VSS lvds_lane_0.VBN.0 lvds_lane_0.VBP.0 VSS nfet_03v3 ad=0.65p pd=3.02u as=0.65p ps=3.02u w=2.5u l=1u
X299 lvds_lane_0.ts.0 lvds_lane_0.VBN.0 VSS VSS nfet_03v3 ad=0.65p pd=3.02u as=0.65p ps=3.02u w=2.5u l=1u
X300 lvds_lane_2.d2a.0 VDD VDD VDD pfet_03v3 ad=0.52p pd=2.52u as=0.88p ps=4.88u w=2u l=0.5u
X301 lvds_lane_0.tp.0 lvds_lane_0.gn.0 lvds_lane_0.fb.0 lvds_lane_0.tp.0 pfet_03v3 ad=1.248p pd=5.32u as=1.248p ps=5.32u w=4.8u l=0.4u
X302 lvds_lane_2.fa.0 lvds_lane_0.VREF.0 lvds_lane_2.tp.0 lvds_lane_2.tp.0 pfet_03v3 ad=1.248p pd=5.32u as=1.248p ps=5.32u w=4.8u l=0.4u
X303 VDD lvds_lane_1.i2.0 RX1_O VDD pfet_03v3 ad=1.3p pd=5.52u as=1.3p ps=5.52u w=5u l=0.28u
X304 lvds_lane_1.fb.0 lvds_lane_0.VREF.0 lvds_lane_1.tp.0 lvds_lane_1.tp.0 pfet_03v3 ad=1.248p pd=5.32u as=1.248p ps=5.32u w=4.8u l=0.4u
X305 lvds_lane_0.oa.0 lvds_lane_0.gp.0 lvds_lane_0.tn.0 VSS nfet_03v3 ad=1.235p pd=5.27u as=1.235p ps=5.27u w=4.75u l=0.5u
X306 lvds_lane_1.tn.0 lvds_lane_0.VREF.0 lvds_lane_1.oa.0 VSS nfet_03v3 ad=1.235p pd=5.27u as=1.235p ps=5.27u w=4.75u l=0.5u
X307 VDD lvds_lane_0.d2a.0 lvds_lane_0.n3a.0 VDD pfet_03v3 ad=0.52p pd=2.52u as=0.52p ps=2.52u w=2u l=0.4u
X308 lvds_lane_1.tp.0 lvds_lane_0.VREF.0 lvds_lane_1.fb.0 lvds_lane_1.tp.0 pfet_03v3 ad=1.248p pd=5.32u as=1.248p ps=5.32u w=4.8u l=0.4u
X309 VDD VDD lvds_lane_2.nd.0 VDD pfet_03v3 ad=1.32p pd=6.88u as=0.78p ps=3.52u w=3u l=0.28u
X310 lvds_lane_2.d2b.0 lvds_lane_2.d2a.0 VDD VDD pfet_03v3 ad=0.52p pd=2.52u as=0.52p ps=2.52u w=2u l=0.4u
X311 lvds_lane_0.fa.0 lvds_lane_0.gp.0 lvds_lane_0.tp.0 lvds_lane_0.tp.0 pfet_03v3 ad=1.248p pd=5.32u as=1.248p ps=5.32u w=4.8u l=0.4u
X312 lvds_lane_2.tp.0 lvds_lane_2.gn.0 lvds_lane_2.fb.0 lvds_lane_2.tp.0 pfet_03v3 ad=1.248p pd=5.32u as=1.248p ps=5.32u w=4.8u l=0.4u
X313 lvds_lane_0.ob.0 lvds_lane_0.gn.0 lvds_lane_0.tn.0 VSS nfet_03v3 ad=1.235p pd=5.27u as=1.235p ps=5.27u w=4.75u l=0.5u
X314 lvds_lane_0.tp.0 lvds_lane_0.VBP.0 VDD VDD pfet_03v3 ad=1.3p pd=5.52u as=1.3p ps=5.52u w=5u l=1u
X315 VDD lvds_lane_2.d2a.0 lvds_lane_2.n3a.0 VDD pfet_03v3 ad=0.52p pd=2.52u as=0.52p ps=2.52u w=2u l=0.4u
X316 VDD VDD lvds_lane_1.n3a.0 VDD pfet_03v3 ad=0.88p pd=4.88u as=0.52p ps=2.52u w=2u l=0.4u
X317 VDD lvds_lane_2.i1.0 lvds_lane_2.i2.0 VDD pfet_03v3 ad=0.975p pd=4.27u as=0.975p ps=4.27u w=3.75u l=0.28u
X318 lvds_lane_1.gp.0 RX1_P VDD ppolyf_u r_width=5u r_length=1.8u
X319 lvds_lane_0.ob.0 lvds_lane_0.VREF.0 lvds_lane_0.tn.0 VSS nfet_03v3 ad=1.235p pd=5.27u as=1.235p ps=5.27u w=4.75u l=0.5u
X320 VSS lvds_lane_0.VBN.0 lvds_lane_0.fa.0 VSS nfet_03v3 ad=0.65p pd=3.02u as=0.65p ps=3.02u w=2.5u l=1u
X321 lvds_lane_2.ob.0 lvds_lane_2.gn.0 lvds_lane_2.tn.0 VSS nfet_03v3 ad=1.235p pd=5.27u as=1.235p ps=5.27u w=4.75u l=0.5u
X322 lvds_lane_1.tp.0 lvds_lane_0.VBP.0 VDD VDD pfet_03v3 ad=1.3p pd=5.52u as=1.3p ps=5.52u w=5u l=1u
X323 lvds_lane_0.fa.0 lvds_lane_0.VREF.0 lvds_lane_0.tp.0 lvds_lane_0.tp.0 pfet_03v3 ad=1.248p pd=5.32u as=1.248p ps=5.32u w=4.8u l=0.4u
X324 lvds_lane_1.fa.0 lvds_lane_0.VREF.0 lvds_lane_1.tp.0 lvds_lane_1.tp.0 pfet_03v3 ad=1.248p pd=5.32u as=1.248p ps=5.32u w=4.8u l=0.4u
X325 lvds_lane_1.d2a.0 lvds_lane_1.d2a.0 VDD VDD pfet_03v3 ad=0.52p pd=2.52u as=0.52p ps=2.52u w=2u l=0.4u
X326 lvds_lane_1.tp.0 lvds_lane_1.gp.0 lvds_lane_1.fa.0 lvds_lane_1.tp.0 pfet_03v3 ad=1.248p pd=5.32u as=1.248p ps=5.32u w=4.8u l=0.4u
X327 VSS lvds_lane_0.VBN.0 lvds_lane_0.tn.0 VSS nfet_03v3 ad=0.65p pd=3.02u as=0.65p ps=3.02u w=2.5u l=1u
X328 lvds_lane_2.ts.0 VSS VSS VSS nfet_03v3 ad=0.65p pd=3.02u as=1.1p ps=5.88u w=2.5u l=1u
X329 VSS VSS lvds_lane_1.fa.0 VSS nfet_03v3 ad=1.1p pd=5.88u as=0.65p ps=3.02u w=2.5u l=1u
X330 VDD lvds_lane_1.d2b.0 lvds_lane_1.d2b.0 VDD pfet_03v3 ad=0.52p pd=2.52u as=0.52p ps=2.52u w=2u l=0.4u
X331 lvds_lane_2.ob.0 lvds_lane_2.gn.0 lvds_lane_2.tn.0 VSS nfet_03v3 ad=1.235p pd=5.27u as=1.235p ps=5.27u w=4.75u l=0.5u
X332 VSS lvds_lane_0.i2.0 RX0_O VSS nfet_03v3 ad=1.04p pd=4.52u as=1.04p ps=4.52u w=4u l=0.28u
X333 VSS lvds_lane_0.i1.0 lvds_lane_0.i2.0 VSS nfet_03v3 ad=0.78p pd=3.52u as=0.78p ps=3.52u w=3u l=0.28u
X334 VDD lvds_lane_1.d2b.0 lvds_lane_1.d3.0 VDD pfet_03v3 ad=0.52p pd=2.52u as=0.52p ps=2.52u w=2u l=0.4u
X335 lvds_lane_0.tn.0 lvds_lane_0.gn.0 lvds_lane_0.ob.0 VSS nfet_03v3 ad=1.235p pd=5.27u as=1.235p ps=5.27u w=4.75u l=0.5u
X336 lvds_bias_0.nrb.0 lvds_bias_0.enb.0 VDD VDD pfet_03v3 ad=1.3p pd=5.52u as=1.3p ps=5.52u w=5u l=0.5u
X337 lvds_lane_2.oa.0 lvds_lane_2.gp.0 lvds_lane_2.tn.0 VSS nfet_03v3 ad=1.235p pd=5.27u as=1.235p ps=5.27u w=4.75u l=0.5u
X338 lvds_lane_1.fa.0 lvds_lane_0.VREF.0 lvds_lane_1.tp.0 lvds_lane_1.tp.0 pfet_03v3 ad=1.248p pd=5.32u as=1.248p ps=5.32u w=4.8u l=0.4u
X339 lvds_lane_1.oa.0 lvds_lane_0.VB2.0 lvds_lane_1.fa.0 VSS nfet_03v3 ad=1.1752p pd=5.04u as=1.1752p ps=5.04u w=4.52u l=0.5u
X340 lvds_lane_0.fb.0 lvds_lane_0.gn.0 lvds_lane_0.tp.0 lvds_lane_0.tp.0 pfet_03v3 ad=1.248p pd=5.32u as=1.248p ps=5.32u w=4.8u l=0.4u
X341 lvds_lane_0.tn.0 lvds_lane_0.gp.0 lvds_lane_0.oa.0 VSS nfet_03v3 ad=1.235p pd=5.27u as=1.235p ps=5.27u w=4.75u l=0.5u
X342 lvds_lane_2.tp.0 lvds_lane_2.gp.0 lvds_lane_2.fa.0 lvds_lane_2.tp.0 pfet_03v3 ad=1.248p pd=5.32u as=1.248p ps=5.32u w=4.8u l=0.4u
X343 lvds_bias_0.nrb.0 lvds_bias_0.enb.0 VDD VDD pfet_03v3 ad=1.3p pd=5.52u as=1.3p ps=5.52u w=5u l=0.5u
X344 lvds_lane_1.fa.0 lvds_lane_0.VREF.0 lvds_lane_1.tp.0 lvds_lane_1.tp.0 pfet_03v3 ad=1.248p pd=5.32u as=1.248p ps=5.32u w=4.8u l=0.4u
X345 lvds_lane_2.fa.0 lvds_lane_2.gp.0 lvds_lane_2.tp.0 lvds_lane_2.tp.0 pfet_03v3 ad=1.248p pd=5.32u as=1.248p ps=5.32u w=4.8u l=0.4u
X346 lvds_lane_0.ts.0 lvds_lane_0.VBN.0 VSS VSS nfet_03v3 ad=0.65p pd=3.02u as=0.65p ps=3.02u w=2.5u l=1u
X347 VDD lvds_lane_0.VBP.0 lvds_lane_0.tp.0 VDD pfet_03v3 ad=1.3p pd=5.52u as=1.3p ps=5.52u w=5u l=1u
D3 lvds_lane_0.gn.0 VDD diode_pd2nw_03v3 pj=26u area=40p
X348 VSS lvds_lane_2.i1.0 lvds_lane_2.i2.0 VSS nfet_03v3 ad=0.78p pd=3.52u as=0.78p ps=3.52u w=3u l=0.28u
X349 VSS lvds_lane_2.i2.0 RX2_O VSS nfet_03v3 ad=1.04p pd=4.52u as=1.04p ps=4.52u w=4u l=0.28u
X350 lvds_lane_0.fb.0 lvds_lane_0.VREF.0 lvds_lane_0.tp.0 lvds_lane_0.tp.0 pfet_03v3 ad=2.112p pd=10.48u as=1.248p ps=5.32u w=4.8u l=0.4u
X351 lvds_lane_2.fa.0 lvds_lane_2.gp.0 lvds_lane_2.tp.0 lvds_lane_2.tp.0 pfet_03v3 ad=1.248p pd=5.32u as=1.248p ps=5.32u w=4.8u l=0.4u
X352 lvds_lane_2.tp.0 lvds_lane_2.gn.0 lvds_lane_2.fb.0 lvds_lane_2.tp.0 pfet_03v3 ad=1.248p pd=5.32u as=1.248p ps=5.32u w=4.8u l=0.4u
X353 lvds_bias_0.nrb.0 lvds_bias_0.enb.0 VDD VDD pfet_03v3 ad=1.3p pd=5.52u as=1.3p ps=5.52u w=5u l=0.5u
X354 RX0_O lvds_lane_0.i2.0 VDD VDD pfet_03v3 ad=1.3p pd=5.52u as=1.3p ps=5.52u w=5u l=0.28u
X355 lvds_lane_1.d3.0 lvds_lane_1.d2b.0 VDD VDD pfet_03v3 ad=0.52p pd=2.52u as=0.52p ps=2.52u w=2u l=0.4u
X356 lvds_lane_1.tn.0 lvds_lane_0.VREF.0 lvds_lane_1.ob.0 VSS nfet_03v3 ad=1.235p pd=5.27u as=1.235p ps=5.27u w=4.75u l=0.5u
X357 lvds_lane_1.d2b.0 lvds_lane_1.d2a.0 VDD VDD pfet_03v3 ad=0.52p pd=2.52u as=0.52p ps=2.52u w=2u l=0.4u
X358 lvds_lane_0.fb.0 lvds_lane_0.VBN.0 VSS VSS nfet_03v3 ad=0.65p pd=3.02u as=0.65p ps=3.02u w=2.5u l=1u
X359 lvds_lane_1.ob.0 lvds_lane_1.gn.0 lvds_lane_1.tn.0 VSS nfet_03v3 ad=1.235p pd=5.27u as=1.235p ps=5.27u w=4.75u l=0.5u
X360 lvds_lane_2.tn.0 lvds_lane_0.VREF.0 lvds_lane_2.ob.0 VSS nfet_03v3 ad=1.235p pd=5.27u as=1.235p ps=5.27u w=4.75u l=0.5u
X361 lvds_lane_0.fb.0 lvds_lane_0.VREF.0 lvds_lane_0.tp.0 lvds_lane_0.tp.0 pfet_03v3 ad=1.248p pd=5.32u as=1.248p ps=5.32u w=4.8u l=0.4u
X362 lvds_lane_1.fa.0 lvds_lane_0.VBN.0 VSS VSS nfet_03v3 ad=0.65p pd=3.02u as=0.65p ps=3.02u w=2.5u l=1u
X363 lvds_lane_0.tn.0 lvds_lane_0.VBN.0 VSS VSS nfet_03v3 ad=0.65p pd=3.02u as=0.65p ps=3.02u w=2.5u l=1u
X364 VDD lvds_lane_1.nd.0 lvds_lane_1.i1.0 VDD pfet_03v3 ad=0.962p pd=4.22u as=0.962p ps=4.22u w=3.7u l=0.28u
X365 VSS lvds_lane_0.VBN.0 lvds_lane_2.ts.0 VSS nfet_03v3 ad=0.65p pd=3.02u as=0.65p ps=3.02u w=2.5u l=1u
X366 lvds_lane_0.tp.0 lvds_lane_0.VBP.0 VDD VDD pfet_03v3 ad=1.3p pd=5.52u as=1.3p ps=5.52u w=5u l=1u
X367 lvds_lane_1.fb.0 lvds_lane_0.VB2.0 lvds_lane_1.ob.0 VSS nfet_03v3 ad=1.1752p pd=5.04u as=1.1752p ps=5.04u w=4.52u l=0.5u
X368 lvds_lane_0.sb.0 lvds_lane_0.ob.0 lvds_lane_0.d2b.0 VSS nfet_03v3 ad=1.0036p pd=4.38u as=1.0036p ps=4.38u w=3.86u l=0.5u
X369 lvds_lane_2.fa.0 lvds_lane_2.gp.0 lvds_lane_2.tp.0 lvds_lane_2.tp.0 pfet_03v3 ad=1.248p pd=5.32u as=1.248p ps=5.32u w=4.8u l=0.4u
X370 VSS lvds_lane_0.VBN.0 lvds_lane_0.fb.0 VSS nfet_03v3 ad=0.65p pd=3.02u as=0.65p ps=3.02u w=2.5u l=1u
X371 lvds_lane_1.tn.0 lvds_lane_0.VBN.0 VSS VSS nfet_03v3 ad=0.65p pd=3.02u as=0.65p ps=3.02u w=2.5u l=1u
X372 VDD lvds_lane_0.d2a.0 lvds_lane_0.d2a.0 VDD pfet_03v3 ad=0.52p pd=2.52u as=0.52p ps=2.52u w=2u l=0.4u
X373 lvds_lane_1.tp.0 lvds_lane_0.VBP.0 VDD VDD pfet_03v3 ad=1.3p pd=5.52u as=1.3p ps=5.52u w=5u l=1u
X374 lvds_lane_0.fb.0 lvds_lane_0.gn.0 lvds_lane_0.tp.0 lvds_lane_0.tp.0 pfet_03v3 ad=1.248p pd=5.32u as=1.248p ps=5.32u w=4.8u l=0.4u
X375 RX2_O lvds_lane_2.i2.0 VDD VDD pfet_03v3 ad=1.3p pd=5.52u as=1.3p ps=5.52u w=5u l=0.28u
X376 VDD lvds_lane_0.VBP.0 lvds_lane_0.VBP.0 VDD pfet_03v3 ad=1.3p pd=5.52u as=1.3p ps=5.52u w=5u l=1u
X377 VSS lvds_lane_0.VBN.0 lvds_lane_0.ts.0 VSS nfet_03v3 ad=0.65p pd=3.02u as=0.65p ps=3.02u w=2.5u l=1u
X378 lvds_lane_0.i2.0 VSS VSS VSS nfet_03v3 ad=0.78p pd=3.52u as=1.32p ps=6.88u w=3u l=0.28u
X379 VDD lvds_lane_0.d2a.0 lvds_lane_0.n3a.0 VDD pfet_03v3 ad=0.52p pd=2.52u as=0.52p ps=2.52u w=2u l=0.4u
X380 lvds_lane_1.sa.0 lvds_lane_1.oa.0 lvds_lane_1.d2a.0 VSS nfet_03v3 ad=1.0036p pd=4.38u as=1.0036p ps=4.38u w=3.86u l=0.5u
D4 VSS lvds_lane_0.gn.0 diode_nd2ps_03v3 pj=26u area=40p
X381 RX0_O VSS VSS VSS nfet_03v3 ad=1.04p pd=4.52u as=1.76p ps=8.88u w=4u l=0.28u
X382 VSS VSS VSS VSS nfet_03v3 ad=0.39p pd=2.02u as=0 ps=0 w=1.5u l=0.28u
X383 lvds_lane_0.n3a.0 lvds_lane_0.d2a.0 VDD VDD pfet_03v3 ad=0.52p pd=2.52u as=0.52p ps=2.52u w=2u l=0.4u
X384 lvds_lane_1.oa.0 lvds_lane_0.VREF.0 lvds_lane_1.tn.0 VSS nfet_03v3 ad=1.235p pd=5.27u as=1.235p ps=5.27u w=4.75u l=0.5u
X385 lvds_lane_0.i2.0 VDD VDD VDD pfet_03v3 ad=0.975p pd=4.27u as=1.65p ps=8.38u w=3.75u l=0.28u
X386 VDD lvds_lane_2.d2b.0 lvds_lane_2.d2a.0 VDD pfet_03v3 ad=0.52p pd=2.52u as=0.52p ps=2.52u w=2u l=0.4u
X387 lvds_lane_2.fb.0 lvds_lane_0.VBN.0 VSS VSS nfet_03v3 ad=0.65p pd=3.02u as=0.65p ps=3.02u w=2.5u l=1u
X388 VSS VSS VSS VSS nfet_03v3 ad=0.78p pd=3.52u as=0 ps=0 w=3u l=0.28u
X389 VSS VSS VSS ppolyf_u_1k r_width=2u r_length=9.11u
X390 lvds_lane_0.fb.0 lvds_lane_0.VREF.0 lvds_lane_0.tp.0 lvds_lane_0.tp.0 pfet_03v3 ad=1.248p pd=5.32u as=1.248p ps=5.32u w=4.8u l=0.4u
X391 lvds_lane_1.fb.0 lvds_lane_0.VREF.0 lvds_lane_1.tp.0 lvds_lane_1.tp.0 pfet_03v3 ad=1.248p pd=5.32u as=1.248p ps=5.32u w=4.8u l=0.4u
X392 lvds_lane_2.fa.0 lvds_lane_0.VBN.0 VSS VSS nfet_03v3 ad=0.65p pd=3.02u as=0.65p ps=3.02u w=2.5u l=1u
X393 lvds_lane_2.i1.0 VDD VDD VDD pfet_03v3 ad=0.962p pd=4.22u as=1.628p ps=8.28u w=3.7u l=0.28u
X394 VDD lvds_lane_0.VBP.0 lvds_lane_0.tp.0 VDD pfet_03v3 ad=1.3p pd=5.52u as=1.3p ps=5.52u w=5u l=1u
X395 lvds_lane_0.fa.0 lvds_lane_0.VREF.0 lvds_lane_0.tp.0 lvds_lane_0.tp.0 pfet_03v3 ad=1.248p pd=5.32u as=1.248p ps=5.32u w=4.8u l=0.4u
X396 VSS VSS lvds_lane_1.ts.0 VSS nfet_03v3 ad=1.1p pd=5.88u as=0.65p ps=3.02u w=2.5u l=1u
X397 lvds_lane_2.i2.0 VSS VSS VSS nfet_03v3 ad=0.78p pd=3.52u as=1.32p ps=6.88u w=3u l=0.28u
X398 RX2_O VSS VSS VSS nfet_03v3 ad=1.04p pd=4.52u as=1.76p ps=8.88u w=4u l=0.28u
X399 lvds_lane_0.VBP.0 lvds_lane_0.VBN.0 VSS VSS nfet_03v3 ad=0.65p pd=3.02u as=0.65p ps=3.02u w=2.5u l=1u
X400 lvds_lane_2.tp.0 lvds_lane_0.VBP.0 VDD VDD pfet_03v3 ad=1.3p pd=5.52u as=1.3p ps=5.52u w=5u l=1u
X401 lvds_lane_1.tp.0 lvds_lane_1.gp.0 lvds_lane_1.fa.0 lvds_lane_1.tp.0 pfet_03v3 ad=1.248p pd=5.32u as=1.248p ps=5.32u w=4.8u l=0.4u
X402 lvds_lane_2.tp.0 lvds_lane_2.gp.0 lvds_lane_2.fa.0 lvds_lane_2.tp.0 pfet_03v3 ad=1.248p pd=5.32u as=1.248p ps=5.32u w=4.8u l=0.4u
X403 VDD lvds_lane_0.i2.0 RX0_O VDD pfet_03v3 ad=1.3p pd=5.52u as=1.3p ps=5.52u w=5u l=0.28u
X404 lvds_lane_0.n3a.0 lvds_lane_0.d2a.0 VDD VDD pfet_03v3 ad=0.52p pd=2.52u as=0.52p ps=2.52u w=2u l=0.4u
X405 VSS VSS lvds_lane_0.fa.0 VSS nfet_03v3 ad=1.9888p pd=9.92u as=1.1752p ps=5.04u w=4.52u l=0.5u
X406 VDD VDD lvds_lane_1.d2b.0 VDD pfet_03v3 ad=0.88p pd=4.88u as=0.52p ps=2.52u w=2u l=0.4u
X407 VSS lvds_lane_0.VBN.0 lvds_lane_1.fa.0 VSS nfet_03v3 ad=0.65p pd=3.02u as=0.65p ps=3.02u w=2.5u l=1u
X408 VSS VSS VSS VSS nfet_03v3 ad=0.78p pd=3.52u as=0 ps=0 w=3u l=0.28u
X409 lvds_bias_0.rdt_m2.0 lvds_bias_0.rdt_m1.0 VSS ppolyf_u_1k r_width=2u r_length=21.01u
X410 lvds_lane_0.tp.0 lvds_lane_0.VREF.0 lvds_lane_0.fb.0 lvds_lane_0.tp.0 pfet_03v3 ad=1.248p pd=5.32u as=1.248p ps=5.32u w=4.8u l=0.4u
X411 lvds_lane_2.fa.0 lvds_lane_0.VB2.0 lvds_lane_2.oa.0 VSS nfet_03v3 ad=1.1752p pd=5.04u as=1.1752p ps=5.04u w=4.52u l=0.5u
X412 VDD lvds_lane_2.d2b.0 lvds_lane_2.d2a.0 VDD pfet_03v3 ad=0.52p pd=2.52u as=0.52p ps=2.52u w=2u l=0.4u
X413 VSS VSS VSS ppolyf_u_1k r_width=2u r_length=8.86u
X414 lvds_lane_0.fa.0 lvds_lane_0.gp.0 lvds_lane_0.tp.0 lvds_lane_0.tp.0 pfet_03v3 ad=1.248p pd=5.32u as=1.248p ps=5.32u w=4.8u l=0.4u
X415 lvds_lane_0.oa.0 lvds_lane_0.VB2.0 lvds_lane_0.fa.0 VSS nfet_03v3 ad=1.1752p pd=5.04u as=1.1752p ps=5.04u w=4.52u l=0.5u
X416 VSS lvds_lane_0.VBN.0 lvds_lane_2.fb.0 VSS nfet_03v3 ad=0.65p pd=3.02u as=0.65p ps=3.02u w=2.5u l=1u
X417 VSS VSS lvds_lane_1.tn.0 VSS nfet_03v3 ad=1.1p pd=5.88u as=0.65p ps=3.02u w=2.5u l=1u
X418 VDD lvds_lane_2.rla_m1.0 VSS ppolyf_u_1k r_width=2u r_length=9.11u
X419 VDD lvds_lane_0.VBP.0 lvds_lane_1.tp.0 VDD pfet_03v3 ad=1.3p pd=5.52u as=1.3p ps=5.52u w=5u l=1u
X420 lvds_lane_2.tp.0 lvds_lane_0.VREF.0 lvds_lane_2.fa.0 lvds_lane_2.tp.0 pfet_03v3 ad=1.248p pd=5.32u as=1.248p ps=5.32u w=4.8u l=0.4u
X421 VSS lvds_lane_0.VBN.0 lvds_lane_0.fa.0 VSS nfet_03v3 ad=0.65p pd=3.02u as=0.65p ps=3.02u w=2.5u l=1u
X422 VDD lvds_lane_2.i2.0 RX2_O VDD pfet_03v3 ad=1.3p pd=5.52u as=1.3p ps=5.52u w=5u l=0.28u
X423 lvds_lane_1.n3a.0 VSS VSS VSS nfet_03v3 ad=0.6734p pd=3.11u as=1.1396p ps=6.06u w=2.59u l=0.28u
X424 lvds_lane_1.tp.0 lvds_lane_1.gn.0 lvds_lane_1.fb.0 lvds_lane_1.tp.0 pfet_03v3 ad=1.248p pd=5.32u as=1.248p ps=5.32u w=4.8u l=0.4u
X425 lvds_lane_0.d2b.0 VDD VDD VDD pfet_03v3 ad=0.52p pd=2.52u as=0.88p ps=4.88u w=2u l=0.5u
X426 lvds_lane_2.fa.0 lvds_lane_0.VB2.0 lvds_lane_2.oa.0 VSS nfet_03v3 ad=1.1752p pd=5.04u as=1.1752p ps=5.04u w=4.52u l=0.5u
X427 lvds_lane_0.d3.0 lvds_lane_0.d2b.0 VDD VDD pfet_03v3 ad=0.52p pd=2.52u as=0.52p ps=2.52u w=2u l=0.4u
X428 VDD lvds_lane_2.d2a.0 lvds_lane_2.d2b.0 VDD pfet_03v3 ad=0.52p pd=2.52u as=0.52p ps=2.52u w=2u l=0.4u
X429 VDD lvds_lane_2.rlb_m1.0 VSS ppolyf_u_1k r_width=2u r_length=9.11u
X430 lvds_lane_0.tp.0 lvds_lane_0.gp.0 lvds_lane_0.fa.0 lvds_lane_0.tp.0 pfet_03v3 ad=1.248p pd=5.32u as=1.248p ps=5.32u w=4.8u l=0.4u
X431 lvds_lane_2.fa.0 lvds_lane_2.gp.0 lvds_lane_2.tp.0 lvds_lane_2.tp.0 pfet_03v3 ad=1.248p pd=5.32u as=1.248p ps=5.32u w=4.8u l=0.4u
X432 lvds_lane_2.fa.0 VSS VSS VSS nfet_03v3 ad=0.65p pd=3.02u as=1.1p ps=5.88u w=2.5u l=1u
X433 lvds_bias_0.rb_m3.0 lvds_bias_0.rb_m2.0 VSS ppolyf_u_1k r_width=2u r_length=22.27u
X434 lvds_lane_2.fb.0 lvds_lane_0.VBN.0 VSS VSS nfet_03v3 ad=0.65p pd=3.02u as=0.65p ps=3.02u w=2.5u l=1u
X435 lvds_lane_1.tn.0 lvds_lane_0.VREF.0 lvds_lane_1.ob.0 VSS nfet_03v3 ad=1.235p pd=5.27u as=2.09p ps=10.38u w=4.75u l=0.5u
X436 lvds_lane_1.tn.0 lvds_lane_0.VREF.0 lvds_lane_1.oa.0 VSS nfet_03v3 ad=1.235p pd=5.27u as=1.235p ps=5.27u w=4.75u l=0.5u
X437 lvds_lane_2.ts.0 lvds_lane_2.sb.0 VSS ppolyf_u_1k r_width=2u r_length=8.86u
X438 lvds_lane_2.tp.0 lvds_lane_0.VBP.0 VDD VDD pfet_03v3 ad=1.3p pd=5.52u as=1.3p ps=5.52u w=5u l=1u
X439 lvds_lane_1.fb.0 lvds_lane_1.gn.0 lvds_lane_1.tp.0 lvds_lane_1.tp.0 pfet_03v3 ad=1.248p pd=5.32u as=1.248p ps=5.32u w=4.8u l=0.4u
X440 lvds_lane_0.oa.0 lvds_lane_0.gp.0 lvds_lane_0.tn.0 VSS nfet_03v3 ad=1.235p pd=5.27u as=1.235p ps=5.27u w=4.75u l=0.5u
X441 lvds_lane_1.i2.0 lvds_lane_1.i1.0 VDD VDD pfet_03v3 ad=0.975p pd=4.27u as=0.975p ps=4.27u w=3.75u l=0.28u
X442 VDD VDD lvds_lane_0.tp.0 VDD pfet_03v3 ad=2.2p pd=10.88u as=1.3p ps=5.52u w=5u l=1u
X443 lvds_lane_1.tp.0 lvds_lane_0.VREF.0 lvds_lane_1.fb.0 lvds_lane_1.tp.0 pfet_03v3 ad=1.248p pd=5.32u as=1.248p ps=5.32u w=4.8u l=0.4u
D5 lvds_lane_2.gp.0 VDD diode_pd2nw_03v3 pj=26u area=40p
X444 lvds_lane_2.tp.0 lvds_lane_0.VREF.0 lvds_lane_2.fb.0 lvds_lane_2.tp.0 pfet_03v3 ad=1.248p pd=5.32u as=1.248p ps=5.32u w=4.8u l=0.4u
X445 VDD lvds_lane_0.d3.0 lvds_lane_0.nd.0 VDD pfet_03v3 ad=0.78p pd=3.52u as=0.78p ps=3.52u w=3u l=0.28u
X446 VDD lvds_lane_2.d2b.0 lvds_lane_2.d3.0 VDD pfet_03v3 ad=0.52p pd=2.52u as=0.52p ps=2.52u w=2u l=0.4u
X447 lvds_lane_2.tn.0 lvds_lane_2.gn.0 lvds_lane_2.ob.0 VSS nfet_03v3 ad=1.235p pd=5.27u as=1.235p ps=5.27u w=4.75u l=0.5u
X448 VDD lvds_lane_2.d2b.0 lvds_lane_2.d2b.0 VDD pfet_03v3 ad=0.52p pd=2.52u as=0.52p ps=2.52u w=2u l=0.4u
X449 VSS VSS lvds_lane_1.d3.0 VSS nfet_03v3 ad=1.1396p pd=6.06u as=0.6734p ps=3.11u w=2.59u l=0.28u
X450 lvds_lane_0.fb.0 lvds_lane_0.gn.0 lvds_lane_0.tp.0 lvds_lane_0.tp.0 pfet_03v3 ad=1.248p pd=5.32u as=1.248p ps=5.32u w=4.8u l=0.4u
X451 lvds_lane_2.fa.0 lvds_lane_0.VBN.0 VSS VSS nfet_03v3 ad=0.65p pd=3.02u as=0.65p ps=3.02u w=2.5u l=1u
X452 lvds_lane_0.ob.0 lvds_lane_0.VREF.0 lvds_lane_0.tn.0 VSS nfet_03v3 ad=1.235p pd=5.27u as=1.235p ps=5.27u w=4.75u l=0.5u
X453 lvds_lane_0.VBP.0 lvds_lane_0.VBP.0 VDD VDD pfet_03v3 ad=1.3p pd=5.52u as=1.3p ps=5.52u w=5u l=1u
X454 lvds_lane_0.fb.0 lvds_lane_0.VBN.0 VSS VSS nfet_03v3 ad=0.65p pd=3.02u as=0.65p ps=3.02u w=2.5u l=1u
X455 VSS lvds_lane_0.VBN.0 lvds_lane_1.tn.0 VSS nfet_03v3 ad=0.65p pd=3.02u as=0.65p ps=3.02u w=2.5u l=1u
X456 lvds_lane_2.oa.0 lvds_lane_2.gp.0 lvds_lane_2.tn.0 VSS nfet_03v3 ad=1.235p pd=5.27u as=1.235p ps=5.27u w=4.75u l=0.5u
X457 lvds_lane_2.tp.0 lvds_lane_0.VBP.0 VDD VDD pfet_03v3 ad=1.3p pd=5.52u as=1.3p ps=5.52u w=5u l=1u
X458 lvds_lane_0.tp.0 lvds_lane_0.gp.0 lvds_lane_0.fa.0 lvds_lane_0.tp.0 pfet_03v3 ad=1.248p pd=5.32u as=1.248p ps=5.32u w=4.8u l=0.4u
X459 lvds_lane_0.tp.0 lvds_lane_0.gp.0 lvds_lane_0.fa.0 lvds_lane_0.tp.0 pfet_03v3 ad=1.248p pd=5.32u as=1.248p ps=5.32u w=4.8u l=0.4u
X460 lvds_lane_1.tp.0 lvds_lane_0.VREF.0 lvds_lane_1.fa.0 lvds_lane_1.tp.0 pfet_03v3 ad=1.248p pd=5.32u as=1.248p ps=5.32u w=4.8u l=0.4u
X461 lvds_lane_2.tn.0 lvds_lane_0.VREF.0 lvds_lane_2.oa.0 VSS nfet_03v3 ad=1.235p pd=5.27u as=1.235p ps=5.27u w=4.75u l=0.5u
X462 lvds_lane_0.n3a.0 VDD VDD VDD pfet_03v3 ad=0.52p pd=2.52u as=0.88p ps=4.88u w=2u l=0.4u
X463 lvds_lane_0.fa.0 lvds_lane_0.gp.0 lvds_lane_0.tp.0 lvds_lane_0.tp.0 pfet_03v3 ad=1.248p pd=5.32u as=1.248p ps=5.32u w=4.8u l=0.4u
X464 lvds_lane_1.tp.0 lvds_lane_0.VREF.0 lvds_lane_1.fa.0 lvds_lane_1.tp.0 pfet_03v3 ad=1.248p pd=5.32u as=1.248p ps=5.32u w=4.8u l=0.4u
X465 VSS lvds_lane_0.VBN.0 lvds_lane_2.fa.0 VSS nfet_03v3 ad=0.65p pd=3.02u as=0.65p ps=3.02u w=2.5u l=1u
X466 VSS lvds_lane_0.VBN.0 lvds_lane_0.VBN.0 VSS nfet_03v3 ad=0.65p pd=3.02u as=0.65p ps=3.02u w=2.5u l=1u
X467 VSS lvds_lane_0.VBN.0 lvds_lane_2.fb.0 VSS nfet_03v3 ad=0.65p pd=3.02u as=0.65p ps=3.02u w=2.5u l=1u
X468 VSS lvds_lane_0.VBN.0 lvds_lane_2.tn.0 VSS nfet_03v3 ad=0.65p pd=3.02u as=0.65p ps=3.02u w=2.5u l=1u
X469 lvds_lane_1.nd.0 VDD VDD VDD pfet_03v3 ad=0.78p pd=3.52u as=1.32p ps=6.88u w=3u l=0.28u
X470 lvds_lane_2.d3.0 lvds_lane_2.n3a.0 VSS VSS nfet_03v3 ad=0.6734p pd=3.11u as=0.6734p ps=3.11u w=2.59u l=0.28u
X471 VDD lvds_lane_1.d2b.0 lvds_lane_1.d3.0 VDD pfet_03v3 ad=0.52p pd=2.52u as=0.52p ps=2.52u w=2u l=0.4u
X472 lvds_lane_0.tn.0 lvds_lane_0.gn.0 lvds_lane_0.ob.0 VSS nfet_03v3 ad=1.235p pd=5.27u as=1.235p ps=5.27u w=4.75u l=0.5u
X473 lvds_lane_1.ts.0 lvds_lane_0.VBN.0 VSS VSS nfet_03v3 ad=0.65p pd=3.02u as=0.65p ps=3.02u w=2.5u l=1u
X474 VSS VSS VSS VSS nfet_03v3 ad=0.39p pd=2.02u as=0 ps=0 w=1.5u l=0.28u
X475 VDD lvds_lane_1.d2a.0 lvds_lane_1.d2b.0 VDD pfet_03v3 ad=0.52p pd=2.52u as=0.52p ps=2.52u w=2u l=0.4u
X476 VDD lvds_lane_0.VBP.0 lvds_lane_2.tp.0 VDD pfet_03v3 ad=1.3p pd=5.52u as=1.3p ps=5.52u w=5u l=1u
X477 lvds_lane_0.tp.0 lvds_lane_0.VREF.0 lvds_lane_0.fb.0 lvds_lane_0.tp.0 pfet_03v3 ad=1.248p pd=5.32u as=1.248p ps=5.32u w=4.8u l=0.4u
X478 lvds_lane_1.fa.0 lvds_lane_1.gp.0 lvds_lane_1.tp.0 lvds_lane_1.tp.0 pfet_03v3 ad=1.248p pd=5.32u as=1.248p ps=5.32u w=4.8u l=0.4u
X479 lvds_lane_1.d2b.0 lvds_lane_1.ob.0 lvds_lane_1.sb.0 VSS nfet_03v3 ad=1.0036p pd=4.38u as=1.0036p ps=4.38u w=3.86u l=0.5u
X480 lvds_lane_1.tp.0 lvds_lane_0.VREF.0 lvds_lane_1.fa.0 lvds_lane_1.tp.0 pfet_03v3 ad=1.248p pd=5.32u as=1.248p ps=5.32u w=4.8u l=0.4u
X481 lvds_lane_1.tn.0 lvds_lane_0.VREF.0 lvds_lane_1.oa.0 VSS nfet_03v3 ad=1.235p pd=5.27u as=1.235p ps=5.27u w=4.75u l=0.5u
X482 VDD lvds_lane_0.VBP.0 lvds_lane_0.tp.0 VDD pfet_03v3 ad=1.3p pd=5.52u as=1.3p ps=5.52u w=5u l=1u
X483 VDD VDD VDD VDD pfet_03v3 ad=0.52p pd=2.52u as=0 ps=0 w=2u l=0.5u
X484 VSS VSS lvds_lane_2.sb.0 VSS nfet_03v3 ad=1.6984p pd=8.6u as=1.0036p ps=4.38u w=3.86u l=0.5u
X485 lvds_lane_1.oa.0 lvds_lane_1.rla_m1.0 VSS ppolyf_u_1k r_width=2u r_length=9.11u
X486 lvds_lane_2.tp.0 lvds_lane_2.gp.0 lvds_lane_2.fa.0 lvds_lane_2.tp.0 pfet_03v3 ad=1.248p pd=5.32u as=1.248p ps=5.32u w=4.8u l=0.4u
X487 lvds_bias_0.nrb.0 lvds_bias_0.enb.0 VDD VDD pfet_03v3 ad=1.3p pd=5.52u as=1.3p ps=5.52u w=5u l=0.5u
X488 lvds_lane_1.d2b.0 lvds_lane_1.d2b.0 VDD VDD pfet_03v3 ad=0.52p pd=2.52u as=0.52p ps=2.52u w=2u l=0.4u
X489 lvds_lane_0.d2b.0 lvds_lane_0.d2a.0 VDD VDD pfet_03v3 ad=0.52p pd=2.52u as=0.52p ps=2.52u w=2u l=0.4u
X490 lvds_lane_1.fa.0 lvds_lane_0.VREF.0 lvds_lane_1.tp.0 lvds_lane_1.tp.0 pfet_03v3 ad=1.248p pd=5.32u as=1.248p ps=5.32u w=4.8u l=0.4u
X491 lvds_lane_1.fb.0 lvds_lane_0.VB2.0 lvds_lane_1.ob.0 VSS nfet_03v3 ad=1.1752p pd=5.04u as=1.1752p ps=5.04u w=4.52u l=0.5u
X492 lvds_lane_2.fb.0 lvds_lane_0.VBN.0 VSS VSS nfet_03v3 ad=0.65p pd=3.02u as=0.65p ps=3.02u w=2.5u l=1u
X493 lvds_lane_1.tn.0 lvds_lane_0.VREF.0 lvds_lane_1.ob.0 VSS nfet_03v3 ad=1.235p pd=5.27u as=1.235p ps=5.27u w=4.75u l=0.5u
X494 lvds_lane_2.d2a.0 lvds_lane_2.d2a.0 VDD VDD pfet_03v3 ad=0.52p pd=2.52u as=0.52p ps=2.52u w=2u l=0.4u
X495 lvds_lane_1.d2a.0 VDD VDD VDD pfet_03v3 ad=0.52p pd=2.52u as=0.88p ps=4.88u w=2u l=0.5u
X496 VDD EN lvds_lane_1.d2b.0 VDD pfet_03v3 ad=0.52p pd=2.52u as=0.52p ps=2.52u w=2u l=0.5u
X497 lvds_lane_1.fa.0 lvds_lane_0.VREF.0 lvds_lane_1.tp.0 lvds_lane_1.tp.0 pfet_03v3 ad=1.248p pd=5.32u as=1.248p ps=5.32u w=4.8u l=0.4u
X498 VSS lvds_lane_0.VBN.0 lvds_lane_1.fa.0 VSS nfet_03v3 ad=0.65p pd=3.02u as=0.65p ps=3.02u w=2.5u l=1u
X499 lvds_lane_2.tn.0 lvds_lane_0.VBN.0 VSS VSS nfet_03v3 ad=0.65p pd=3.02u as=0.65p ps=3.02u w=2.5u l=1u
X500 lvds_lane_2.tp.0 VDD VDD VDD pfet_03v3 ad=1.3p pd=5.52u as=2.2p ps=10.88u w=5u l=1u
X501 lvds_lane_1.fb.0 lvds_lane_0.VB2.0 lvds_lane_1.ob.0 VSS nfet_03v3 ad=1.1752p pd=5.04u as=1.1752p ps=5.04u w=4.52u l=0.5u
X502 VDD lvds_lane_0.VBP.0 lvds_lane_0.VBP.0 VDD pfet_03v3 ad=1.3p pd=5.52u as=1.3p ps=5.52u w=5u l=1u
X503 lvds_lane_0.tn.0 lvds_lane_0.VREF.0 lvds_lane_0.oa.0 VSS nfet_03v3 ad=1.235p pd=5.27u as=1.235p ps=5.27u w=4.75u l=0.5u
X504 VDD lvds_lane_0.VBP.0 lvds_lane_1.tp.0 VDD pfet_03v3 ad=1.3p pd=5.52u as=1.3p ps=5.52u w=5u l=1u
X505 lvds_lane_0.fb.0 lvds_lane_0.VREF.0 lvds_lane_0.tp.0 lvds_lane_0.tp.0 pfet_03v3 ad=1.248p pd=5.32u as=1.248p ps=5.32u w=4.8u l=0.4u
X506 lvds_lane_0.tp.0 lvds_lane_0.VREF.0 lvds_lane_0.fb.0 lvds_lane_0.tp.0 pfet_03v3 ad=1.248p pd=5.32u as=1.248p ps=5.32u w=4.8u l=0.4u
X507 lvds_lane_1.tp.0 lvds_lane_0.VREF.0 lvds_lane_1.fb.0 lvds_lane_1.tp.0 pfet_03v3 ad=1.248p pd=5.32u as=1.248p ps=5.32u w=4.8u l=0.4u
X508 lvds_lane_1.ob.0 lvds_lane_1.rlb_m1.0 VSS ppolyf_u_1k r_width=2u r_length=9.11u
X509 lvds_lane_2.tp.0 lvds_lane_2.gn.0 lvds_lane_2.fb.0 lvds_lane_2.tp.0 pfet_03v3 ad=1.248p pd=5.32u as=1.248p ps=5.32u w=4.8u l=0.4u
X510 VDD VDD lvds_lane_1.nd.0 VDD pfet_03v3 ad=1.32p pd=6.88u as=0.78p ps=3.52u w=3u l=0.28u
X511 lvds_lane_1.gn.0 RX1_N VDD ppolyf_u r_width=5u r_length=1.8u
X512 lvds_lane_2.tp.0 lvds_lane_0.VREF.0 lvds_lane_2.fb.0 lvds_lane_2.tp.0 pfet_03v3 ad=1.248p pd=5.32u as=1.248p ps=5.32u w=4.8u l=0.4u
X513 VDD lvds_lane_1.d2a.0 lvds_lane_1.n3a.0 VDD pfet_03v3 ad=0.52p pd=2.52u as=0.52p ps=2.52u w=2u l=0.4u
X514 VDD VDD lvds_lane_0.n3a.0 VDD pfet_03v3 ad=0.88p pd=4.88u as=0.52p ps=2.52u w=2u l=0.4u
X515 lvds_lane_0.tp.0 lvds_lane_0.VBP.0 VDD VDD pfet_03v3 ad=1.3p pd=5.52u as=1.3p ps=5.52u w=5u l=1u
X516 lvds_lane_0.fa.0 lvds_lane_0.VREF.0 lvds_lane_0.tp.0 lvds_lane_0.tp.0 pfet_03v3 ad=1.248p pd=5.32u as=1.248p ps=5.32u w=4.8u l=0.4u
X517 VSS VSS lvds_bias_0.nmid.0 VSS nfet_03v3 ad=2.2p pd=10.88u as=1.3p ps=5.52u w=5u l=0.5u
X518 lvds_lane_0.tp.0 lvds_lane_0.gp.0 lvds_lane_0.fa.0 lvds_lane_0.tp.0 pfet_03v3 ad=1.248p pd=5.32u as=1.248p ps=5.32u w=4.8u l=0.4u
X519 lvds_lane_0.d2a.0 lvds_lane_0.d2a.0 VDD VDD pfet_03v3 ad=0.52p pd=2.52u as=0.52p ps=2.52u w=2u l=0.4u
X520 lvds_lane_1.ts.0 lvds_lane_1.sa.0 VSS ppolyf_u_1k r_width=2u r_length=8.86u
X521 lvds_lane_1.fb.0 lvds_lane_0.VREF.0 lvds_lane_1.tp.0 lvds_lane_1.tp.0 pfet_03v3 ad=1.248p pd=5.32u as=1.248p ps=5.32u w=4.8u l=0.4u
X522 lvds_lane_2.fb.0 lvds_lane_0.VREF.0 lvds_lane_2.tp.0 lvds_lane_2.tp.0 pfet_03v3 ad=1.248p pd=5.32u as=1.248p ps=5.32u w=4.8u l=0.4u
X523 lvds_lane_1.tp.0 lvds_lane_0.VBP.0 VDD VDD pfet_03v3 ad=1.3p pd=5.52u as=1.3p ps=5.52u w=5u l=1u
X524 VSS VSS lvds_lane_0.fa.0 VSS nfet_03v3 ad=1.1p pd=5.88u as=0.65p ps=3.02u w=2.5u l=1u
X525 VDD lvds_lane_0.d2b.0 lvds_lane_0.d2b.0 VDD pfet_03v3 ad=0.52p pd=2.52u as=0.52p ps=2.52u w=2u l=0.4u
X526 lvds_lane_2.sa.0 lvds_lane_2.oa.0 lvds_lane_2.d2a.0 VSS nfet_03v3 ad=1.0036p pd=4.38u as=1.0036p ps=4.38u w=3.86u l=0.5u
X527 lvds_lane_2.nd.0 EN VDD VDD pfet_03v3 ad=0.78p pd=3.52u as=0.78p ps=3.52u w=3u l=0.28u
X528 VSS EN lvds_bias_0.nmid.0 VSS nfet_03v3 ad=1.3p pd=5.52u as=1.3p ps=5.52u w=5u l=0.5u
X529 VDD lvds_lane_0.VBP.0 lvds_lane_0.VBP.0 VDD pfet_03v3 ad=1.3p pd=5.52u as=1.3p ps=5.52u w=5u l=1u
X530 lvds_lane_2.tp.0 lvds_lane_2.gp.0 lvds_lane_2.fa.0 lvds_lane_2.tp.0 pfet_03v3 ad=1.248p pd=5.32u as=1.248p ps=5.32u w=4.8u l=0.4u
X531 VDD lvds_lane_0.d2b.0 lvds_lane_0.d3.0 VDD pfet_03v3 ad=0.52p pd=2.52u as=0.52p ps=2.52u w=2u l=0.4u
X532 VSS lvds_lane_0.VBN.0 lvds_lane_2.tn.0 VSS nfet_03v3 ad=0.65p pd=3.02u as=0.65p ps=3.02u w=2.5u l=1u
X533 lvds_lane_2.oa.0 lvds_lane_0.VREF.0 lvds_lane_2.tn.0 VSS nfet_03v3 ad=1.235p pd=5.27u as=1.235p ps=5.27u w=4.75u l=0.5u
X534 VDD lvds_lane_0.VBP.0 lvds_lane_2.tp.0 VDD pfet_03v3 ad=1.3p pd=5.52u as=1.3p ps=5.52u w=5u l=1u
X535 lvds_lane_0.fa.0 lvds_lane_0.VREF.0 lvds_lane_0.tp.0 lvds_lane_0.tp.0 pfet_03v3 ad=1.248p pd=5.32u as=1.248p ps=5.32u w=4.8u l=0.4u
X536 lvds_lane_0.oa.0 lvds_lane_0.VB2.0 lvds_lane_0.fa.0 VSS nfet_03v3 ad=1.1752p pd=5.04u as=1.1752p ps=5.04u w=4.52u l=0.5u
X537 lvds_lane_2.i1.0 VSS VSS VSS nfet_03v3 ad=0.39p pd=2.02u as=0.66p ps=3.88u w=1.5u l=0.28u
X538 lvds_lane_1.ob.0 lvds_lane_1.gn.0 lvds_lane_1.tn.0 VSS nfet_03v3 ad=1.235p pd=5.27u as=1.235p ps=5.27u w=4.75u l=0.5u
X539 lvds_lane_1.fb.0 lvds_lane_1.gn.0 lvds_lane_1.tp.0 lvds_lane_1.tp.0 pfet_03v3 ad=1.248p pd=5.32u as=1.248p ps=5.32u w=4.8u l=0.4u
X540 lvds_lane_2.ob.0 lvds_lane_0.VB2.0 lvds_lane_2.fb.0 VSS nfet_03v3 ad=1.1752p pd=5.04u as=1.1752p ps=5.04u w=4.52u l=0.5u
X541 lvds_lane_2.ob.0 lvds_lane_0.VREF.0 lvds_lane_2.tn.0 VSS nfet_03v3 ad=1.235p pd=5.27u as=1.235p ps=5.27u w=4.75u l=0.5u
X542 lvds_lane_0.fa.0 lvds_lane_0.VREF.0 lvds_lane_0.tp.0 lvds_lane_0.tp.0 pfet_03v3 ad=1.248p pd=5.32u as=1.248p ps=5.32u w=4.8u l=0.4u
X543 lvds_lane_1.fa.0 lvds_lane_1.gp.0 lvds_lane_1.tp.0 lvds_lane_1.tp.0 pfet_03v3 ad=1.248p pd=5.32u as=1.248p ps=5.32u w=4.8u l=0.4u
X544 lvds_lane_2.fa.0 lvds_lane_0.VB2.0 lvds_lane_2.oa.0 VSS nfet_03v3 ad=1.1752p pd=5.04u as=1.1752p ps=5.04u w=4.52u l=0.5u
X545 lvds_lane_2.tp.0 lvds_lane_0.VREF.0 lvds_lane_2.fa.0 lvds_lane_2.tp.0 pfet_03v3 ad=1.248p pd=5.32u as=1.248p ps=5.32u w=4.8u l=0.4u
D6 VSS lvds_lane_2.gp.0 diode_nd2ps_03v3 pj=26u area=40p
X546 lvds_lane_1.oa.0 lvds_lane_1.gp.0 lvds_lane_1.tn.0 VSS nfet_03v3 ad=1.235p pd=5.27u as=1.235p ps=5.27u w=4.75u l=0.5u
X547 lvds_lane_2.tn.0 lvds_lane_0.VBN.0 VSS VSS nfet_03v3 ad=0.65p pd=3.02u as=0.65p ps=3.02u w=2.5u l=1u
X548 VSS VSS VSS VSS nfet_03v3 ad=0.52p pd=2.52u as=0 ps=0 w=2u l=0.28u
X549 lvds_lane_1.tp.0 lvds_lane_1.gn.0 lvds_lane_1.fb.0 lvds_lane_1.tp.0 pfet_03v3 ad=1.248p pd=5.32u as=1.248p ps=5.32u w=4.8u l=0.4u
X550 lvds_lane_2.fa.0 lvds_lane_0.VB2.0 lvds_lane_2.oa.0 VSS nfet_03v3 ad=1.1752p pd=5.04u as=1.1752p ps=5.04u w=4.52u l=0.5u
X551 lvds_lane_0.d3.0 lvds_lane_0.d2b.0 VDD VDD pfet_03v3 ad=0.52p pd=2.52u as=0.52p ps=2.52u w=2u l=0.4u
X552 lvds_lane_0.d2b.0 lvds_lane_0.d2a.0 VDD VDD pfet_03v3 ad=0.52p pd=2.52u as=0.52p ps=2.52u w=2u l=0.4u
X553 lvds_lane_2.fa.0 lvds_lane_0.VREF.0 lvds_lane_2.tp.0 lvds_lane_2.tp.0 pfet_03v3 ad=1.248p pd=5.32u as=1.248p ps=5.32u w=4.8u l=0.4u
X554 lvds_lane_0.ob.0 lvds_lane_0.gn.0 lvds_lane_0.tn.0 VSS nfet_03v3 ad=1.235p pd=5.27u as=1.235p ps=5.27u w=4.75u l=0.5u
X555 lvds_lane_0.tn.0 lvds_lane_0.VREF.0 lvds_lane_0.ob.0 VSS nfet_03v3 ad=1.235p pd=5.27u as=1.235p ps=5.27u w=4.75u l=0.5u
X556 lvds_lane_1.tn.0 lvds_lane_0.VREF.0 lvds_lane_1.ob.0 VSS nfet_03v3 ad=1.235p pd=5.27u as=1.235p ps=5.27u w=4.75u l=0.5u
X557 lvds_lane_2.n3a.0 lvds_lane_2.d2a.0 VDD VDD pfet_03v3 ad=0.52p pd=2.52u as=0.52p ps=2.52u w=2u l=0.4u
X558 lvds_lane_2.d2a.0 lvds_lane_2.d2b.0 VDD VDD pfet_03v3 ad=0.52p pd=2.52u as=0.52p ps=2.52u w=2u l=0.4u
X559 lvds_lane_0.fa.0 lvds_lane_0.VBN.0 VSS VSS nfet_03v3 ad=0.65p pd=3.02u as=0.65p ps=3.02u w=2.5u l=1u
X560 VDD lvds_lane_0.nd.0 lvds_lane_0.i1.0 VDD pfet_03v3 ad=0.962p pd=4.22u as=0.962p ps=4.22u w=3.7u l=0.28u
X561 VDD lvds_lane_0.VBP.0 lvds_lane_1.tp.0 VDD pfet_03v3 ad=1.3p pd=5.52u as=1.3p ps=5.52u w=5u l=1u
X562 lvds_lane_0.fb.0 lvds_lane_0.VB2.0 lvds_lane_0.ob.0 VSS nfet_03v3 ad=1.1752p pd=5.04u as=1.1752p ps=5.04u w=4.52u l=0.5u
X563 lvds_lane_0.tn.0 lvds_lane_0.VBN.0 VSS VSS nfet_03v3 ad=0.65p pd=3.02u as=0.65p ps=3.02u w=2.5u l=1u
X564 lvds_lane_2.tn.0 lvds_lane_2.gp.0 lvds_lane_2.oa.0 VSS nfet_03v3 ad=1.235p pd=5.27u as=1.235p ps=5.27u w=4.75u l=0.5u
X565 lvds_lane_0.tp.0 lvds_lane_0.VBP.0 VDD VDD pfet_03v3 ad=1.3p pd=5.52u as=1.3p ps=5.52u w=5u l=1u
X566 VDD VDD lvds_lane_2.i2.0 VDD pfet_03v3 ad=1.65p pd=8.38u as=0.975p ps=4.27u w=3.75u l=0.28u
X567 VSS lvds_lane_0.VBN.0 lvds_lane_2.ts.0 VSS nfet_03v3 ad=0.65p pd=3.02u as=0.65p ps=3.02u w=2.5u l=1u
X568 lvds_lane_2.tp.0 lvds_lane_0.VREF.0 lvds_lane_2.fb.0 lvds_lane_2.tp.0 pfet_03v3 ad=1.248p pd=5.32u as=2.112p ps=10.48u w=4.8u l=0.4u
X569 lvds_lane_0.sa.0 lvds_lane_0.oa.0 lvds_lane_0.d2a.0 VSS nfet_03v3 ad=1.0036p pd=4.38u as=1.0036p ps=4.38u w=3.86u l=0.5u
X570 lvds_lane_2.fa.0 lvds_lane_0.VREF.0 lvds_lane_2.tp.0 lvds_lane_2.tp.0 pfet_03v3 ad=1.248p pd=5.32u as=1.248p ps=5.32u w=4.8u l=0.4u
X571 lvds_lane_1.fa.0 lvds_lane_0.VBN.0 VSS VSS nfet_03v3 ad=0.65p pd=3.02u as=0.65p ps=3.02u w=2.5u l=1u
X572 lvds_lane_2.tn.0 lvds_lane_2.gn.0 lvds_lane_2.ob.0 VSS nfet_03v3 ad=1.235p pd=5.27u as=1.235p ps=5.27u w=4.75u l=0.5u
X573 lvds_lane_0.oa.0 lvds_lane_0.VREF.0 lvds_lane_0.tn.0 VSS nfet_03v3 ad=1.235p pd=5.27u as=1.235p ps=5.27u w=4.75u l=0.5u
X574 lvds_lane_2.nd.0 VSS VSS VSS nfet_03v3 ad=0.52p pd=2.52u as=0.88p ps=4.88u w=2u l=0.28u
X575 VSS VSS VSS ppolyf_u_1k r_width=2u r_length=21.01u
X576 lvds_lane_2.d2a.0 VSS VSS VSS nfet_03v3 ad=1.0036p pd=4.38u as=1.6984p ps=8.6u w=3.86u l=0.5u
X577 lvds_lane_1.tp.0 lvds_lane_0.VBP.0 VDD VDD pfet_03v3 ad=1.3p pd=5.52u as=1.3p ps=5.52u w=5u l=1u
X578 lvds_lane_2.tp.0 lvds_lane_0.VREF.0 lvds_lane_2.fb.0 lvds_lane_2.tp.0 pfet_03v3 ad=1.248p pd=5.32u as=1.248p ps=5.32u w=4.8u l=0.4u
X579 lvds_lane_1.fb.0 lvds_lane_0.VBN.0 VSS VSS nfet_03v3 ad=0.65p pd=3.02u as=0.65p ps=3.02u w=2.5u l=1u
X580 lvds_lane_2.tn.0 lvds_lane_0.VREF.0 lvds_lane_2.ob.0 VSS nfet_03v3 ad=1.235p pd=5.27u as=1.235p ps=5.27u w=4.75u l=0.5u
X581 lvds_lane_0.fb.0 lvds_lane_0.VREF.0 lvds_lane_0.tp.0 lvds_lane_0.tp.0 pfet_03v3 ad=1.248p pd=5.32u as=1.248p ps=5.32u w=4.8u l=0.4u
X582 lvds_lane_0.VREF.0 lvds_bias_0.rdb_m1.0 VSS ppolyf_u_1k r_width=2u r_length=19.26u
X583 lvds_lane_2.tp.0 lvds_lane_0.VREF.0 lvds_lane_2.fb.0 lvds_lane_2.tp.0 pfet_03v3 ad=1.248p pd=5.32u as=1.248p ps=5.32u w=4.8u l=0.4u
X584 lvds_lane_1.i1.0 VDD VDD VDD pfet_03v3 ad=0.962p pd=4.22u as=1.628p ps=8.28u w=3.7u l=0.28u
X585 VSS VSS lvds_lane_0.ts.0 VSS nfet_03v3 ad=1.1p pd=5.88u as=0.65p ps=3.02u w=2.5u l=1u
X586 VSS EN lvds_lane_2.nm.0 VSS nfet_03v3 ad=0.52p pd=2.52u as=0.52p ps=2.52u w=2u l=0.28u
X587 VSS lvds_lane_2.nd.0 lvds_lane_2.i1.0 VSS nfet_03v3 ad=0.39p pd=2.02u as=0.39p ps=2.02u w=1.5u l=0.28u
X588 lvds_lane_0.tp.0 lvds_lane_0.gp.0 lvds_lane_0.fa.0 lvds_lane_0.tp.0 pfet_03v3 ad=1.248p pd=5.32u as=1.248p ps=5.32u w=4.8u l=0.4u
X589 lvds_lane_1.tp.0 lvds_lane_1.gp.0 lvds_lane_1.fa.0 lvds_lane_1.tp.0 pfet_03v3 ad=1.248p pd=5.32u as=1.248p ps=5.32u w=4.8u l=0.4u
X590 lvds_lane_1.fb.0 lvds_lane_0.VREF.0 lvds_lane_1.tp.0 lvds_lane_1.tp.0 pfet_03v3 ad=1.248p pd=5.32u as=1.248p ps=5.32u w=4.8u l=0.4u
X591 lvds_lane_2.fb.0 lvds_lane_0.VREF.0 lvds_lane_2.tp.0 lvds_lane_2.tp.0 pfet_03v3 ad=1.248p pd=5.32u as=1.248p ps=5.32u w=4.8u l=0.4u
X592 lvds_lane_2.fb.0 lvds_lane_2.gn.0 lvds_lane_2.tp.0 lvds_lane_2.tp.0 pfet_03v3 ad=1.248p pd=5.32u as=1.248p ps=5.32u w=4.8u l=0.4u
X593 VDD VDD lvds_lane_0.d2b.0 VDD pfet_03v3 ad=0.88p pd=4.88u as=0.52p ps=2.52u w=2u l=0.4u
X594 VSS lvds_lane_0.VBN.0 lvds_lane_0.fa.0 VSS nfet_03v3 ad=0.65p pd=3.02u as=0.65p ps=3.02u w=2.5u l=1u
X595 VDD lvds_lane_2.d2a.0 lvds_lane_2.n3a.0 VDD pfet_03v3 ad=0.52p pd=2.52u as=0.52p ps=2.52u w=2u l=0.4u
X596 VDD lvds_lane_2.d2a.0 lvds_lane_2.d2a.0 VDD pfet_03v3 ad=0.52p pd=2.52u as=0.52p ps=2.52u w=2u l=0.4u
X597 VDD lvds_lane_1.d2b.0 lvds_lane_1.d2a.0 VDD pfet_03v3 ad=0.52p pd=2.52u as=0.52p ps=2.52u w=2u l=0.4u
X598 lvds_lane_1.fa.0 lvds_lane_0.VB2.0 lvds_lane_1.oa.0 VSS nfet_03v3 ad=1.1752p pd=5.04u as=1.1752p ps=5.04u w=4.52u l=0.5u
X599 VSS lvds_lane_0.VBN.0 lvds_lane_1.fb.0 VSS nfet_03v3 ad=0.65p pd=3.02u as=0.65p ps=3.02u w=2.5u l=1u
X600 VSS VSS lvds_lane_0.tn.0 VSS nfet_03v3 ad=1.1p pd=5.88u as=0.65p ps=3.02u w=2.5u l=1u
X601 RX1_O VDD VDD VDD pfet_03v3 ad=1.3p pd=5.52u as=2.2p ps=10.88u w=5u l=0.28u
X602 lvds_lane_1.d2b.0 VSS VSS VSS nfet_03v3 ad=1.0036p pd=4.38u as=1.6984p ps=8.6u w=3.86u l=0.5u
X603 VDD lvds_lane_0.VBP.0 lvds_lane_0.tp.0 VDD pfet_03v3 ad=1.3p pd=5.52u as=1.3p ps=5.52u w=5u l=1u
X604 lvds_lane_1.tp.0 lvds_lane_0.VREF.0 lvds_lane_1.fa.0 lvds_lane_1.tp.0 pfet_03v3 ad=1.248p pd=5.32u as=1.248p ps=5.32u w=4.8u l=0.4u
X605 lvds_lane_0.tp.0 lvds_lane_0.gn.0 lvds_lane_0.fb.0 lvds_lane_0.tp.0 pfet_03v3 ad=1.248p pd=5.32u as=1.248p ps=5.32u w=4.8u l=0.4u
X606 lvds_lane_1.fa.0 lvds_lane_0.VB2.0 lvds_lane_1.oa.0 VSS nfet_03v3 ad=1.1752p pd=5.04u as=1.1752p ps=5.04u w=4.52u l=0.5u
X607 lvds_lane_1.d2a.0 lvds_lane_1.d2b.0 VDD VDD pfet_03v3 ad=0.52p pd=2.52u as=0.52p ps=2.52u w=2u l=0.4u
X608 VDD lvds_lane_1.rlb_m1.0 VSS ppolyf_u_1k r_width=2u r_length=9.11u
X609 lvds_lane_1.tn.0 lvds_lane_0.VREF.0 lvds_lane_1.oa.0 VSS nfet_03v3 ad=1.235p pd=5.27u as=1.235p ps=5.27u w=4.75u l=0.5u
X610 lvds_bias_0.rf_m1.0 lvds_bias_0.vf.0 VSS ppolyf_u_1k r_width=2u r_length=23.07u
X611 lvds_lane_2.tp.0 lvds_lane_0.VREF.0 lvds_lane_2.fa.0 lvds_lane_2.tp.0 pfet_03v3 ad=1.248p pd=5.32u as=1.248p ps=5.32u w=4.8u l=0.4u
X612 lvds_lane_1.fa.0 VSS VSS VSS nfet_03v3 ad=0.65p pd=3.02u as=1.1p ps=5.88u w=2.5u l=1u
X613 lvds_lane_1.fb.0 lvds_lane_0.VB2.0 lvds_lane_1.ob.0 VSS nfet_03v3 ad=1.1752p pd=5.04u as=1.1752p ps=5.04u w=4.52u l=0.5u
X614 lvds_lane_0.tn.0 lvds_lane_0.VREF.0 lvds_lane_0.ob.0 VSS nfet_03v3 ad=1.235p pd=5.27u as=2.09p ps=10.38u w=4.75u l=0.5u
X615 lvds_lane_0.tn.0 lvds_lane_0.VREF.0 lvds_lane_0.oa.0 VSS nfet_03v3 ad=1.235p pd=5.27u as=1.235p ps=5.27u w=4.75u l=0.5u
X616 lvds_lane_1.tp.0 lvds_lane_0.VREF.0 lvds_lane_1.fa.0 lvds_lane_1.tp.0 pfet_03v3 ad=1.248p pd=5.32u as=1.248p ps=5.32u w=4.8u l=0.4u
X617 lvds_lane_1.i1.0 VSS VSS VSS nfet_03v3 ad=0.39p pd=2.02u as=0.66p ps=3.88u w=1.5u l=0.28u
X618 lvds_lane_0.i2.0 lvds_lane_0.i1.0 VDD VDD pfet_03v3 ad=0.975p pd=4.27u as=0.975p ps=4.27u w=3.75u l=0.28u
X619 lvds_lane_0.fb.0 lvds_lane_0.gn.0 lvds_lane_0.tp.0 lvds_lane_0.tp.0 pfet_03v3 ad=1.248p pd=5.32u as=1.248p ps=5.32u w=4.8u l=0.4u
X620 lvds_lane_1.tp.0 lvds_lane_0.VREF.0 lvds_lane_1.fb.0 lvds_lane_1.tp.0 pfet_03v3 ad=1.248p pd=5.32u as=1.248p ps=5.32u w=4.8u l=0.4u
X621 lvds_lane_2.tp.0 lvds_lane_2.gp.0 lvds_lane_2.fa.0 lvds_lane_2.tp.0 pfet_03v3 ad=1.248p pd=5.32u as=1.248p ps=5.32u w=4.8u l=0.4u
X622 lvds_lane_0.tp.0 lvds_lane_0.VREF.0 lvds_lane_0.fb.0 lvds_lane_0.tp.0 pfet_03v3 ad=1.248p pd=5.32u as=1.248p ps=5.32u w=4.8u l=0.4u
X623 VSS lvds_bias_0.enb.0 lvds_lane_0.VBN.0 VSS nfet_03v3 ad=0.52p pd=2.52u as=0.52p ps=2.52u w=2u l=0.5u
X624 lvds_lane_2.tp.0 lvds_lane_2.gn.0 lvds_lane_2.fb.0 lvds_lane_2.tp.0 pfet_03v3 ad=1.248p pd=5.32u as=1.248p ps=5.32u w=4.8u l=0.4u
X625 VDD lvds_lane_2.d2b.0 lvds_lane_2.d3.0 VDD pfet_03v3 ad=0.52p pd=2.52u as=0.52p ps=2.52u w=2u l=0.4u
X626 VDD lvds_lane_1.d2b.0 lvds_lane_1.d3.0 VDD pfet_03v3 ad=0.52p pd=2.52u as=0.52p ps=2.52u w=2u l=0.4u
D7 lvds_lane_1.gp.0 VDD diode_pd2nw_03v3 pj=26u area=40p
X627 lvds_lane_1.tn.0 lvds_lane_1.gn.0 lvds_lane_1.ob.0 VSS nfet_03v3 ad=1.235p pd=5.27u as=1.235p ps=5.27u w=4.75u l=0.5u
X628 VSS VSS VSS VSS nfet_03v3 ad=0.52p pd=2.52u as=0 ps=0 w=2u l=0.28u
X629 VDD lvds_lane_2.d2b.0 lvds_lane_2.d2a.0 VDD pfet_03v3 ad=0.52p pd=2.52u as=0.52p ps=2.52u w=2u l=0.4u
X630 VDD lvds_lane_1.d2b.0 lvds_lane_1.d2b.0 VDD pfet_03v3 ad=0.52p pd=2.52u as=0.52p ps=2.52u w=2u l=0.4u
X631 lvds_lane_2.fb.0 lvds_lane_2.gn.0 lvds_lane_2.tp.0 lvds_lane_2.tp.0 pfet_03v3 ad=1.248p pd=5.32u as=1.248p ps=5.32u w=4.8u l=0.4u
X632 lvds_lane_1.fa.0 lvds_lane_0.VBN.0 VSS VSS nfet_03v3 ad=0.65p pd=3.02u as=0.65p ps=3.02u w=2.5u l=1u
X633 lvds_lane_2.fa.0 lvds_lane_0.VBN.0 VSS VSS nfet_03v3 ad=0.65p pd=3.02u as=0.65p ps=3.02u w=2.5u l=1u
X634 VDD VDD VDD VDD pfet_03v3 ad=0.962p pd=4.22u as=0 ps=0 w=3.7u l=0.28u
X635 VSS lvds_lane_0.VBN.0 lvds_lane_0.tn.0 VSS nfet_03v3 ad=0.65p pd=3.02u as=0.65p ps=3.02u w=2.5u l=1u
X636 lvds_lane_1.tp.0 lvds_lane_0.VBP.0 VDD VDD pfet_03v3 ad=1.3p pd=5.52u as=1.3p ps=5.52u w=5u l=1u
X637 lvds_lane_0.tp.0 lvds_lane_0.VREF.0 lvds_lane_0.fa.0 lvds_lane_0.tp.0 pfet_03v3 ad=1.248p pd=5.32u as=1.248p ps=5.32u w=4.8u l=0.4u
X638 lvds_lane_1.tn.0 lvds_lane_0.VREF.0 lvds_lane_1.oa.0 VSS nfet_03v3 ad=1.235p pd=5.27u as=1.235p ps=5.27u w=4.75u l=0.5u
X639 lvds_lane_2.sb.0 lvds_lane_2.ob.0 lvds_lane_2.d2b.0 VSS nfet_03v3 ad=1.0036p pd=4.38u as=1.0036p ps=4.38u w=3.86u l=0.5u
X640 lvds_lane_1.d2b.0 lvds_lane_1.d2a.0 VDD VDD pfet_03v3 ad=0.52p pd=2.52u as=0.52p ps=2.52u w=2u l=0.4u
X641 lvds_lane_1.tp.0 lvds_lane_1.gn.0 lvds_lane_1.fb.0 lvds_lane_1.tp.0 pfet_03v3 ad=1.248p pd=5.32u as=1.248p ps=5.32u w=4.8u l=0.4u
X642 lvds_lane_0.tp.0 lvds_lane_0.VREF.0 lvds_lane_0.fa.0 lvds_lane_0.tp.0 pfet_03v3 ad=1.248p pd=5.32u as=1.248p ps=5.32u w=4.8u l=0.4u
X643 VDD lvds_lane_1.i1.0 lvds_lane_1.i2.0 VDD pfet_03v3 ad=0.975p pd=4.27u as=0.975p ps=4.27u w=3.75u l=0.28u
X644 VSS EN lvds_bias_0.enb.0 VSS nfet_03v3 ad=0.44p pd=2.88u as=0.44p ps=2.88u w=1u l=0.28u
X645 lvds_lane_2.fb.0 lvds_lane_0.VREF.0 lvds_lane_2.tp.0 lvds_lane_2.tp.0 pfet_03v3 ad=1.248p pd=5.32u as=1.248p ps=5.32u w=4.8u l=0.4u
X646 VSS lvds_lane_0.VBN.0 lvds_lane_1.fa.0 VSS nfet_03v3 ad=0.65p pd=3.02u as=0.65p ps=3.02u w=2.5u l=1u
X647 VSS lvds_lane_0.VBN.0 lvds_lane_2.fb.0 VSS nfet_03v3 ad=0.65p pd=3.02u as=0.65p ps=3.02u w=2.5u l=1u
X648 VSS lvds_lane_0.VBN.0 lvds_lane_1.tn.0 VSS nfet_03v3 ad=0.65p pd=3.02u as=0.65p ps=3.02u w=2.5u l=1u
X649 VDD VDD RX1_O VDD pfet_03v3 ad=2.2p pd=10.88u as=1.3p ps=5.52u w=5u l=0.28u
X650 lvds_lane_1.ob.0 lvds_lane_1.gn.0 lvds_lane_1.tn.0 VSS nfet_03v3 ad=1.235p pd=5.27u as=1.235p ps=5.27u w=4.75u l=0.5u
X651 lvds_lane_0.nd.0 VDD VDD VDD pfet_03v3 ad=0.78p pd=3.52u as=1.32p ps=6.88u w=3u l=0.28u
X652 VDD lvds_lane_0.d2b.0 lvds_lane_0.d3.0 VDD pfet_03v3 ad=0.52p pd=2.52u as=0.52p ps=2.52u w=2u l=0.4u
X653 VSS lvds_lane_0.VBN.0 lvds_lane_2.fa.0 VSS nfet_03v3 ad=0.65p pd=3.02u as=0.65p ps=3.02u w=2.5u l=1u
X654 lvds_lane_2.ob.0 lvds_lane_0.VB2.0 lvds_lane_2.fb.0 VSS nfet_03v3 ad=1.1752p pd=5.04u as=1.1752p ps=5.04u w=4.52u l=0.5u
X655 lvds_lane_0.ts.0 lvds_lane_0.VBN.0 VSS VSS nfet_03v3 ad=0.65p pd=3.02u as=0.65p ps=3.02u w=2.5u l=1u
X656 lvds_lane_1.d3.0 lvds_lane_1.n3a.0 VSS VSS nfet_03v3 ad=0.6734p pd=3.11u as=0.6734p ps=3.11u w=2.59u l=0.28u
X657 VDD lvds_lane_0.d2a.0 lvds_lane_0.d2b.0 VDD pfet_03v3 ad=0.52p pd=2.52u as=0.52p ps=2.52u w=2u l=0.4u
X658 lvds_lane_1.nd.0 VSS VSS VSS nfet_03v3 ad=0.52p pd=2.52u as=0.88p ps=4.88u w=2u l=0.28u
X659 lvds_lane_2.oa.0 lvds_lane_0.VREF.0 lvds_lane_2.tn.0 VSS nfet_03v3 ad=1.235p pd=5.27u as=1.235p ps=5.27u w=4.75u l=0.5u
X660 lvds_lane_0.fa.0 lvds_lane_0.gp.0 lvds_lane_0.tp.0 lvds_lane_0.tp.0 pfet_03v3 ad=1.248p pd=5.32u as=1.248p ps=5.32u w=4.8u l=0.4u
X661 lvds_lane_1.ts.0 VSS VSS VSS nfet_03v3 ad=0.65p pd=3.02u as=1.1p ps=5.88u w=2.5u l=1u
X662 lvds_lane_0.d2b.0 lvds_lane_0.ob.0 lvds_lane_0.sb.0 VSS nfet_03v3 ad=1.0036p pd=4.38u as=1.0036p ps=4.38u w=3.86u l=0.5u
X663 lvds_lane_0.tp.0 lvds_lane_0.VREF.0 lvds_lane_0.fa.0 lvds_lane_0.tp.0 pfet_03v3 ad=1.248p pd=5.32u as=1.248p ps=5.32u w=4.8u l=0.4u
X664 lvds_lane_2.tp.0 lvds_lane_2.gn.0 lvds_lane_2.fb.0 lvds_lane_2.tp.0 pfet_03v3 ad=1.248p pd=5.32u as=1.248p ps=5.32u w=4.8u l=0.4u
X665 lvds_lane_2.ob.0 lvds_lane_0.VB2.0 lvds_lane_2.fb.0 VSS nfet_03v3 ad=1.1752p pd=5.04u as=1.1752p ps=5.04u w=4.52u l=0.5u
X666 lvds_lane_0.tn.0 lvds_lane_0.VREF.0 lvds_lane_0.oa.0 VSS nfet_03v3 ad=1.235p pd=5.27u as=1.235p ps=5.27u w=4.75u l=0.5u
X667 lvds_lane_1.ob.0 lvds_lane_1.gn.0 lvds_lane_1.tn.0 VSS nfet_03v3 ad=1.235p pd=5.27u as=1.235p ps=5.27u w=4.75u l=0.5u
X668 VDD VDD VDD VDD pfet_03v3 ad=0.52p pd=2.52u as=0 ps=0 w=2u l=0.5u
X669 lvds_lane_0.d2b.0 lvds_lane_0.d2b.0 VDD VDD pfet_03v3 ad=0.52p pd=2.52u as=0.52p ps=2.52u w=2u l=0.4u
X670 lvds_lane_0.oa.0 lvds_lane_0.rla_m1.0 VSS ppolyf_u_1k r_width=2u r_length=9.11u
X671 lvds_lane_0.fa.0 lvds_lane_0.VREF.0 lvds_lane_0.tp.0 lvds_lane_0.tp.0 pfet_03v3 ad=1.248p pd=5.32u as=1.248p ps=5.32u w=4.8u l=0.4u
X672 lvds_lane_2.tp.0 lvds_lane_2.gp.0 lvds_lane_2.fa.0 lvds_lane_2.tp.0 pfet_03v3 ad=1.248p pd=5.32u as=1.248p ps=5.32u w=4.8u l=0.4u
X673 lvds_lane_0.fb.0 lvds_lane_0.VB2.0 lvds_lane_0.ob.0 VSS nfet_03v3 ad=1.1752p pd=5.04u as=1.1752p ps=5.04u w=4.52u l=0.5u
X674 VSS EN lvds_lane_1.nm.0 VSS nfet_03v3 ad=0.52p pd=2.52u as=0.52p ps=2.52u w=2u l=0.28u
X675 VSS lvds_lane_1.nd.0 lvds_lane_1.i1.0 VSS nfet_03v3 ad=0.39p pd=2.02u as=0.39p ps=2.02u w=1.5u l=0.28u
X676 lvds_lane_1.fb.0 lvds_lane_0.VBN.0 VSS VSS nfet_03v3 ad=0.65p pd=3.02u as=0.65p ps=3.02u w=2.5u l=1u
X677 lvds_lane_0.tn.0 lvds_lane_0.VREF.0 lvds_lane_0.ob.0 VSS nfet_03v3 ad=1.235p pd=5.27u as=1.235p ps=5.27u w=4.75u l=0.5u
X678 lvds_lane_1.oa.0 lvds_lane_1.gp.0 lvds_lane_1.tn.0 VSS nfet_03v3 ad=1.235p pd=5.27u as=1.235p ps=5.27u w=4.75u l=0.5u
X679 lvds_lane_1.d2a.0 lvds_lane_1.d2a.0 VDD VDD pfet_03v3 ad=0.52p pd=2.52u as=0.52p ps=2.52u w=2u l=0.4u
X680 lvds_lane_2.tp.0 lvds_lane_0.VREF.0 lvds_lane_2.fa.0 lvds_lane_2.tp.0 pfet_03v3 ad=1.248p pd=5.32u as=1.248p ps=5.32u w=4.8u l=0.4u
X681 lvds_lane_2.ob.0 VSS VSS VSS nfet_03v3 ad=1.1752p pd=5.04u as=1.9888p ps=9.92u w=4.52u l=0.5u
X682 VDD EN lvds_lane_0.d2b.0 VDD pfet_03v3 ad=0.52p pd=2.52u as=0.52p ps=2.52u w=2u l=0.5u
X683 lvds_lane_0.d2a.0 VDD VDD VDD pfet_03v3 ad=0.52p pd=2.52u as=0.88p ps=4.88u w=2u l=0.5u
X684 lvds_lane_1.tn.0 lvds_lane_0.VBN.0 VSS VSS nfet_03v3 ad=0.65p pd=3.02u as=0.65p ps=3.02u w=2.5u l=1u
X685 lvds_lane_1.tp.0 VDD VDD VDD pfet_03v3 ad=1.3p pd=5.52u as=2.2p ps=10.88u w=5u l=1u
X686 lvds_lane_0.fa.0 lvds_lane_0.VREF.0 lvds_lane_0.tp.0 lvds_lane_0.tp.0 pfet_03v3 ad=1.248p pd=5.32u as=1.248p ps=5.32u w=4.8u l=0.4u
X687 VSS lvds_lane_0.VBN.0 lvds_lane_0.fa.0 VSS nfet_03v3 ad=0.65p pd=3.02u as=0.65p ps=3.02u w=2.5u l=1u
X688 lvds_lane_0.fb.0 lvds_lane_0.VB2.0 lvds_lane_0.ob.0 VSS nfet_03v3 ad=1.1752p pd=5.04u as=1.1752p ps=5.04u w=4.52u l=0.5u
X689 VDD lvds_lane_0.VBP.0 lvds_lane_0.VB2.0 VDD pfet_03v3 ad=1.3p pd=5.52u as=1.3p ps=5.52u w=5u l=1u
X690 lvds_lane_1.tp.0 lvds_lane_1.gp.0 lvds_lane_1.fa.0 lvds_lane_1.tp.0 pfet_03v3 ad=1.248p pd=5.32u as=1.248p ps=5.32u w=4.8u l=0.4u
X691 VSS lvds_lane_2.n3a.0 lvds_lane_2.n3a.0 VSS nfet_03v3 ad=0.6734p pd=3.11u as=0.6734p ps=3.11u w=2.59u l=0.28u
X692 VDD lvds_lane_0.VBP.0 lvds_lane_0.tp.0 VDD pfet_03v3 ad=1.3p pd=5.52u as=1.3p ps=5.52u w=5u l=1u
X693 lvds_lane_0.tp.0 lvds_lane_0.VREF.0 lvds_lane_0.fb.0 lvds_lane_0.tp.0 pfet_03v3 ad=1.248p pd=5.32u as=1.248p ps=5.32u w=4.8u l=0.4u
X694 lvds_lane_1.fa.0 lvds_lane_1.gp.0 lvds_lane_1.tp.0 lvds_lane_1.tp.0 pfet_03v3 ad=1.248p pd=5.32u as=1.248p ps=5.32u w=4.8u l=0.4u
X695 lvds_lane_2.fa.0 lvds_lane_0.VREF.0 lvds_lane_2.tp.0 lvds_lane_2.tp.0 pfet_03v3 ad=1.248p pd=5.32u as=1.248p ps=5.32u w=4.8u l=0.4u
X696 lvds_bias_0.vf.0 lvds_lane_0.VB2.0 lvds_lane_0.VB2.0 VSS nfet_03v3 ad=2.0566p pd=8.43u as=2.0566p ps=8.43u w=7.91u l=0.5u
X697 RX0_O VDD VDD VDD pfet_03v3 ad=1.3p pd=5.52u as=2.2p ps=10.88u w=5u l=0.28u
X698 VDD VDD lvds_lane_0.nd.0 VDD pfet_03v3 ad=1.32p pd=6.88u as=0.78p ps=3.52u w=3u l=0.28u
X699 lvds_lane_0.ob.0 lvds_lane_0.rlb_m1.0 VSS ppolyf_u_1k r_width=2u r_length=9.11u
X700 lvds_lane_2.tn.0 lvds_lane_2.gp.0 lvds_lane_2.oa.0 VSS nfet_03v3 ad=1.235p pd=5.27u as=1.235p ps=5.27u w=4.75u l=0.5u
X701 lvds_lane_0.gn.0 RX0_N VDD ppolyf_u r_width=5u r_length=1.8u
X702 lvds_lane_2.fa.0 lvds_lane_0.VBN.0 VSS VSS nfet_03v3 ad=0.65p pd=3.02u as=0.65p ps=3.02u w=2.5u l=1u
X703 lvds_lane_1.tp.0 lvds_lane_0.VREF.0 lvds_lane_1.fb.0 lvds_lane_1.tp.0 pfet_03v3 ad=1.248p pd=5.32u as=1.248p ps=5.32u w=4.8u l=0.4u
X704 RX1_O lvds_lane_1.i2.0 VDD VDD pfet_03v3 ad=1.3p pd=5.52u as=1.3p ps=5.52u w=5u l=0.28u
X705 VDD lvds_lane_0.d2a.0 lvds_lane_0.n3a.0 VDD pfet_03v3 ad=0.52p pd=2.52u as=0.52p ps=2.52u w=2u l=0.4u
X706 VSS VSS VSS VSS nfet_03v3 ad=0.52p pd=2.52u as=0 ps=0 w=2u l=0.5u
X707 lvds_lane_2.fb.0 lvds_lane_0.VBN.0 VSS VSS nfet_03v3 ad=0.65p pd=3.02u as=0.65p ps=3.02u w=2.5u l=1u
X708 lvds_lane_2.tn.0 lvds_lane_0.VBN.0 VSS VSS nfet_03v3 ad=0.65p pd=3.02u as=0.65p ps=3.02u w=2.5u l=1u
X709 VSS lvds_lane_0.VBN.0 lvds_lane_1.ts.0 VSS nfet_03v3 ad=0.65p pd=3.02u as=0.65p ps=3.02u w=2.5u l=1u
X710 lvds_lane_2.tp.0 lvds_lane_0.VBP.0 VDD VDD pfet_03v3 ad=1.3p pd=5.52u as=1.3p ps=5.52u w=5u l=1u
X711 lvds_lane_2.d3.0 lvds_lane_2.d2b.0 VDD VDD pfet_03v3 ad=0.52p pd=2.52u as=0.52p ps=2.52u w=2u l=0.4u
X712 lvds_lane_1.fa.0 lvds_lane_1.gp.0 lvds_lane_1.tp.0 lvds_lane_1.tp.0 pfet_03v3 ad=1.248p pd=5.32u as=1.248p ps=5.32u w=4.8u l=0.4u
X713 lvds_lane_2.d2b.0 lvds_lane_2.d2b.0 VDD VDD pfet_03v3 ad=0.52p pd=2.52u as=0.52p ps=2.52u w=2u l=0.4u
X714 lvds_lane_0.VB2.0 VSS VSS VSS nfet_03v3 ad=0.52p pd=2.52u as=0.88p ps=4.88u w=2u l=0.5u
X715 RX2_O VDD VDD VDD pfet_03v3 ad=1.3p pd=5.52u as=2.2p ps=10.88u w=5u l=0.28u
X716 lvds_bias_0.enb.0 VDD VDD VDD pfet_03v3 ad=0.65p pd=3.02u as=1.1p ps=5.88u w=2.5u l=0.28u
X717 lvds_lane_0.VREF.0 lvds_bias_0.rdt_m3.0 VSS ppolyf_u_1k r_width=2u r_length=21.01u
X718 lvds_lane_0.fb.0 lvds_lane_0.VREF.0 lvds_lane_0.tp.0 lvds_lane_0.tp.0 pfet_03v3 ad=1.248p pd=5.32u as=1.248p ps=5.32u w=4.8u l=0.4u
X719 lvds_lane_1.fb.0 lvds_lane_0.VREF.0 lvds_lane_1.tp.0 lvds_lane_1.tp.0 pfet_03v3 ad=1.248p pd=5.32u as=1.248p ps=5.32u w=4.8u l=0.4u
X720 lvds_lane_0.ts.0 lvds_lane_0.sa.0 VSS ppolyf_u_1k r_width=2u r_length=8.86u
X721 lvds_lane_0.tp.0 lvds_lane_0.VBP.0 VDD VDD pfet_03v3 ad=1.3p pd=5.52u as=1.3p ps=5.52u w=5u l=1u
X722 lvds_lane_2.tp.0 lvds_lane_2.gn.0 lvds_lane_2.fb.0 lvds_lane_2.tp.0 pfet_03v3 ad=1.248p pd=5.32u as=1.248p ps=5.32u w=4.8u l=0.4u
X723 lvds_lane_2.tn.0 lvds_lane_2.gp.0 lvds_lane_2.oa.0 VSS nfet_03v3 ad=1.235p pd=5.27u as=1.235p ps=5.27u w=4.75u l=0.5u
X724 VSS lvds_lane_0.VBN.0 lvds_lane_2.fb.0 VSS nfet_03v3 ad=0.65p pd=3.02u as=0.65p ps=3.02u w=2.5u l=1u
X725 lvds_lane_1.nd.0 EN VDD VDD pfet_03v3 ad=0.78p pd=3.52u as=0.78p ps=3.52u w=3u l=0.28u
X726 lvds_lane_1.sa.0 lvds_lane_1.oa.0 lvds_lane_1.d2a.0 VSS nfet_03v3 ad=1.0036p pd=4.38u as=1.0036p ps=4.38u w=3.86u l=0.5u
X727 lvds_lane_1.tp.0 lvds_lane_1.gp.0 lvds_lane_1.fa.0 lvds_lane_1.tp.0 pfet_03v3 ad=1.248p pd=5.32u as=1.248p ps=5.32u w=4.8u l=0.4u
X728 VSS lvds_lane_0.VBN.0 lvds_lane_0.VBN.0 VSS nfet_03v3 ad=0.65p pd=3.02u as=0.65p ps=3.02u w=2.5u l=1u
X729 lvds_lane_0.i1.0 VSS VSS VSS nfet_03v3 ad=0.39p pd=2.02u as=0.66p ps=3.88u w=1.5u l=0.28u
X730 VDD lvds_lane_1.d2b.0 lvds_lane_1.d2a.0 VDD pfet_03v3 ad=0.52p pd=2.52u as=0.52p ps=2.52u w=2u l=0.4u
X731 VSS lvds_lane_0.VBN.0 lvds_lane_1.tn.0 VSS nfet_03v3 ad=0.65p pd=3.02u as=0.65p ps=3.02u w=2.5u l=1u
X732 lvds_lane_0.VBP.0 lvds_lane_0.VBN.0 VSS VSS nfet_03v3 ad=0.65p pd=3.02u as=0.65p ps=3.02u w=2.5u l=1u
X733 VDD lvds_lane_0.VBP.0 lvds_lane_1.tp.0 VDD pfet_03v3 ad=1.3p pd=5.52u as=1.3p ps=5.52u w=5u l=1u
X734 lvds_lane_2.fb.0 lvds_lane_0.VREF.0 lvds_lane_2.tp.0 lvds_lane_2.tp.0 pfet_03v3 ad=1.248p pd=5.32u as=1.248p ps=5.32u w=4.8u l=0.4u
X735 VSS VSS VSS ppolyf_u_1k r_width=2u r_length=9.11u
X736 lvds_lane_2.tn.0 lvds_lane_2.gp.0 lvds_lane_2.oa.0 VSS nfet_03v3 ad=1.235p pd=5.27u as=1.235p ps=5.27u w=4.75u l=0.5u
X737 VDD lvds_lane_0.VBP.0 lvds_lane_2.tp.0 VDD pfet_03v3 ad=1.3p pd=5.52u as=1.3p ps=5.52u w=5u l=1u
X738 lvds_lane_1.fa.0 lvds_lane_0.VBN.0 VSS VSS nfet_03v3 ad=0.65p pd=3.02u as=0.65p ps=3.02u w=2.5u l=1u
X739 lvds_lane_0.ob.0 lvds_lane_0.gn.0 lvds_lane_0.tn.0 VSS nfet_03v3 ad=1.235p pd=5.27u as=1.235p ps=5.27u w=4.75u l=0.5u
X740 lvds_lane_0.fb.0 lvds_lane_0.gn.0 lvds_lane_0.tp.0 lvds_lane_0.tp.0 pfet_03v3 ad=1.248p pd=5.32u as=1.248p ps=5.32u w=4.8u l=0.4u
X741 VSS VSS VSS VSS nfet_03v3 ad=0.52p pd=2.52u as=0 ps=0 w=2u l=0.28u
X742 lvds_lane_2.tn.0 lvds_lane_2.gn.0 lvds_lane_2.ob.0 VSS nfet_03v3 ad=1.235p pd=5.27u as=1.235p ps=5.27u w=4.75u l=0.5u
X743 lvds_lane_1.tp.0 lvds_lane_0.VBP.0 VDD VDD pfet_03v3 ad=1.3p pd=5.52u as=1.3p ps=5.52u w=5u l=1u
X744 lvds_lane_1.fa.0 lvds_lane_0.VB2.0 lvds_lane_1.oa.0 VSS nfet_03v3 ad=1.1752p pd=5.04u as=1.1752p ps=5.04u w=4.52u l=0.5u
X745 VSS VSS VSS ppolyf_u_1k r_width=2u r_length=8.86u
X746 lvds_lane_0.fa.0 lvds_lane_0.gp.0 lvds_lane_0.tp.0 lvds_lane_0.tp.0 pfet_03v3 ad=1.248p pd=5.32u as=1.248p ps=5.32u w=4.8u l=0.4u
X747 lvds_lane_1.tp.0 lvds_lane_0.VREF.0 lvds_lane_1.fa.0 lvds_lane_1.tp.0 pfet_03v3 ad=1.248p pd=5.32u as=1.248p ps=5.32u w=4.8u l=0.4u
X748 lvds_lane_2.tp.0 lvds_lane_0.VREF.0 lvds_lane_2.fa.0 lvds_lane_2.tp.0 pfet_03v3 ad=1.248p pd=5.32u as=1.248p ps=5.32u w=4.8u l=0.4u
D8 VSS lvds_lane_1.gp.0 diode_nd2ps_03v3 pj=26u area=40p
X749 lvds_lane_0.oa.0 lvds_lane_0.gp.0 lvds_lane_0.tn.0 VSS nfet_03v3 ad=1.235p pd=5.27u as=1.235p ps=5.27u w=4.75u l=0.5u
X750 lvds_lane_1.tn.0 lvds_lane_0.VBN.0 VSS VSS nfet_03v3 ad=0.65p pd=3.02u as=0.65p ps=3.02u w=2.5u l=1u
X751 VDD lvds_bias_0.enb.0 lvds_bias_0.nrb.0 VDD pfet_03v3 ad=1.3p pd=5.52u as=1.3p ps=5.52u w=5u l=0.5u
X752 lvds_lane_0.tp.0 lvds_lane_0.gn.0 lvds_lane_0.fb.0 lvds_lane_0.tp.0 pfet_03v3 ad=1.248p pd=5.32u as=1.248p ps=5.32u w=4.8u l=0.4u
X753 lvds_lane_2.fb.0 lvds_lane_2.gn.0 lvds_lane_2.tp.0 lvds_lane_2.tp.0 pfet_03v3 ad=1.248p pd=5.32u as=1.248p ps=5.32u w=4.8u l=0.4u
X754 lvds_lane_1.fa.0 lvds_lane_0.VB2.0 lvds_lane_1.oa.0 VSS nfet_03v3 ad=1.1752p pd=5.04u as=1.1752p ps=5.04u w=4.52u l=0.5u
X755 lvds_lane_2.tn.0 VSS VSS VSS nfet_03v3 ad=0.65p pd=3.02u as=1.1p ps=5.88u w=2.5u l=1u
X756 lvds_lane_2.tp.0 lvds_lane_0.VREF.0 lvds_lane_2.fa.0 lvds_lane_2.tp.0 pfet_03v3 ad=1.248p pd=5.32u as=1.248p ps=5.32u w=4.8u l=0.4u
X757 lvds_lane_2.oa.0 lvds_lane_0.VREF.0 lvds_lane_2.tn.0 VSS nfet_03v3 ad=1.235p pd=5.27u as=1.235p ps=5.27u w=4.75u l=0.5u
X758 lvds_lane_2.n3a.0 lvds_lane_2.d2a.0 VDD VDD pfet_03v3 ad=0.52p pd=2.52u as=0.52p ps=2.52u w=2u l=0.4u
X759 lvds_lane_1.n3a.0 lvds_lane_1.d2a.0 VDD VDD pfet_03v3 ad=0.52p pd=2.52u as=0.52p ps=2.52u w=2u l=0.4u
X760 lvds_lane_0.tn.0 lvds_lane_0.VREF.0 lvds_lane_0.ob.0 VSS nfet_03v3 ad=1.235p pd=5.27u as=1.235p ps=5.27u w=4.75u l=0.5u
X761 lvds_lane_1.d2a.0 lvds_lane_1.d2b.0 VDD VDD pfet_03v3 ad=0.52p pd=2.52u as=0.52p ps=2.52u w=2u l=0.4u
X762 VDD lvds_lane_1.rla_m1.0 VSS ppolyf_u_1k r_width=2u r_length=9.11u
X763 lvds_lane_0.gp.0 RX0_P VDD ppolyf_u r_width=5u r_length=1.8u
X764 VDD VDD RX0_O VDD pfet_03v3 ad=2.2p pd=10.88u as=1.3p ps=5.52u w=5u l=0.28u
X765 VDD lvds_lane_0.VBP.0 lvds_lane_0.tp.0 VDD pfet_03v3 ad=1.3p pd=5.52u as=1.3p ps=5.52u w=5u l=1u
X766 lvds_lane_1.tn.0 lvds_lane_1.gp.0 lvds_lane_1.oa.0 VSS nfet_03v3 ad=1.235p pd=5.27u as=1.235p ps=5.27u w=4.75u l=0.5u
X767 lvds_lane_2.ob.0 lvds_lane_0.VREF.0 lvds_lane_2.tn.0 VSS nfet_03v3 ad=1.235p pd=5.27u as=1.235p ps=5.27u w=4.75u l=0.5u
X768 lvds_lane_1.tp.0 lvds_lane_0.VREF.0 lvds_lane_1.fb.0 lvds_lane_1.tp.0 pfet_03v3 ad=1.248p pd=5.32u as=2.112p ps=10.48u w=4.8u l=0.4u
X769 lvds_lane_0.nd.0 VSS VSS VSS nfet_03v3 ad=0.52p pd=2.52u as=0.88p ps=4.88u w=2u l=0.28u
X770 VDD lvds_lane_1.d2a.0 lvds_lane_1.d2b.0 VDD pfet_03v3 ad=0.52p pd=2.52u as=0.52p ps=2.52u w=2u l=0.4u
X771 lvds_lane_1.fa.0 lvds_lane_1.gp.0 lvds_lane_1.tp.0 lvds_lane_1.tp.0 pfet_03v3 ad=1.248p pd=5.32u as=1.248p ps=5.32u w=4.8u l=0.4u
X772 lvds_lane_0.VB2.0 lvds_lane_0.VBP.0 VDD VDD pfet_03v3 ad=1.3p pd=5.52u as=1.3p ps=5.52u w=5u l=1u
X773 lvds_lane_2.fa.0 lvds_lane_0.VREF.0 lvds_lane_2.tp.0 lvds_lane_2.tp.0 pfet_03v3 ad=1.248p pd=5.32u as=1.248p ps=5.32u w=4.8u l=0.4u
X774 lvds_lane_1.tn.0 lvds_lane_1.gn.0 lvds_lane_1.ob.0 VSS nfet_03v3 ad=1.235p pd=5.27u as=1.235p ps=5.27u w=4.75u l=0.5u
X775 lvds_lane_2.oa.0 lvds_lane_0.VREF.0 lvds_lane_2.tn.0 VSS nfet_03v3 ad=1.235p pd=5.27u as=1.235p ps=5.27u w=4.75u l=0.5u
X776 lvds_lane_0.fa.0 lvds_lane_0.VBN.0 VSS VSS nfet_03v3 ad=0.65p pd=3.02u as=0.65p ps=3.02u w=2.5u l=1u
X777 lvds_lane_2.tp.0 lvds_lane_0.VBP.0 VDD VDD pfet_03v3 ad=1.3p pd=5.52u as=1.3p ps=5.52u w=5u l=1u
X778 lvds_lane_2.fa.0 lvds_lane_2.gp.0 lvds_lane_2.tp.0 lvds_lane_2.tp.0 pfet_03v3 ad=1.248p pd=5.32u as=1.248p ps=5.32u w=4.8u l=0.4u
X779 lvds_lane_1.d2a.0 VSS VSS VSS nfet_03v3 ad=1.0036p pd=4.38u as=1.6984p ps=8.6u w=3.86u l=0.5u
X780 lvds_lane_0.tp.0 lvds_lane_0.VBP.0 VDD VDD pfet_03v3 ad=1.3p pd=5.52u as=1.3p ps=5.52u w=5u l=1u
X781 lvds_lane_0.fb.0 lvds_lane_0.VBN.0 VSS VSS nfet_03v3 ad=0.65p pd=3.02u as=0.65p ps=3.02u w=2.5u l=1u
X782 lvds_lane_1.fb.0 lvds_lane_0.VBN.0 VSS VSS nfet_03v3 ad=0.65p pd=3.02u as=0.65p ps=3.02u w=2.5u l=1u
X783 VDD VDD RX2_O VDD pfet_03v3 ad=2.2p pd=10.88u as=1.3p ps=5.52u w=5u l=0.28u
X784 lvds_lane_1.ts.0 lvds_lane_1.sb.0 VSS ppolyf_u_1k r_width=2u r_length=8.86u
X785 VSS lvds_lane_0.nd.0 lvds_lane_0.i1.0 VSS nfet_03v3 ad=0.39p pd=2.02u as=0.39p ps=2.02u w=1.5u l=0.28u
X786 VSS EN lvds_lane_0.nm.0 VSS nfet_03v3 ad=0.52p pd=2.52u as=0.52p ps=2.52u w=2u l=0.28u
X787 lvds_lane_1.tn.0 lvds_lane_0.VREF.0 lvds_lane_1.ob.0 VSS nfet_03v3 ad=1.235p pd=5.27u as=1.235p ps=5.27u w=4.75u l=0.5u
X788 lvds_lane_1.tp.0 lvds_lane_0.VBP.0 VDD VDD pfet_03v3 ad=1.3p pd=5.52u as=1.3p ps=5.52u w=5u l=1u
X789 lvds_lane_1.tp.0 lvds_lane_0.VREF.0 lvds_lane_1.fb.0 lvds_lane_1.tp.0 pfet_03v3 ad=1.248p pd=5.32u as=1.248p ps=5.32u w=4.8u l=0.4u
X790 lvds_lane_0.i1.0 VDD VDD VDD pfet_03v3 ad=0.962p pd=4.22u as=1.628p ps=8.28u w=3.7u l=0.28u
X791 lvds_lane_0.tp.0 lvds_lane_0.gp.0 lvds_lane_0.fa.0 lvds_lane_0.tp.0 pfet_03v3 ad=1.248p pd=5.32u as=1.248p ps=5.32u w=4.8u l=0.4u
X792 lvds_lane_0.fb.0 lvds_lane_0.VREF.0 lvds_lane_0.tp.0 lvds_lane_0.tp.0 pfet_03v3 ad=1.248p pd=5.32u as=1.248p ps=5.32u w=4.8u l=0.4u
X793 lvds_lane_1.fb.0 lvds_lane_0.VREF.0 lvds_lane_1.tp.0 lvds_lane_1.tp.0 pfet_03v3 ad=1.248p pd=5.32u as=1.248p ps=5.32u w=4.8u l=0.4u
X794 lvds_lane_2.fa.0 lvds_lane_2.gp.0 lvds_lane_2.tp.0 lvds_lane_2.tp.0 pfet_03v3 ad=1.248p pd=5.32u as=1.248p ps=5.32u w=4.8u l=0.4u
X795 VSS lvds_lane_0.VBN.0 lvds_lane_2.tn.0 VSS nfet_03v3 ad=0.65p pd=3.02u as=0.65p ps=3.02u w=2.5u l=1u
X796 lvds_lane_1.tp.0 lvds_lane_0.VREF.0 lvds_lane_1.fb.0 lvds_lane_1.tp.0 pfet_03v3 ad=1.248p pd=5.32u as=1.248p ps=5.32u w=4.8u l=0.4u
X797 lvds_lane_2.tp.0 lvds_lane_2.gn.0 lvds_lane_2.fb.0 lvds_lane_2.tp.0 pfet_03v3 ad=1.248p pd=5.32u as=1.248p ps=5.32u w=4.8u l=0.4u
X798 lvds_lane_2.ob.0 lvds_lane_0.VREF.0 lvds_lane_2.tn.0 VSS nfet_03v3 ad=2.09p pd=10.38u as=1.235p ps=5.27u w=4.75u l=0.5u
X799 VDD lvds_lane_0.VBP.0 lvds_lane_2.tp.0 VDD pfet_03v3 ad=1.3p pd=5.52u as=1.3p ps=5.52u w=5u l=1u
X800 lvds_lane_1.oa.0 lvds_lane_1.gp.0 lvds_lane_1.tn.0 VSS nfet_03v3 ad=1.235p pd=5.27u as=1.235p ps=5.27u w=4.75u l=0.5u
X801 lvds_lane_2.fb.0 lvds_lane_2.gn.0 lvds_lane_2.tp.0 lvds_lane_2.tp.0 pfet_03v3 ad=1.248p pd=5.32u as=1.248p ps=5.32u w=4.8u l=0.4u
X802 VSS VSS lvds_lane_2.fb.0 VSS nfet_03v3 ad=1.9888p pd=9.92u as=1.1752p ps=5.04u w=4.52u l=0.5u
X803 VDD lvds_lane_1.d2a.0 lvds_lane_1.d2a.0 VDD pfet_03v3 ad=0.52p pd=2.52u as=0.52p ps=2.52u w=2u l=0.4u
X804 VDD lvds_lane_1.d2a.0 lvds_lane_1.n3a.0 VDD pfet_03v3 ad=0.52p pd=2.52u as=0.52p ps=2.52u w=2u l=0.4u
X805 VDD lvds_lane_0.d2b.0 lvds_lane_0.d2a.0 VDD pfet_03v3 ad=0.52p pd=2.52u as=0.52p ps=2.52u w=2u l=0.4u
X806 VSS VSS lvds_lane_2.sa.0 VSS nfet_03v3 ad=1.6984p pd=8.6u as=1.0036p ps=4.38u w=3.86u l=0.5u
X807 lvds_lane_0.fa.0 lvds_lane_0.VB2.0 lvds_lane_0.oa.0 VSS nfet_03v3 ad=1.1752p pd=5.04u as=1.1752p ps=5.04u w=4.52u l=0.5u
X808 VSS lvds_lane_0.VBN.0 lvds_lane_0.fb.0 VSS nfet_03v3 ad=0.65p pd=3.02u as=0.65p ps=3.02u w=2.5u l=1u
X809 RX0_O lvds_lane_0.i2.0 VDD VDD pfet_03v3 ad=1.3p pd=5.52u as=1.3p ps=5.52u w=5u l=0.28u
X810 VDD VDD VDD VDD pfet_03v3 ad=0.52p pd=2.52u as=0 ps=0 w=2u l=0.5u
X811 lvds_lane_0.d2b.0 VSS VSS VSS nfet_03v3 ad=1.0036p pd=4.38u as=1.6984p ps=8.6u w=3.86u l=0.5u
X812 lvds_lane_0.tp.0 lvds_lane_0.VREF.0 lvds_lane_0.fa.0 lvds_lane_0.tp.0 pfet_03v3 ad=1.248p pd=5.32u as=1.248p ps=5.32u w=4.8u l=0.4u
X813 lvds_lane_2.ts.0 lvds_lane_0.VBN.0 VSS VSS nfet_03v3 ad=0.65p pd=3.02u as=0.65p ps=3.02u w=2.5u l=1u
X814 lvds_lane_0.fa.0 lvds_lane_0.VB2.0 lvds_lane_0.oa.0 VSS nfet_03v3 ad=1.1752p pd=5.04u as=1.1752p ps=5.04u w=4.52u l=0.5u
X815 lvds_lane_2.tp.0 lvds_lane_2.gn.0 lvds_lane_2.fb.0 lvds_lane_2.tp.0 pfet_03v3 ad=1.248p pd=5.32u as=1.248p ps=5.32u w=4.8u l=0.4u
X816 lvds_lane_0.d2a.0 lvds_lane_0.d2b.0 VDD VDD pfet_03v3 ad=0.52p pd=2.52u as=0.52p ps=2.52u w=2u l=0.4u
X817 VDD lvds_lane_0.rlb_m1.0 VSS ppolyf_u_1k r_width=2u r_length=9.11u
X818 lvds_lane_2.fb.0 lvds_lane_2.gn.0 lvds_lane_2.tp.0 lvds_lane_2.tp.0 pfet_03v3 ad=1.248p pd=5.32u as=1.248p ps=5.32u w=4.8u l=0.4u
X819 lvds_lane_0.tn.0 lvds_lane_0.VREF.0 lvds_lane_0.oa.0 VSS nfet_03v3 ad=1.235p pd=5.27u as=1.235p ps=5.27u w=4.75u l=0.5u
X820 VSS lvds_lane_0.VBN.0 lvds_lane_1.fb.0 VSS nfet_03v3 ad=0.65p pd=3.02u as=0.65p ps=3.02u w=2.5u l=1u
X821 lvds_lane_0.fa.0 VSS VSS VSS nfet_03v3 ad=0.65p pd=3.02u as=1.1p ps=5.88u w=2.5u l=1u
X822 RX2_O lvds_lane_2.i2.0 VDD VDD pfet_03v3 ad=1.3p pd=5.52u as=1.3p ps=5.52u w=5u l=0.28u
X823 lvds_lane_0.fb.0 lvds_lane_0.VB2.0 lvds_lane_0.ob.0 VSS nfet_03v3 ad=1.1752p pd=5.04u as=1.1752p ps=5.04u w=4.52u l=0.5u
X824 VDD lvds_lane_0.VBP.0 lvds_lane_1.tp.0 VDD pfet_03v3 ad=1.3p pd=5.52u as=1.3p ps=5.52u w=5u l=1u
X825 VSS VSS lvds_lane_1.sb.0 VSS nfet_03v3 ad=1.6984p pd=8.6u as=1.0036p ps=4.38u w=3.86u l=0.5u
X826 lvds_lane_1.tp.0 lvds_lane_1.gp.0 lvds_lane_1.fa.0 lvds_lane_1.tp.0 pfet_03v3 ad=1.248p pd=5.32u as=1.248p ps=5.32u w=4.8u l=0.4u
X827 lvds_lane_0.VBP.0 lvds_lane_0.VBN.0 VSS VSS nfet_03v3 ad=0.65p pd=3.02u as=0.65p ps=3.02u w=2.5u l=1u
X828 lvds_lane_0.tp.0 lvds_lane_0.VREF.0 lvds_lane_0.fa.0 lvds_lane_0.tp.0 pfet_03v3 ad=1.248p pd=5.32u as=1.248p ps=5.32u w=4.8u l=0.4u
X829 lvds_lane_0.tp.0 lvds_lane_0.VREF.0 lvds_lane_0.fb.0 lvds_lane_0.tp.0 pfet_03v3 ad=1.248p pd=5.32u as=1.248p ps=5.32u w=4.8u l=0.4u
X830 lvds_lane_2.fa.0 lvds_lane_2.gp.0 lvds_lane_2.tp.0 lvds_lane_2.tp.0 pfet_03v3 ad=1.248p pd=5.32u as=1.248p ps=5.32u w=4.8u l=0.4u
X831 lvds_bias_0.rb_m3.0 lvds_lane_0.VBN.0 VSS ppolyf_u_1k r_width=2u r_length=22.27u
X832 VDD lvds_lane_1.d2b.0 lvds_lane_1.d3.0 VDD pfet_03v3 ad=0.52p pd=2.52u as=0.52p ps=2.52u w=2u l=0.4u
X833 VDD lvds_lane_0.d2b.0 lvds_lane_0.d3.0 VDD pfet_03v3 ad=0.52p pd=2.52u as=0.52p ps=2.52u w=2u l=0.4u
X834 lvds_lane_0.tn.0 lvds_lane_0.gn.0 lvds_lane_0.ob.0 VSS nfet_03v3 ad=1.235p pd=5.27u as=1.235p ps=5.27u w=4.75u l=0.5u
X835 VDD lvds_lane_1.d2b.0 lvds_lane_1.d2a.0 VDD pfet_03v3 ad=0.52p pd=2.52u as=0.52p ps=2.52u w=2u l=0.4u
X836 VDD lvds_lane_0.d2b.0 lvds_lane_0.d2b.0 VDD pfet_03v3 ad=0.52p pd=2.52u as=0.52p ps=2.52u w=2u l=0.4u
X837 lvds_lane_1.fb.0 lvds_lane_1.gn.0 lvds_lane_1.tp.0 lvds_lane_1.tp.0 pfet_03v3 ad=1.248p pd=5.32u as=1.248p ps=5.32u w=4.8u l=0.4u
X838 lvds_lane_0.fa.0 lvds_lane_0.VBN.0 VSS VSS nfet_03v3 ad=0.65p pd=3.02u as=0.65p ps=3.02u w=2.5u l=1u
X839 VDD VDD VDD VDD pfet_03v3 ad=0.962p pd=4.22u as=0 ps=0 w=3.7u l=0.28u
X840 lvds_lane_0.tp.0 lvds_lane_0.VBP.0 VDD VDD pfet_03v3 ad=1.3p pd=5.52u as=1.3p ps=5.52u w=5u l=1u
X841 lvds_lane_0.tn.0 lvds_lane_0.VREF.0 lvds_lane_0.oa.0 VSS nfet_03v3 ad=1.235p pd=5.27u as=1.235p ps=5.27u w=4.75u l=0.5u
X842 lvds_lane_0.d2b.0 lvds_lane_0.d2a.0 VDD VDD pfet_03v3 ad=0.52p pd=2.52u as=0.52p ps=2.52u w=2u l=0.4u
X843 lvds_lane_0.tp.0 lvds_lane_0.gn.0 lvds_lane_0.fb.0 lvds_lane_0.tp.0 pfet_03v3 ad=1.248p pd=5.32u as=1.248p ps=5.32u w=4.8u l=0.4u
X844 lvds_lane_1.tp.0 lvds_lane_1.gn.0 lvds_lane_1.fb.0 lvds_lane_1.tp.0 pfet_03v3 ad=1.248p pd=5.32u as=1.248p ps=5.32u w=4.8u l=0.4u
X845 lvds_lane_2.tn.0 lvds_lane_2.gn.0 lvds_lane_2.ob.0 VSS nfet_03v3 ad=1.235p pd=5.27u as=1.235p ps=5.27u w=4.75u l=0.5u
X846 lvds_lane_0.n3a.0 VSS VSS VSS nfet_03v3 ad=0.6734p pd=3.11u as=1.1396p ps=6.06u w=2.59u l=0.28u
X847 lvds_lane_1.fb.0 lvds_lane_0.VREF.0 lvds_lane_1.tp.0 lvds_lane_1.tp.0 pfet_03v3 ad=1.248p pd=5.32u as=1.248p ps=5.32u w=4.8u l=0.4u
X848 lvds_lane_2.tp.0 lvds_lane_2.gn.0 lvds_lane_2.fb.0 lvds_lane_2.tp.0 pfet_03v3 ad=1.248p pd=5.32u as=1.248p ps=5.32u w=4.8u l=0.4u
X849 VSS lvds_lane_0.VBN.0 lvds_lane_0.fa.0 VSS nfet_03v3 ad=0.65p pd=3.02u as=0.65p ps=3.02u w=2.5u l=1u
X850 VDD lvds_lane_0.i1.0 lvds_lane_0.i2.0 VDD pfet_03v3 ad=0.975p pd=4.27u as=0.975p ps=4.27u w=3.75u l=0.28u
X851 lvds_lane_2.tn.0 lvds_lane_2.gp.0 lvds_lane_2.oa.0 VSS nfet_03v3 ad=1.235p pd=5.27u as=1.235p ps=5.27u w=4.75u l=0.5u
X852 VSS lvds_lane_0.VBN.0 lvds_lane_1.fb.0 VSS nfet_03v3 ad=0.65p pd=3.02u as=0.65p ps=3.02u w=2.5u l=1u
X853 VSS lvds_lane_0.VBN.0 lvds_lane_0.tn.0 VSS nfet_03v3 ad=0.65p pd=3.02u as=0.65p ps=3.02u w=2.5u l=1u
X854 lvds_lane_2.ts.0 lvds_lane_0.VBN.0 VSS VSS nfet_03v3 ad=0.65p pd=3.02u as=0.65p ps=3.02u w=2.5u l=1u
D9 lvds_lane_2.gn.0 VDD diode_pd2nw_03v3 pj=26u area=40p
X855 lvds_lane_0.ob.0 lvds_lane_0.gn.0 lvds_lane_0.tn.0 VSS nfet_03v3 ad=1.235p pd=5.27u as=1.235p ps=5.27u w=4.75u l=0.5u
X856 lvds_lane_2.fb.0 lvds_lane_0.VREF.0 lvds_lane_2.tp.0 lvds_lane_2.tp.0 pfet_03v3 ad=2.112p pd=10.48u as=1.248p ps=5.32u w=4.8u l=0.4u
X857 lvds_lane_0.ts.0 VSS VSS VSS nfet_03v3 ad=0.65p pd=3.02u as=1.1p ps=5.88u w=2.5u l=1u
X858 lvds_lane_2.fb.0 lvds_lane_2.gn.0 lvds_lane_2.tp.0 lvds_lane_2.tp.0 pfet_03v3 ad=1.248p pd=5.32u as=1.248p ps=5.32u w=4.8u l=0.4u
X859 lvds_lane_0.ob.0 lvds_lane_0.gn.0 lvds_lane_0.tn.0 VSS nfet_03v3 ad=1.235p pd=5.27u as=1.235p ps=5.27u w=4.75u l=0.5u
X860 VDD lvds_bias_0.enb.0 lvds_bias_0.nrb.0 VDD pfet_03v3 ad=1.3p pd=5.52u as=1.3p ps=5.52u w=5u l=0.5u
X861 VDD VDD lvds_bias_0.nrb.0 VDD pfet_03v3 ad=2.2p pd=10.88u as=1.3p ps=5.52u w=5u l=0.5u
X862 lvds_lane_1.tp.0 lvds_lane_1.gp.0 lvds_lane_1.fa.0 lvds_lane_1.tp.0 pfet_03v3 ad=1.248p pd=5.32u as=1.248p ps=5.32u w=4.8u l=0.4u
X863 lvds_lane_1.oa.0 lvds_lane_0.VREF.0 lvds_lane_1.tn.0 VSS nfet_03v3 ad=1.235p pd=5.27u as=1.235p ps=5.27u w=4.75u l=0.5u
X864 lvds_lane_0.fb.0 lvds_lane_0.VBN.0 VSS VSS nfet_03v3 ad=0.65p pd=3.02u as=0.65p ps=3.02u w=2.5u l=1u
X865 lvds_lane_0.oa.0 lvds_lane_0.gp.0 lvds_lane_0.tn.0 VSS nfet_03v3 ad=1.235p pd=5.27u as=1.235p ps=5.27u w=4.75u l=0.5u
X866 lvds_lane_2.sb.0 lvds_lane_2.ob.0 lvds_lane_2.d2b.0 VSS nfet_03v3 ad=1.0036p pd=4.38u as=1.0036p ps=4.38u w=3.86u l=0.5u
X867 VSS lvds_lane_0.VBN.0 lvds_lane_2.fb.0 VSS nfet_03v3 ad=0.65p pd=3.02u as=0.65p ps=3.02u w=2.5u l=1u
X868 VDD lvds_bias_0.enb.0 lvds_bias_0.nrb.0 VDD pfet_03v3 ad=1.3p pd=5.52u as=1.3p ps=5.52u w=5u l=0.5u
X869 VDD lvds_lane_2.d2a.0 lvds_lane_2.d2a.0 VDD pfet_03v3 ad=0.52p pd=2.52u as=0.52p ps=2.52u w=2u l=0.4u
X870 lvds_lane_0.d2a.0 lvds_lane_0.d2a.0 VDD VDD pfet_03v3 ad=0.52p pd=2.52u as=0.52p ps=2.52u w=2u l=0.4u
X871 lvds_lane_2.fb.0 lvds_lane_2.gn.0 lvds_lane_2.tp.0 lvds_lane_2.tp.0 pfet_03v3 ad=1.248p pd=5.32u as=1.248p ps=5.32u w=4.8u l=0.4u
X872 lvds_lane_0.tn.0 lvds_lane_0.VBN.0 VSS VSS nfet_03v3 ad=0.65p pd=3.02u as=0.65p ps=3.02u w=2.5u l=1u
X873 lvds_lane_2.d2a.0 VDD VDD VDD pfet_03v3 ad=0.52p pd=2.52u as=0.88p ps=4.88u w=2u l=0.4u
X874 lvds_lane_2.d3.0 lvds_lane_2.d2b.0 VDD VDD pfet_03v3 ad=0.52p pd=2.52u as=0.52p ps=2.52u w=2u l=0.4u
X875 lvds_lane_0.tp.0 VDD VDD VDD pfet_03v3 ad=1.3p pd=5.52u as=2.2p ps=10.88u w=5u l=1u
X876 lvds_lane_1.ob.0 lvds_lane_0.VB2.0 lvds_lane_1.fb.0 VSS nfet_03v3 ad=1.1752p pd=5.04u as=1.1752p ps=5.04u w=4.52u l=0.5u
X877 VSS VSS lvds_lane_0.d3.0 VSS nfet_03v3 ad=1.1396p pd=6.06u as=0.6734p ps=3.11u w=2.59u l=0.28u
X878 VSS lvds_lane_0.VBN.0 lvds_lane_2.ts.0 VSS nfet_03v3 ad=0.65p pd=3.02u as=0.65p ps=3.02u w=2.5u l=1u
D10 VSS lvds_lane_2.gn.0 diode_nd2ps_03v3 pj=26u area=40p
X879 lvds_lane_0.tp.0 lvds_lane_0.gp.0 lvds_lane_0.fa.0 lvds_lane_0.tp.0 pfet_03v3 ad=1.248p pd=5.32u as=1.248p ps=5.32u w=4.8u l=0.4u
X880 lvds_lane_1.ob.0 lvds_lane_0.VREF.0 lvds_lane_1.tn.0 VSS nfet_03v3 ad=1.235p pd=5.27u as=1.235p ps=5.27u w=4.75u l=0.5u
X881 lvds_lane_0.VBN.0 VSS VSS VSS nfet_03v3 ad=0.65p pd=3.02u as=1.1p ps=5.88u w=2.5u l=1u
X882 VSS lvds_lane_1.n3a.0 lvds_lane_1.n3a.0 VSS nfet_03v3 ad=0.6734p pd=3.11u as=0.6734p ps=3.11u w=2.59u l=0.28u
X883 VDD lvds_lane_0.VBP.0 lvds_lane_0.VBP.0 VDD pfet_03v3 ad=1.3p pd=5.52u as=1.3p ps=5.52u w=5u l=1u
X884 lvds_lane_2.nm.0 lvds_lane_2.d3.0 lvds_lane_2.nd.0 VSS nfet_03v3 ad=0.52p pd=2.52u as=0.52p ps=2.52u w=2u l=0.28u
X885 lvds_lane_2.i2.0 VDD VDD VDD pfet_03v3 ad=0.975p pd=4.27u as=1.65p ps=8.38u w=3.75u l=0.28u
X886 lvds_lane_0.fa.0 lvds_lane_0.gp.0 lvds_lane_0.tp.0 lvds_lane_0.tp.0 pfet_03v3 ad=1.248p pd=5.32u as=1.248p ps=5.32u w=4.8u l=0.4u
X887 lvds_lane_1.fa.0 lvds_lane_0.VREF.0 lvds_lane_1.tp.0 lvds_lane_1.tp.0 pfet_03v3 ad=1.248p pd=5.32u as=1.248p ps=5.32u w=4.8u l=0.4u
X888 lvds_lane_1.tn.0 lvds_lane_1.gp.0 lvds_lane_1.oa.0 VSS nfet_03v3 ad=1.235p pd=5.27u as=1.235p ps=5.27u w=4.75u l=0.5u
X889 lvds_bias_0.rdt_m2.0 lvds_bias_0.rdt_m3.0 VSS ppolyf_u_1k r_width=2u r_length=21.01u
X890 lvds_lane_1.fa.0 lvds_lane_0.VBN.0 VSS VSS nfet_03v3 ad=0.65p pd=3.02u as=0.65p ps=3.02u w=2.5u l=1u
X891 lvds_lane_0.tp.0 lvds_lane_0.VREF.0 lvds_lane_0.fb.0 lvds_lane_0.tp.0 pfet_03v3 ad=1.248p pd=5.32u as=1.248p ps=5.32u w=4.8u l=0.4u
X892 lvds_lane_2.fb.0 lvds_lane_0.VREF.0 lvds_lane_2.tp.0 lvds_lane_2.tp.0 pfet_03v3 ad=1.248p pd=5.32u as=1.248p ps=5.32u w=4.8u l=0.4u
X893 VSS VSS VSS ppolyf_u_1k r_width=2u r_length=9.11u
X894 lvds_lane_1.fa.0 lvds_lane_0.VREF.0 lvds_lane_1.tp.0 lvds_lane_1.tp.0 pfet_03v3 ad=1.248p pd=5.32u as=1.248p ps=5.32u w=4.8u l=0.4u
X895 lvds_lane_1.tn.0 lvds_lane_0.VBN.0 VSS VSS nfet_03v3 ad=0.65p pd=3.02u as=0.65p ps=3.02u w=2.5u l=1u
X896 lvds_lane_2.fa.0 lvds_lane_0.VREF.0 lvds_lane_2.tp.0 lvds_lane_2.tp.0 pfet_03v3 ad=1.248p pd=5.32u as=1.248p ps=5.32u w=4.8u l=0.4u
X897 VSS lvds_lane_0.VBN.0 lvds_lane_0.ts.0 VSS nfet_03v3 ad=0.65p pd=3.02u as=0.65p ps=3.02u w=2.5u l=1u
X898 lvds_lane_1.d3.0 lvds_lane_1.d2b.0 VDD VDD pfet_03v3 ad=0.52p pd=2.52u as=0.52p ps=2.52u w=2u l=0.4u
X899 lvds_lane_0.fa.0 lvds_lane_0.gp.0 lvds_lane_0.tp.0 lvds_lane_0.tp.0 pfet_03v3 ad=1.248p pd=5.32u as=1.248p ps=5.32u w=4.8u l=0.4u
X900 lvds_lane_2.tp.0 lvds_lane_0.VREF.0 lvds_lane_2.fa.0 lvds_lane_2.tp.0 pfet_03v3 ad=1.248p pd=5.32u as=1.248p ps=5.32u w=4.8u l=0.4u
X901 VSS lvds_lane_0.VBN.0 lvds_lane_1.ts.0 VSS nfet_03v3 ad=0.65p pd=3.02u as=0.65p ps=3.02u w=2.5u l=1u
X902 lvds_lane_1.d2b.0 lvds_lane_1.d2b.0 VDD VDD pfet_03v3 ad=0.52p pd=2.52u as=0.52p ps=2.52u w=2u l=0.4u
X903 VDD VDD lvds_lane_1.i2.0 VDD pfet_03v3 ad=1.65p pd=8.38u as=0.975p ps=4.27u w=3.75u l=0.28u
X904 lvds_lane_0.fb.0 lvds_lane_0.VREF.0 lvds_lane_0.tp.0 lvds_lane_0.tp.0 pfet_03v3 ad=1.248p pd=5.32u as=1.248p ps=5.32u w=4.8u l=0.4u
X905 lvds_lane_1.tp.0 lvds_lane_1.gn.0 lvds_lane_1.fb.0 lvds_lane_1.tp.0 pfet_03v3 ad=1.248p pd=5.32u as=1.248p ps=5.32u w=4.8u l=0.4u
X906 lvds_lane_1.fa.0 lvds_lane_0.VREF.0 lvds_lane_1.tp.0 lvds_lane_1.tp.0 pfet_03v3 ad=1.248p pd=5.32u as=1.248p ps=5.32u w=4.8u l=0.4u
X907 lvds_lane_0.nd.0 EN VDD VDD pfet_03v3 ad=0.78p pd=3.52u as=0.78p ps=3.52u w=3u l=0.28u
X908 VSS VSS VSS ppolyf_u_1k r_width=2u r_length=8.86u
X909 lvds_lane_0.sa.0 lvds_lane_0.oa.0 lvds_lane_0.d2a.0 VSS nfet_03v3 ad=1.0036p pd=4.38u as=1.0036p ps=4.38u w=3.86u l=0.5u
X910 lvds_lane_0.tp.0 lvds_lane_0.gp.0 lvds_lane_0.fa.0 lvds_lane_0.tp.0 pfet_03v3 ad=1.248p pd=5.32u as=1.248p ps=5.32u w=4.8u l=0.4u
X911 lvds_lane_2.fa.0 lvds_lane_2.gp.0 lvds_lane_2.tp.0 lvds_lane_2.tp.0 pfet_03v3 ad=1.248p pd=5.32u as=1.248p ps=5.32u w=4.8u l=0.4u
X912 VSS lvds_lane_0.VBN.0 lvds_lane_0.tn.0 VSS nfet_03v3 ad=0.65p pd=3.02u as=0.65p ps=3.02u w=2.5u l=1u
X913 lvds_lane_0.VBN.0 lvds_lane_0.VBN.0 VSS VSS nfet_03v3 ad=0.65p pd=3.02u as=0.65p ps=3.02u w=2.5u l=1u
X914 VDD lvds_lane_0.d2b.0 lvds_lane_0.d2a.0 VDD pfet_03v3 ad=0.52p pd=2.52u as=0.52p ps=2.52u w=2u l=0.4u
X915 VDD lvds_lane_0.VBP.0 lvds_lane_0.tp.0 VDD pfet_03v3 ad=1.3p pd=5.52u as=1.3p ps=5.52u w=5u l=1u
X916 lvds_lane_1.tp.0 lvds_lane_0.VREF.0 lvds_lane_1.fb.0 lvds_lane_1.tp.0 pfet_03v3 ad=1.248p pd=5.32u as=1.248p ps=5.32u w=4.8u l=0.4u
X917 lvds_lane_2.tp.0 lvds_lane_2.gn.0 lvds_lane_2.fb.0 lvds_lane_2.tp.0 pfet_03v3 ad=1.248p pd=5.32u as=1.248p ps=5.32u w=4.8u l=0.4u
X918 VSS lvds_lane_0.VBN.0 lvds_lane_2.fa.0 VSS nfet_03v3 ad=0.65p pd=3.02u as=0.65p ps=3.02u w=2.5u l=1u
X919 lvds_lane_2.d2a.0 lvds_lane_2.oa.0 lvds_lane_2.sa.0 VSS nfet_03v3 ad=1.0036p pd=4.38u as=1.0036p ps=4.38u w=3.86u l=0.5u
X920 VSS VSS VSS ppolyf_u_1k r_width=2u r_length=9.11u
X921 lvds_lane_2.d2b.0 VDD VDD VDD pfet_03v3 ad=0.52p pd=2.52u as=0.88p ps=4.88u w=2u l=0.5u
X922 VDD lvds_lane_0.VBP.0 lvds_lane_1.tp.0 VDD pfet_03v3 ad=1.3p pd=5.52u as=1.3p ps=5.52u w=5u l=1u
X923 lvds_lane_0.fa.0 lvds_lane_0.VBN.0 VSS VSS nfet_03v3 ad=0.65p pd=3.02u as=0.65p ps=3.02u w=2.5u l=1u
X924 lvds_lane_0.VBP.0 lvds_lane_0.VBP.0 VDD VDD pfet_03v3 ad=1.3p pd=5.52u as=1.3p ps=5.52u w=5u l=1u
X925 lvds_lane_0.tp.0 lvds_lane_0.VBP.0 VDD VDD pfet_03v3 ad=1.3p pd=5.52u as=1.3p ps=5.52u w=5u l=1u
X926 lvds_lane_0.fa.0 lvds_lane_0.VB2.0 lvds_lane_0.oa.0 VSS nfet_03v3 ad=1.1752p pd=5.04u as=1.1752p ps=5.04u w=4.52u l=0.5u
X927 lvds_lane_0.tp.0 lvds_lane_0.VREF.0 lvds_lane_0.fa.0 lvds_lane_0.tp.0 pfet_03v3 ad=1.248p pd=5.32u as=1.248p ps=5.32u w=4.8u l=0.4u
X928 lvds_lane_1.tp.0 lvds_lane_0.VREF.0 lvds_lane_1.fa.0 lvds_lane_1.tp.0 pfet_03v3 ad=1.248p pd=5.32u as=1.248p ps=5.32u w=4.8u l=0.4u
D11 VSS lvds_lane_0.gp.0 diode_nd2ps_03v3 pj=26u area=40p
X929 lvds_lane_1.fb.0 lvds_lane_1.gn.0 lvds_lane_1.tp.0 lvds_lane_1.tp.0 pfet_03v3 ad=1.248p pd=5.32u as=1.248p ps=5.32u w=4.8u l=0.4u
X930 lvds_lane_0.tn.0 lvds_lane_0.VBN.0 VSS VSS nfet_03v3 ad=0.65p pd=3.02u as=0.65p ps=3.02u w=2.5u l=1u
X931 VDD VDD VDD VDD pfet_03v3 ad=0.52p pd=2.52u as=0 ps=0 w=2u l=0.5u
X932 VSS lvds_lane_0.VBN.0 lvds_lane_2.fb.0 VSS nfet_03v3 ad=0.65p pd=3.02u as=0.65p ps=3.02u w=2.5u l=1u
X933 lvds_lane_0.fa.0 lvds_lane_0.VB2.0 lvds_lane_0.oa.0 VSS nfet_03v3 ad=1.1752p pd=5.04u as=1.1752p ps=5.04u w=4.52u l=0.5u
X934 lvds_lane_2.oa.0 lvds_lane_0.VB2.0 lvds_lane_2.fa.0 VSS nfet_03v3 ad=1.1752p pd=5.04u as=1.1752p ps=5.04u w=4.52u l=0.5u
X935 lvds_lane_1.tn.0 VSS VSS VSS nfet_03v3 ad=0.65p pd=3.02u as=1.1p ps=5.88u w=2.5u l=1u
X936 VDD lvds_lane_0.VBP.0 lvds_lane_2.tp.0 VDD pfet_03v3 ad=1.3p pd=5.52u as=1.3p ps=5.52u w=5u l=1u
X937 lvds_lane_1.oa.0 lvds_lane_0.VREF.0 lvds_lane_1.tn.0 VSS nfet_03v3 ad=1.235p pd=5.27u as=1.235p ps=5.27u w=4.75u l=0.5u
X938 VDD EN lvds_lane_2.d2a.0 VDD pfet_03v3 ad=0.52p pd=2.52u as=0.52p ps=2.52u w=2u l=0.5u
X939 lvds_lane_1.n3a.0 lvds_lane_1.d2a.0 VDD VDD pfet_03v3 ad=0.52p pd=2.52u as=0.52p ps=2.52u w=2u l=0.4u
X940 lvds_lane_0.n3a.0 lvds_lane_0.d2a.0 VDD VDD pfet_03v3 ad=0.52p pd=2.52u as=0.52p ps=2.52u w=2u l=0.4u
X941 lvds_lane_0.VBP.0 VDD VDD VDD pfet_03v3 ad=0.52p pd=2.52u as=0.88p ps=4.88u w=2u l=0.5u
X942 lvds_lane_0.d2a.0 lvds_lane_0.d2b.0 VDD VDD pfet_03v3 ad=0.52p pd=2.52u as=0.52p ps=2.52u w=2u l=0.4u
X943 VDD lvds_lane_0.rla_m1.0 VSS ppolyf_u_1k r_width=2u r_length=9.11u
X944 VDD VDD lvds_lane_2.tp.0 VDD pfet_03v3 ad=2.2p pd=10.88u as=1.3p ps=5.52u w=5u l=1u
X945 lvds_lane_2.oa.0 VSS VSS VSS nfet_03v3 ad=1.1752p pd=5.04u as=1.9888p ps=9.92u w=4.52u l=0.5u
X946 lvds_lane_0.tn.0 lvds_lane_0.gp.0 lvds_lane_0.oa.0 VSS nfet_03v3 ad=1.235p pd=5.27u as=1.235p ps=5.27u w=4.75u l=0.5u
X947 lvds_lane_1.ob.0 lvds_lane_0.VREF.0 lvds_lane_1.tn.0 VSS nfet_03v3 ad=1.235p pd=5.27u as=1.235p ps=5.27u w=4.75u l=0.5u
X948 lvds_lane_0.tp.0 lvds_lane_0.VREF.0 lvds_lane_0.fb.0 lvds_lane_0.tp.0 pfet_03v3 ad=1.248p pd=5.32u as=2.112p ps=10.48u w=4.8u l=0.4u
X949 lvds_lane_2.fb.0 lvds_lane_2.gn.0 lvds_lane_2.tp.0 lvds_lane_2.tp.0 pfet_03v3 ad=1.248p pd=5.32u as=1.248p ps=5.32u w=4.8u l=0.4u
X950 VDD lvds_lane_0.d2a.0 lvds_lane_0.d2b.0 VDD pfet_03v3 ad=0.52p pd=2.52u as=0.52p ps=2.52u w=2u l=0.4u
X951 lvds_lane_0.fa.0 lvds_lane_0.gp.0 lvds_lane_0.tp.0 lvds_lane_0.tp.0 pfet_03v3 ad=1.248p pd=5.32u as=1.248p ps=5.32u w=4.8u l=0.4u
X952 lvds_lane_1.tp.0 lvds_lane_0.VREF.0 lvds_lane_1.fa.0 lvds_lane_1.tp.0 pfet_03v3 ad=1.248p pd=5.32u as=1.248p ps=5.32u w=4.8u l=0.4u
X953 lvds_lane_2.fb.0 lvds_lane_0.VBN.0 VSS VSS nfet_03v3 ad=0.65p pd=3.02u as=0.65p ps=3.02u w=2.5u l=1u
X954 lvds_lane_2.oa.0 lvds_lane_2.gp.0 lvds_lane_2.tn.0 VSS nfet_03v3 ad=1.235p pd=5.27u as=1.235p ps=5.27u w=4.75u l=0.5u
X955 lvds_lane_2.tp.0 lvds_lane_2.gp.0 lvds_lane_2.fa.0 lvds_lane_2.tp.0 pfet_03v3 ad=1.248p pd=5.32u as=1.248p ps=5.32u w=4.8u l=0.4u
X956 lvds_lane_0.tn.0 lvds_lane_0.gn.0 lvds_lane_0.ob.0 VSS nfet_03v3 ad=1.235p pd=5.27u as=1.235p ps=5.27u w=4.75u l=0.5u
X957 lvds_lane_1.oa.0 lvds_lane_0.VREF.0 lvds_lane_1.tn.0 VSS nfet_03v3 ad=1.235p pd=5.27u as=1.235p ps=5.27u w=4.75u l=0.5u
X958 VDD lvds_lane_2.d2a.0 lvds_lane_2.n3a.0 VDD pfet_03v3 ad=0.52p pd=2.52u as=0.52p ps=2.52u w=2u l=0.4u
X959 lvds_lane_1.tp.0 lvds_lane_0.VBP.0 VDD VDD pfet_03v3 ad=1.3p pd=5.52u as=1.3p ps=5.52u w=5u l=1u
X960 lvds_lane_1.fa.0 lvds_lane_1.gp.0 lvds_lane_1.tp.0 lvds_lane_1.tp.0 pfet_03v3 ad=1.248p pd=5.32u as=1.248p ps=5.32u w=4.8u l=0.4u
X961 lvds_lane_2.fa.0 lvds_lane_2.gp.0 lvds_lane_2.tp.0 lvds_lane_2.tp.0 pfet_03v3 ad=1.248p pd=5.32u as=1.248p ps=5.32u w=4.8u l=0.4u
X962 lvds_lane_0.VBP.0 lvds_lane_0.VBP.0 VDD VDD pfet_03v3 ad=1.3p pd=5.52u as=1.3p ps=5.52u w=5u l=1u
X963 lvds_lane_0.fb.0 lvds_lane_0.VBN.0 VSS VSS nfet_03v3 ad=0.65p pd=3.02u as=0.65p ps=3.02u w=2.5u l=1u
X964 VDD VDD VDD VDD pfet_03v3 ad=0.65p pd=3.02u as=0 ps=0 w=2.5u l=0.28u
X965 lvds_lane_0.ts.0 lvds_lane_0.sb.0 VSS ppolyf_u_1k r_width=2u r_length=8.86u
X966 lvds_lane_0.d2a.0 VSS VSS VSS nfet_03v3 ad=1.0036p pd=4.38u as=1.6984p ps=8.6u w=3.86u l=0.5u
X967 lvds_lane_2.tp.0 lvds_lane_0.VBP.0 VDD VDD pfet_03v3 ad=1.3p pd=5.52u as=1.3p ps=5.52u w=5u l=1u
X968 lvds_lane_2.ob.0 lvds_lane_2.gn.0 lvds_lane_2.tn.0 VSS nfet_03v3 ad=1.235p pd=5.27u as=1.235p ps=5.27u w=4.75u l=0.5u
X969 lvds_lane_0.tn.0 lvds_lane_0.VREF.0 lvds_lane_0.ob.0 VSS nfet_03v3 ad=1.235p pd=5.27u as=1.235p ps=5.27u w=4.75u l=0.5u
X970 lvds_lane_0.tp.0 lvds_lane_0.VBP.0 VDD VDD pfet_03v3 ad=1.3p pd=5.52u as=1.3p ps=5.52u w=5u l=1u
X971 lvds_lane_0.tp.0 lvds_lane_0.VREF.0 lvds_lane_0.fb.0 lvds_lane_0.tp.0 pfet_03v3 ad=1.248p pd=5.32u as=1.248p ps=5.32u w=4.8u l=0.4u
X972 lvds_lane_1.tp.0 lvds_lane_1.gp.0 lvds_lane_1.fa.0 lvds_lane_1.tp.0 pfet_03v3 ad=1.248p pd=5.32u as=1.248p ps=5.32u w=4.8u l=0.4u
X973 lvds_lane_2.ob.0 lvds_lane_0.VREF.0 lvds_lane_2.tn.0 VSS nfet_03v3 ad=1.235p pd=5.27u as=1.235p ps=5.27u w=4.75u l=0.5u
X974 lvds_lane_0.fb.0 lvds_lane_0.VREF.0 lvds_lane_0.tp.0 lvds_lane_0.tp.0 pfet_03v3 ad=1.248p pd=5.32u as=1.248p ps=5.32u w=4.8u l=0.4u
X975 VSS lvds_lane_0.VBN.0 lvds_lane_2.fa.0 VSS nfet_03v3 ad=0.65p pd=3.02u as=0.65p ps=3.02u w=2.5u l=1u
X976 VSS lvds_lane_0.VBN.0 lvds_lane_1.tn.0 VSS nfet_03v3 ad=0.65p pd=3.02u as=0.65p ps=3.02u w=2.5u l=1u
X977 lvds_lane_0.tp.0 lvds_lane_0.VREF.0 lvds_lane_0.fb.0 lvds_lane_0.tp.0 pfet_03v3 ad=1.248p pd=5.32u as=1.248p ps=5.32u w=4.8u l=0.4u
X978 lvds_lane_1.tp.0 lvds_lane_1.gn.0 lvds_lane_1.fb.0 lvds_lane_1.tp.0 pfet_03v3 ad=1.248p pd=5.32u as=1.248p ps=5.32u w=4.8u l=0.4u
X979 lvds_lane_1.tp.0 lvds_lane_1.gn.0 lvds_lane_1.fb.0 lvds_lane_1.tp.0 pfet_03v3 ad=1.248p pd=5.32u as=1.248p ps=5.32u w=4.8u l=0.4u
X980 lvds_lane_0.VBN.0 lvds_lane_0.VBN.0 VSS VSS nfet_03v3 ad=0.65p pd=3.02u as=0.65p ps=3.02u w=2.5u l=1u
X981 lvds_lane_2.tn.0 lvds_lane_2.gn.0 lvds_lane_2.ob.0 VSS nfet_03v3 ad=1.235p pd=5.27u as=1.235p ps=5.27u w=4.75u l=0.5u
X982 lvds_lane_0.VBP.0 lvds_lane_0.VBP.0 VDD VDD pfet_03v3 ad=1.3p pd=5.52u as=1.3p ps=5.52u w=5u l=1u
X983 lvds_lane_2.fa.0 lvds_lane_0.VREF.0 lvds_lane_2.tp.0 lvds_lane_2.tp.0 pfet_03v3 ad=1.248p pd=5.32u as=1.248p ps=5.32u w=4.8u l=0.4u
X984 VSS lvds_lane_0.VBN.0 lvds_lane_2.tn.0 VSS nfet_03v3 ad=0.65p pd=3.02u as=0.65p ps=3.02u w=2.5u l=1u
X985 lvds_lane_1.nm.0 lvds_lane_1.d3.0 lvds_lane_1.nd.0 VSS nfet_03v3 ad=0.52p pd=2.52u as=0.52p ps=2.52u w=2u l=0.28u
X986 lvds_lane_1.fa.0 lvds_lane_0.VBN.0 VSS VSS nfet_03v3 ad=0.65p pd=3.02u as=0.65p ps=3.02u w=2.5u l=1u
X987 RX1_O lvds_lane_1.i2.0 VSS VSS nfet_03v3 ad=1.04p pd=4.52u as=1.04p ps=4.52u w=4u l=0.28u
X988 lvds_lane_1.fb.0 lvds_lane_1.gn.0 lvds_lane_1.tp.0 lvds_lane_1.tp.0 pfet_03v3 ad=1.248p pd=5.32u as=1.248p ps=5.32u w=4.8u l=0.4u
X989 lvds_lane_0.oa.0 lvds_lane_0.gp.0 lvds_lane_0.tn.0 VSS nfet_03v3 ad=1.235p pd=5.27u as=1.235p ps=5.27u w=4.75u l=0.5u
X990 VDD lvds_lane_0.d2a.0 lvds_lane_0.n3a.0 VDD pfet_03v3 ad=0.52p pd=2.52u as=0.52p ps=2.52u w=2u l=0.4u
X991 VSS VSS lvds_lane_1.sa.0 VSS nfet_03v3 ad=1.6984p pd=8.6u as=1.0036p ps=4.38u w=3.86u l=0.5u
X992 VDD lvds_lane_0.VBP.0 lvds_lane_2.tp.0 VDD pfet_03v3 ad=1.3p pd=5.52u as=1.3p ps=5.52u w=5u l=1u
X993 lvds_lane_2.d2b.0 lvds_lane_2.d2a.0 VDD VDD pfet_03v3 ad=0.52p pd=2.52u as=0.52p ps=2.52u w=2u l=0.4u
X994 VDD lvds_lane_0.d2a.0 lvds_lane_0.d2a.0 VDD pfet_03v3 ad=0.52p pd=2.52u as=0.52p ps=2.52u w=2u l=0.4u
X995 lvds_lane_1.sb.0 lvds_lane_1.ob.0 lvds_lane_1.d2b.0 VSS nfet_03v3 ad=1.0036p pd=4.38u as=1.0036p ps=4.38u w=3.86u l=0.5u
X996 VDD lvds_bias_0.enb.0 lvds_bias_0.nrb.0 VDD pfet_03v3 ad=1.3p pd=5.52u as=1.3p ps=5.52u w=5u l=0.5u
X997 VDD lvds_lane_0.VBP.0 lvds_lane_0.VBP.0 VDD pfet_03v3 ad=1.3p pd=5.52u as=1.3p ps=5.52u w=5u l=1u
X998 lvds_lane_1.fb.0 lvds_lane_1.gn.0 lvds_lane_1.tp.0 lvds_lane_1.tp.0 pfet_03v3 ad=1.248p pd=5.32u as=1.248p ps=5.32u w=4.8u l=0.4u
X999 lvds_lane_2.fb.0 lvds_lane_2.gn.0 lvds_lane_2.tp.0 lvds_lane_2.tp.0 pfet_03v3 ad=1.248p pd=5.32u as=1.248p ps=5.32u w=4.8u l=0.4u
X1000 VSS lvds_lane_0.VBN.0 lvds_lane_0.fb.0 VSS nfet_03v3 ad=0.65p pd=3.02u as=0.65p ps=3.02u w=2.5u l=1u
X1001 VDD lvds_lane_1.i2.0 RX1_O VDD pfet_03v3 ad=1.3p pd=5.52u as=1.3p ps=5.52u w=5u l=0.28u
X1002 VDD lvds_lane_0.VBP.0 lvds_lane_2.tp.0 VDD pfet_03v3 ad=1.3p pd=5.52u as=1.3p ps=5.52u w=5u l=1u
X1003 lvds_lane_2.tp.0 lvds_lane_0.VREF.0 lvds_lane_2.fb.0 lvds_lane_2.tp.0 pfet_03v3 ad=1.248p pd=5.32u as=1.248p ps=5.32u w=4.8u l=0.4u
X1004 VSS lvds_lane_0.VBN.0 lvds_lane_1.fa.0 VSS nfet_03v3 ad=0.65p pd=3.02u as=0.65p ps=3.02u w=2.5u l=1u
X1005 lvds_lane_1.ob.0 lvds_lane_0.VB2.0 lvds_lane_1.fb.0 VSS nfet_03v3 ad=1.1752p pd=5.04u as=1.1752p ps=5.04u w=4.52u l=0.5u
X1006 VDD lvds_lane_0.VBP.0 lvds_lane_0.tp.0 VDD pfet_03v3 ad=1.3p pd=5.52u as=1.3p ps=5.52u w=5u l=1u
X1007 lvds_lane_1.oa.0 lvds_lane_0.VREF.0 lvds_lane_1.tn.0 VSS nfet_03v3 ad=1.235p pd=5.27u as=1.235p ps=5.27u w=4.75u l=0.5u
X1008 lvds_lane_1.tp.0 lvds_lane_1.gn.0 lvds_lane_1.fb.0 lvds_lane_1.tp.0 pfet_03v3 ad=1.248p pd=5.32u as=1.248p ps=5.32u w=4.8u l=0.4u
X1009 lvds_lane_1.ob.0 lvds_lane_0.VB2.0 lvds_lane_1.fb.0 VSS nfet_03v3 ad=1.1752p pd=5.04u as=1.1752p ps=5.04u w=4.52u l=0.5u
X1010 lvds_lane_2.fb.0 lvds_lane_0.VBN.0 VSS VSS nfet_03v3 ad=0.65p pd=3.02u as=0.65p ps=3.02u w=2.5u l=1u
X1011 lvds_bias_0.rf_m1.0 VSS VSS ppolyf_u_1k r_width=2u r_length=23.07u
X1012 VSS VSS lvds_lane_0.sb.0 VSS nfet_03v3 ad=1.6984p pd=8.6u as=1.0036p ps=4.38u w=3.86u l=0.5u
X1013 lvds_lane_0.tp.0 lvds_lane_0.gp.0 lvds_lane_0.fa.0 lvds_lane_0.tp.0 pfet_03v3 ad=1.248p pd=5.32u as=1.248p ps=5.32u w=4.8u l=0.4u
X1014 lvds_lane_2.fb.0 lvds_lane_0.VREF.0 lvds_lane_2.tp.0 lvds_lane_2.tp.0 pfet_03v3 ad=1.248p pd=5.32u as=1.248p ps=5.32u w=4.8u l=0.4u
X1015 lvds_lane_2.tn.0 lvds_lane_0.VBN.0 VSS VSS nfet_03v3 ad=0.65p pd=3.02u as=0.65p ps=3.02u w=2.5u l=1u
X1016 lvds_lane_2.tp.0 lvds_lane_0.VBP.0 VDD VDD pfet_03v3 ad=1.3p pd=5.52u as=1.3p ps=5.52u w=5u l=1u
X1017 lvds_bias_0.rdb_m2.0 lvds_bias_0.rdb_m1.0 VSS ppolyf_u_1k r_width=2u r_length=19.26u
X1018 lvds_lane_1.fa.0 lvds_lane_1.gp.0 lvds_lane_1.tp.0 lvds_lane_1.tp.0 pfet_03v3 ad=1.248p pd=5.32u as=1.248p ps=5.32u w=4.8u l=0.4u
X1019 lvds_lane_1.ob.0 VSS VSS VSS nfet_03v3 ad=1.1752p pd=5.04u as=1.9888p ps=9.92u w=4.52u l=0.5u
X1020 VDD lvds_lane_0.d2b.0 lvds_lane_0.d3.0 VDD pfet_03v3 ad=0.52p pd=2.52u as=0.52p ps=2.52u w=2u l=0.4u
X1021 lvds_lane_2.tp.0 lvds_lane_0.VBP.0 VDD VDD pfet_03v3 ad=1.3p pd=5.52u as=1.3p ps=5.52u w=5u l=1u
X1022 lvds_lane_1.tp.0 lvds_lane_0.VREF.0 lvds_lane_1.fa.0 lvds_lane_1.tp.0 pfet_03v3 ad=1.248p pd=5.32u as=1.248p ps=5.32u w=4.8u l=0.4u
X1023 VDD lvds_lane_0.d2b.0 lvds_lane_0.d2a.0 VDD pfet_03v3 ad=0.52p pd=2.52u as=0.52p ps=2.52u w=2u l=0.4u
X1024 lvds_lane_0.fb.0 lvds_lane_0.gn.0 lvds_lane_0.tp.0 lvds_lane_0.tp.0 pfet_03v3 ad=1.248p pd=5.32u as=1.248p ps=5.32u w=4.8u l=0.4u
X1025 lvds_lane_2.tp.0 lvds_lane_2.gp.0 lvds_lane_2.fa.0 lvds_lane_2.tp.0 pfet_03v3 ad=1.248p pd=5.32u as=1.248p ps=5.32u w=4.8u l=0.4u
X1026 lvds_lane_2.d2a.0 lvds_lane_2.d2a.0 VDD VDD pfet_03v3 ad=0.52p pd=2.52u as=0.52p ps=2.52u w=2u l=0.4u
X1027 VDD lvds_lane_2.d2a.0 lvds_lane_2.n3a.0 VDD pfet_03v3 ad=0.52p pd=2.52u as=0.52p ps=2.52u w=2u l=0.4u
X1028 VDD VDD VDD VDD pfet_03v3 ad=0.962p pd=4.22u as=0 ps=0 w=3.7u l=0.28u
C0 lvds_lane_0.d2a.0 lvds_lane_0.d2b.0 2.80463f
C1 lvds_lane_2.nd.0 EN 0.90578f
C2 lvds_lane_0.d2b.0 EN 0.43087f
C3 lvds_bias_0.rdt_m2.0 lvds_bias_0.nmid.0 0.00432f
C4 lvds_lane_2.sa.0 lvds_lane_2.sb.0 0.77697f
C5 lvds_lane_0.VREF.0 lvds_lane_1.gn.0 2.33633f
C6 RX1_O lvds_lane_1.i1.0 0
C7 VDD lvds_lane_2.oa.0 1.59618f
C8 lvds_lane_0.gn.0 lvds_lane_0.VB2.0 0.05558f
C9 lvds_lane_0.VBN.0 lvds_lane_2.oa.0 0.33374f
C10 lvds_lane_1.sb.0 lvds_lane_1.d2b.0 0.85915f
C11 lvds_lane_1.nm.0 lvds_lane_1.nd.0 0.2193f
C12 lvds_lane_0.VBP.0 lvds_bias_0.rb_m1.0 0.0038f
C13 RX0_O EN 1.94682f
C14 lvds_lane_0.sa.0 lvds_lane_0.rla_m1.0 0.30587f
C15 lvds_lane_1.fa.0 lvds_lane_1.oa.0 2.90441f
C16 VDD lvds_lane_2.tn.0 0.19528f
C17 lvds_lane_0.VBN.0 lvds_lane_2.tn.0 0.82513f
C18 VDD lvds_lane_0.i1.0 2.62227f
C19 lvds_lane_2.fb.0 lvds_lane_2.fa.0 0.80129f
C20 lvds_lane_2.gp.0 VDD 4.53691f
C21 lvds_lane_0.VBN.0 lvds_lane_2.gp.0 0.14191f
C22 lvds_lane_1.i2.0 VDD 4.2835f
C23 lvds_lane_2.nd.0 lvds_lane_2.d3.0 0.22426f
C24 lvds_lane_2.ob.0 lvds_lane_2.oa.0 0.59251f
C25 lvds_lane_0.tn.0 lvds_lane_0.oa.0 9.87797f
C26 lvds_lane_2.nm.0 EN 0.02238f
C27 lvds_lane_0.gp.0 lvds_lane_0.VB2.0 0.05601f
C28 lvds_lane_0.VBN.0 lvds_lane_1.fa.0 2.39287f
C29 lvds_lane_0.VB2.0 lvds_lane_1.oa.0 0.57905f
C30 lvds_lane_1.fa.0 lvds_lane_1.gp.0 2.44274f
C31 lvds_lane_2.rla_m1.0 lvds_lane_2.sa.0 0.30587f
C32 lvds_lane_1.ob.0 lvds_lane_1.tn.0 9.55392f
C33 lvds_lane_2.ob.0 lvds_lane_2.tn.0 9.55392f
C34 lvds_lane_1.d2a.0 lvds_lane_1.oa.0 0.23141f
C35 lvds_bias_0.rb_m2.0 lvds_bias_0.vf.0 0.08519f
C36 VDD lvds_lane_2.d2b.0 12.259f
C37 lvds_lane_0.VREF.0 lvds_lane_1.ts.0 0.00271f
C38 RX0_O lvds_lane_0.i2.0 0.50501f
C39 lvds_lane_2.ob.0 lvds_lane_2.gp.0 0.3633f
C40 lvds_lane_1.ob.0 lvds_lane_1.oa.0 0.59251f
C41 lvds_lane_2.tp.0 VDD 11.3411f
C42 VDD lvds_lane_2.gn.0 4.52025f
C43 lvds_lane_0.VBN.0 lvds_lane_2.gn.0 0.11482f
C44 VDD lvds_lane_0.VB2.0 6.61063f
C45 lvds_lane_0.VBN.0 lvds_lane_0.VB2.0 0.63813f
C46 lvds_lane_0.fa.0 lvds_lane_0.VB2.0 1.75715f
C47 lvds_lane_1.tn.0 lvds_lane_1.gn.0 0.99696f
C48 VDD lvds_lane_1.tp.0 11.3411f
C49 lvds_lane_1.gp.0 lvds_lane_0.VB2.0 0.05601f
C50 lvds_lane_0.nd.0 EN 0.90578f
C51 VDD lvds_bias_0.rdb_m2.0 0.00594f
C52 lvds_lane_1.gp.0 lvds_lane_1.tp.0 12.8757f
C53 lvds_lane_2.nm.0 lvds_lane_2.d3.0 0.01765f
C54 lvds_lane_0.sa.0 lvds_lane_0.oa.0 0.20057f
C55 lvds_lane_1.fb.0 lvds_lane_0.VREF.0 2.88984f
C56 lvds_lane_1.gn.0 lvds_lane_1.oa.0 0.30476f
C57 VDD lvds_lane_1.d2a.0 13.0234f
C58 lvds_lane_1.rla_m1.0 lvds_lane_1.d2a.0 0.00155f
C59 lvds_bias_0.rb_m2.0 lvds_bias_0.nrb.0 0.03837f
C60 lvds_lane_2.i2.0 VDD 4.2835f
C61 RX2_P lvds_lane_0.VBP.0 0.03967f
C62 lvds_lane_1.ob.0 VDD 1.9912f
C63 lvds_lane_1.ob.0 lvds_lane_0.VBN.0 0.19136f
C64 lvds_lane_1.ob.0 lvds_lane_1.gp.0 0.3633f
C65 lvds_lane_2.ob.0 lvds_lane_2.d2b.0 0.20289f
C66 RX1_N lvds_lane_1.gn.0 0.14621f
C67 lvds_lane_2.ob.0 lvds_lane_2.gn.0 1.03804f
C68 lvds_lane_2.ob.0 lvds_lane_0.VB2.0 0.57476f
C69 lvds_lane_2.i1.0 VDD 2.62227f
C70 lvds_lane_0.nm.0 EN 0.02238f
C71 lvds_lane_0.rla_m1.0 lvds_lane_0.d2b.0 0.00475f
C72 VDD lvds_lane_1.gn.0 4.52025f
C73 lvds_lane_0.VBN.0 lvds_lane_1.gn.0 0.11482f
C74 lvds_lane_0.tn.0 lvds_lane_0.VREF.0 1.62411f
C75 lvds_bias_0.enb.0 lvds_lane_0.VB2.0 2.12636f
C76 lvds_lane_1.gp.0 lvds_lane_1.gn.0 2.07546f
C77 lvds_lane_0.tp.0 lvds_lane_0.fb.0 25.7437f
C78 lvds_lane_0.d2a.0 VDD 13.0234f
C79 VDD EN 65.1213f
C80 lvds_lane_0.VBN.0 EN 0.42114f
C81 lvds_lane_0.VREF.0 lvds_lane_0.fb.0 2.88984f
C82 lvds_lane_0.d2b.0 lvds_lane_0.n3a.0 0.50895f
C83 lvds_lane_2.d2a.0 lvds_lane_2.oa.0 0.23141f
C84 lvds_lane_2.fa.0 lvds_lane_0.VREF.0 2.64932f
C85 lvds_lane_0.ob.0 lvds_lane_0.tn.0 9.55392f
C86 lvds_lane_0.sa.0 lvds_lane_0.d2b.0 0.20733f
C87 lvds_lane_2.n3a.0 VDD 5.30403f
C88 lvds_lane_0.VB2.0 lvds_bias_0.nmid.0 0.91956f
C89 lvds_bias_0.rdt_m2.0 lvds_bias_0.rdb_m2.0 0.37f
C90 lvds_lane_0.ts.0 lvds_lane_0.VREF.0 0.00271f
C91 lvds_bias_0.rdb_m2.0 lvds_bias_0.nmid.0 0.04228f
C92 RX0_N lvds_lane_0.VBP.0 0.03712f
C93 lvds_lane_0.ob.0 lvds_lane_0.fb.0 2.81909f
C94 lvds_lane_0.tn.0 lvds_lane_0.gn.0 0.99696f
C95 lvds_lane_2.fb.0 lvds_lane_0.VREF.0 2.88984f
C96 VDD lvds_lane_1.nd.0 2.72518f
C97 lvds_lane_2.tn.0 lvds_lane_2.oa.0 9.87797f
C98 RX2_N lvds_lane_0.VBP.0 0.03712f
C99 lvds_lane_1.d2a.0 lvds_lane_1.sa.0 1.70252f
C100 VDD lvds_lane_2.d3.0 4.25479f
C101 lvds_bias_0.nrb.0 lvds_bias_0.vf.0 0.76263f
C102 lvds_bias_0.vf.0 lvds_lane_0.VBP.0 0.3587f
C103 lvds_bias_0.enb.0 EN 4.04436f
C104 lvds_lane_2.gp.0 lvds_lane_2.oa.0 1.25114f
C105 lvds_lane_1.ob.0 lvds_lane_1.sa.0 0.01084f
C106 VDD lvds_lane_1.i1.0 2.62227f
C107 lvds_lane_0.gn.0 lvds_lane_0.fb.0 2.59553f
C108 VDD lvds_lane_1.ts.0 0.55022f
C109 lvds_lane_0.ob.0 lvds_lane_0.sa.0 0.01084f
C110 VDD lvds_lane_0.i2.0 4.2835f
C111 lvds_lane_0.VBN.0 lvds_lane_1.ts.0 0.52623f
C112 lvds_lane_1.d3.0 lvds_lane_1.d2a.0 2.65586f
C113 lvds_lane_2.gp.0 lvds_lane_2.tn.0 1.20627f
C114 lvds_lane_2.d2a.0 lvds_lane_2.d2b.0 2.80463f
C115 lvds_lane_0.oa.0 lvds_lane_0.VREF.0 2.14744f
C116 lvds_bias_0.nmid.0 EN 0.59891f
C117 lvds_lane_0.tn.0 lvds_lane_0.gp.0 1.20627f
C118 lvds_lane_0.VBN.0 lvds_lane_1.fb.0 1.48704f
C119 lvds_bias_0.nrb.0 lvds_lane_0.VBP.0 0.36246f
C120 lvds_bias_0.enb.0 lvds_bias_0.rb_m1.0 0
C121 lvds_lane_1.fb.0 lvds_lane_1.gp.0 0.86843f
C122 lvds_lane_2.gn.0 lvds_lane_2.oa.0 0.30476f
C123 lvds_lane_0.VB2.0 lvds_lane_2.oa.0 0.57905f
C124 lvds_lane_1.d2b.0 VDD 12.259f
C125 lvds_lane_1.d2b.0 lvds_lane_1.rla_m1.0 0.00475f
C126 lvds_lane_0.gp.0 lvds_lane_0.fb.0 0.86843f
C127 lvds_lane_0.ob.0 lvds_lane_0.oa.0 0.59251f
C128 lvds_lane_0.tp.0 lvds_lane_0.VBP.0 3.37779f
C129 lvds_lane_1.d3.0 EN 0.54374f
C130 lvds_bias_0.rb_m3.0 lvds_bias_0.rf_m1.0 0.04347f
C131 lvds_lane_0.d2a.0 lvds_lane_0.d3.0 2.65586f
C132 lvds_lane_0.tn.0 VDD 0.19528f
C133 lvds_lane_0.d3.0 EN 0.54374f
C134 lvds_lane_0.gn.0 RX0_N 0.14621f
C135 lvds_lane_0.tn.0 lvds_lane_0.VBN.0 0.82513f
C136 lvds_lane_2.gn.0 lvds_lane_2.tn.0 0.99696f
C137 lvds_lane_0.VREF.0 lvds_lane_0.VBP.0 0.0747f
C138 lvds_lane_0.gn.0 lvds_lane_0.oa.0 0.30476f
C139 lvds_lane_2.tp.0 lvds_lane_2.gp.0 12.8757f
C140 lvds_bias_0.rb_m2.0 lvds_lane_0.VBN.0 0.03954f
C141 lvds_lane_1.rlb_m1.0 lvds_lane_1.rla_m1.0 0.39394f
C142 lvds_lane_2.gp.0 lvds_lane_2.gn.0 2.07546f
C143 RX2_P VDD 2.27847f
C144 lvds_lane_2.gp.0 lvds_lane_0.VB2.0 0.05601f
C145 lvds_bias_0.rdb_m3.0 lvds_bias_0.rdt_m1.0 0.41833f
C146 lvds_lane_0.VBN.0 lvds_lane_0.fb.0 1.48704f
C147 lvds_lane_0.fa.0 lvds_lane_0.fb.0 0.80129f
C148 lvds_lane_2.fa.0 lvds_lane_0.VBN.0 2.39287f
C149 RX2_O VDD 4.00067f
C150 lvds_lane_2.sa.0 VDD 0.00564f
C151 lvds_lane_1.fa.0 lvds_lane_0.VB2.0 1.75715f
C152 lvds_lane_2.ts.0 lvds_lane_0.VREF.0 0.00271f
C153 lvds_lane_1.fa.0 lvds_lane_1.tp.0 25.3704f
C154 lvds_lane_2.d2a.0 EN 0.18482f
C155 lvds_lane_0.VREF.0 lvds_lane_0.tp.0 14.925f
C156 lvds_lane_1.d3.0 lvds_lane_1.nd.0 0.22426f
C157 lvds_lane_0.ts.0 VDD 0.55022f
C158 lvds_lane_0.ts.0 lvds_lane_0.VBN.0 0.52623f
C159 VDD lvds_lane_0.n3a.0 5.30403f
C160 VDD lvds_lane_1.n3a.0 5.30403f
C161 lvds_lane_2.n3a.0 lvds_lane_2.d2a.0 0.37969f
C162 lvds_lane_0.sa.0 VDD 0.00564f
C163 lvds_lane_0.ob.0 lvds_lane_0.d2b.0 0.20289f
C164 lvds_lane_2.nd.0 lvds_lane_2.nm.0 0.2193f
C165 lvds_lane_2.fb.0 lvds_lane_0.VBN.0 1.48704f
C166 lvds_lane_1.ob.0 lvds_lane_1.fa.0 0
C167 lvds_lane_2.tp.0 lvds_lane_2.gn.0 13.4594f
C168 lvds_lane_2.ob.0 lvds_lane_2.sb.0 0.28465f
C169 lvds_lane_0.gn.0 lvds_lane_0.VBP.0 0.26446f
C170 lvds_lane_2.tp.0 lvds_lane_0.VB2.0 0.05309f
C171 lvds_lane_0.oa.0 lvds_lane_0.gp.0 1.25114f
C172 lvds_lane_2.gn.0 lvds_lane_0.VB2.0 0.05558f
C173 lvds_lane_2.ob.0 lvds_lane_2.fa.0 0
C174 lvds_lane_0.VB2.0 lvds_lane_1.tp.0 0.05309f
C175 lvds_lane_2.ob.0 lvds_lane_2.sa.0 0.01084f
C176 lvds_lane_1.d2b.0 lvds_lane_1.sa.0 0.20733f
C177 lvds_lane_0.ob.0 lvds_lane_0.VREF.0 2.70252f
C178 lvds_lane_0.i1.0 EN 0.26447f
C179 lvds_lane_1.fa.0 lvds_lane_1.gn.0 0.67123f
C180 RX0_N VDD 2.56543f
C181 lvds_lane_2.d2a.0 lvds_lane_2.d3.0 2.65586f
C182 lvds_lane_1.i2.0 EN 0.31483f
C183 lvds_lane_0.gn.0 lvds_lane_0.tp.0 13.4594f
C184 lvds_lane_1.ob.0 lvds_lane_0.VB2.0 0.57476f
C185 lvds_lane_0.sb.0 lvds_lane_0.sa.0 0.77697f
C186 lvds_lane_1.d2b.0 lvds_lane_1.d3.0 0.35626f
C187 lvds_lane_0.oa.0 VDD 1.59618f
C188 lvds_lane_0.VBN.0 lvds_lane_0.oa.0 0.33374f
C189 lvds_lane_0.fa.0 lvds_lane_0.oa.0 2.90441f
C190 lvds_lane_2.fb.0 lvds_lane_2.ob.0 2.81909f
C191 RX2_N VDD 2.56543f
C192 lvds_lane_0.gn.0 lvds_lane_0.VREF.0 2.33633f
C193 lvds_lane_1.rlb_m1.0 lvds_lane_1.sa.0 0
C194 lvds_bias_0.vf.0 VDD 0.00294f
C195 lvds_bias_0.vf.0 lvds_lane_0.VBN.0 1.54524f
C196 lvds_lane_0.gp.0 lvds_lane_0.VBP.0 0.26446f
C197 VDD RX1_O 4.00061f
C198 lvds_lane_0.VB2.0 lvds_lane_1.gn.0 0.05558f
C199 lvds_lane_1.gn.0 lvds_lane_1.tp.0 13.4594f
C200 lvds_bias_0.rdt_m3.0 lvds_bias_0.rdt_m1.0 0.08167f
C201 lvds_lane_2.d2b.0 EN 0.43087f
C202 lvds_lane_0.VBP.0 RX0_P 0.03875f
C203 lvds_lane_0.ob.0 lvds_lane_0.gn.0 1.03804f
C204 lvds_lane_0.VB2.0 EN 2.2084f
C205 lvds_lane_2.n3a.0 lvds_lane_2.d2b.0 0.50895f
C206 lvds_lane_2.i2.0 lvds_lane_2.i1.0 0.28557f
C207 RX1_N lvds_lane_0.VBP.0 0.03712f
C208 lvds_lane_0.i1.0 lvds_lane_0.i2.0 0.28557f
C209 lvds_lane_0.gp.0 lvds_lane_0.tp.0 12.8757f
C210 lvds_lane_0.VBP.0 RX1_P 0.03967f
C211 lvds_lane_1.ob.0 lvds_lane_1.gn.0 1.03804f
C212 lvds_lane_1.tn.0 lvds_lane_0.VREF.0 1.62411f
C213 lvds_lane_1.i2.0 lvds_lane_1.i1.0 0.28557f
C214 VDD lvds_lane_0.VBP.0 0.11404p
C215 lvds_bias_0.nrb.0 VDD 5.10108f
C216 lvds_lane_0.VBN.0 lvds_lane_0.VBP.0 7.61409f
C217 lvds_bias_0.nrb.0 lvds_lane_0.VBN.0 0.04436f
C218 lvds_lane_1.gp.0 lvds_lane_0.VBP.0 0.26446f
C219 lvds_lane_1.d2a.0 EN 0.18482f
C220 lvds_lane_0.gp.0 lvds_lane_0.VREF.0 1.91483f
C221 lvds_lane_0.VREF.0 lvds_lane_1.oa.0 2.14744f
C222 lvds_lane_2.i2.0 EN 0.31483f
C223 lvds_bias_0.vf.0 lvds_bias_0.enb.0 1.18587f
C224 lvds_lane_2.nd.0 VDD 2.72518f
C225 lvds_lane_0.d3.0 lvds_lane_0.n3a.0 0.59994f
C226 lvds_lane_1.d3.0 lvds_lane_1.n3a.0 0.59994f
C227 lvds_lane_0.rlb_m1.0 lvds_lane_0.rla_m1.0 0.39394f
C228 VDD lvds_lane_0.d2b.0 12.259f
C229 lvds_bias_0.rb_m3.0 lvds_bias_0.rb_m1.0 0.06955f
C230 lvds_lane_1.sb.0 lvds_lane_1.sa.0 0.77697f
C231 lvds_lane_2.ts.0 VDD 0.55022f
C232 lvds_lane_2.ts.0 lvds_lane_0.VBN.0 0.52623f
C233 VDD lvds_lane_0.tp.0 11.3411f
C234 lvds_lane_2.d3.0 lvds_lane_2.d2b.0 0.35626f
C235 lvds_lane_0.fa.0 lvds_lane_0.tp.0 25.3704f
C236 lvds_lane_0.ob.0 lvds_lane_0.gp.0 0.3633f
C237 lvds_lane_2.i1.0 EN 0.26447f
C238 lvds_lane_2.sa.0 lvds_lane_2.d2a.0 1.70252f
C239 lvds_lane_1.fa.0 lvds_lane_1.fb.0 0.80129f
C240 lvds_lane_0.VREF.0 VDD 2.13357f
C241 lvds_lane_0.VBN.0 lvds_lane_0.VREF.0 2.95645f
C242 VDD RX0_O 3.99882f
C243 lvds_lane_0.fa.0 lvds_lane_0.VREF.0 2.64932f
C244 lvds_lane_2.fa.0 lvds_lane_2.oa.0 2.90441f
C245 lvds_lane_0.VREF.0 lvds_lane_1.gp.0 1.91483f
C246 lvds_lane_2.sa.0 lvds_lane_2.rlb_m1.0 0
C247 lvds_lane_0.rlb_m1.0 lvds_lane_0.sa.0 0
C248 lvds_bias_0.enb.0 lvds_lane_0.VBP.0 1.1468f
C249 lvds_bias_0.nrb.0 lvds_bias_0.enb.0 0.83214f
C250 lvds_lane_2.sa.0 lvds_lane_2.oa.0 0.20057f
C251 lvds_lane_0.d2a.0 EN 0.18482f
C252 lvds_lane_0.sb.0 lvds_lane_0.d2b.0 0.85915f
C253 lvds_lane_0.gn.0 lvds_lane_0.gp.0 2.07546f
C254 lvds_lane_2.n3a.0 EN 0.07539f
C255 lvds_lane_0.ob.0 VDD 1.9912f
C256 lvds_lane_0.ob.0 lvds_lane_0.VBN.0 0.19136f
C257 lvds_lane_0.fa.0 lvds_lane_0.ob.0 0
C258 lvds_lane_1.fb.0 lvds_lane_0.VB2.0 2.14447f
C259 RX2_P lvds_lane_2.gp.0 0.14621f
C260 lvds_lane_1.fb.0 lvds_lane_1.tp.0 25.7437f
C261 lvds_lane_2.fa.0 lvds_lane_2.gp.0 2.44274f
C262 lvds_lane_0.VBP.0 lvds_bias_0.nmid.0 0.03404f
C263 lvds_lane_2.ob.0 lvds_lane_0.VREF.0 2.70252f
C264 lvds_lane_0.VREF.0 lvds_bias_0.enb.0 0.14548f
C265 lvds_lane_0.nd.0 lvds_lane_0.nm.0 0.2193f
C266 lvds_lane_2.rla_m1.0 lvds_lane_2.d2a.0 0.00155f
C267 lvds_bias_0.rb_m1.0 EN 0.00476f
C268 lvds_lane_0.gn.0 VDD 4.52025f
C269 lvds_lane_0.gn.0 lvds_lane_0.VBN.0 0.11482f
C270 lvds_lane_0.fa.0 lvds_lane_0.gn.0 0.67123f
C271 lvds_lane_1.nd.0 EN 0.90578f
C272 lvds_lane_1.ob.0 lvds_lane_1.fb.0 2.81909f
C273 lvds_lane_1.tn.0 lvds_lane_1.oa.0 9.87797f
C274 lvds_lane_2.rla_m1.0 lvds_lane_2.rlb_m1.0 0.39394f
C275 lvds_lane_1.d3.0 lvds_lane_1.nm.0 0.01765f
C276 lvds_lane_1.d2b.0 lvds_lane_1.d2a.0 2.80463f
C277 lvds_lane_2.d3.0 EN 0.54374f
C278 lvds_lane_0.sb.0 lvds_lane_0.ob.0 0.28465f
C279 lvds_bias_0.enb.0 lvds_bias_0.rdt_m1.0 0.0052f
C280 EN lvds_lane_1.i1.0 0.26447f
C281 lvds_lane_2.sb.0 lvds_lane_2.d2b.0 0.85915f
C282 lvds_lane_0.nd.0 VDD 2.72518f
C283 lvds_lane_1.ob.0 lvds_lane_1.d2b.0 0.20289f
C284 lvds_lane_2.fb.0 lvds_lane_2.gp.0 0.86843f
C285 lvds_lane_0.i2.0 EN 0.31483f
C286 lvds_lane_2.n3a.0 lvds_lane_2.d3.0 0.59994f
C287 lvds_lane_0.VREF.0 lvds_bias_0.rdt_m2.0 0.00234f
C288 lvds_lane_1.fb.0 lvds_lane_1.gn.0 2.59553f
C289 lvds_lane_0.gp.0 RX0_P 0.14621f
C290 lvds_lane_0.VREF.0 lvds_bias_0.nmid.0 0
C291 lvds_lane_2.sa.0 lvds_lane_2.d2b.0 0.20733f
C292 lvds_lane_0.VB2.0 lvds_lane_0.fb.0 2.14447f
C293 lvds_lane_2.tp.0 lvds_lane_2.fa.0 25.3704f
C294 lvds_lane_2.fa.0 lvds_lane_2.gn.0 0.67123f
C295 lvds_lane_2.fa.0 lvds_lane_0.VB2.0 1.75715f
C296 lvds_lane_1.tn.0 VDD 0.19528f
C297 lvds_lane_1.tn.0 lvds_lane_0.VBN.0 0.82513f
C298 lvds_lane_0.d3.0 lvds_lane_0.d2b.0 0.35626f
C299 lvds_lane_1.tn.0 lvds_lane_1.gp.0 1.20627f
C300 lvds_lane_0.gp.0 VDD 4.53691f
C301 lvds_lane_0.VBN.0 lvds_lane_0.gp.0 0.14191f
C302 lvds_lane_0.fa.0 lvds_lane_0.gp.0 2.44274f
C303 VDD lvds_lane_1.oa.0 1.59618f
C304 lvds_lane_0.VBN.0 lvds_lane_1.oa.0 0.33374f
C305 lvds_lane_1.gp.0 lvds_lane_1.oa.0 1.25114f
C306 lvds_lane_1.nd.0 lvds_lane_1.i1.0 0.21598f
C307 lvds_lane_1.d2b.0 EN 0.43087f
C308 VDD RX0_P 2.27023f
C309 lvds_lane_2.i2.0 RX2_O 0.50509f
C310 lvds_lane_2.fb.0 lvds_lane_2.tp.0 25.7437f
C311 lvds_lane_2.fb.0 lvds_lane_2.gn.0 2.59553f
C312 lvds_lane_2.fb.0 lvds_lane_0.VB2.0 2.14447f
C313 lvds_bias_0.rdb_m1.0 lvds_bias_0.rdt_m3.0 0.22342f
C314 VDD RX1_N 2.56543f
C315 VDD RX1_P 2.27847f
C316 lvds_lane_1.n3a.0 lvds_lane_1.d2a.0 0.37969f
C317 lvds_lane_1.i2.0 RX1_O 0.50509f
C318 lvds_lane_1.gp.0 RX1_P 0.14621f
C319 lvds_lane_0.VBN.0 VDD 3.76135f
C320 lvds_lane_2.rla_m1.0 lvds_lane_2.d2b.0 0.00475f
C321 lvds_lane_0.fa.0 lvds_lane_0.VBN.0 2.39287f
C322 lvds_lane_2.i1.0 RX2_O 0
C323 lvds_lane_1.gp.0 VDD 4.53691f
C324 lvds_lane_0.VBN.0 lvds_lane_1.gp.0 0.14191f
C325 lvds_lane_0.d2a.0 lvds_lane_0.rla_m1.0 0.00155f
C326 RX2_O EN 0.005f
C327 lvds_lane_2.gp.0 lvds_lane_0.VBP.0 0.26446f
C328 lvds_lane_0.oa.0 lvds_lane_0.VB2.0 0.57905f
C329 RX2_N lvds_lane_2.gn.0 0.14621f
C330 lvds_lane_1.ob.0 lvds_lane_1.sb.0 0.28465f
C331 lvds_lane_0.VREF.0 lvds_lane_2.oa.0 2.14744f
C332 lvds_bias_0.vf.0 lvds_lane_0.VB2.0 0.92899f
C333 lvds_lane_0.d2a.0 lvds_lane_0.n3a.0 0.37969f
C334 lvds_lane_0.n3a.0 EN 0.07539f
C335 lvds_lane_2.ob.0 VDD 1.9912f
C336 lvds_lane_2.ob.0 lvds_lane_0.VBN.0 0.19136f
C337 lvds_lane_1.n3a.0 EN 0.07539f
C338 lvds_lane_0.sa.0 lvds_lane_0.d2a.0 1.70252f
C339 VDD lvds_bias_0.enb.0 6.1787f
C340 lvds_lane_0.VBN.0 lvds_bias_0.enb.0 0.2848f
C341 lvds_lane_0.nd.0 lvds_lane_0.d3.0 0.22426f
C342 lvds_lane_0.VREF.0 lvds_lane_2.tn.0 1.62411f
C343 RX0_O lvds_lane_0.i1.0 0
C344 lvds_lane_1.sa.0 lvds_lane_1.oa.0 0.20057f
C345 lvds_lane_2.gp.0 lvds_lane_0.VREF.0 1.91483f
C346 lvds_lane_2.tp.0 lvds_lane_0.VBP.0 3.37779f
C347 lvds_lane_2.gn.0 lvds_lane_0.VBP.0 0.26446f
C348 lvds_lane_0.VB2.0 lvds_lane_0.VBP.0 5.46578f
C349 lvds_bias_0.nrb.0 lvds_lane_0.VB2.0 0.03936f
C350 lvds_lane_0.VBP.0 lvds_lane_1.tp.0 3.37779f
C351 VDD lvds_bias_0.rdt_m2.0 0.00209f
C352 lvds_lane_1.fa.0 lvds_lane_0.VREF.0 2.64932f
C353 VDD lvds_bias_0.nmid.0 0.89656f
C354 lvds_lane_0.VBN.0 lvds_bias_0.nmid.0 0.11617f
C355 lvds_lane_0.d2a.0 lvds_lane_0.oa.0 0.23141f
C356 VDD lvds_lane_1.sa.0 0.00564f
C357 lvds_lane_1.rla_m1.0 lvds_lane_1.sa.0 0.30587f
C358 lvds_lane_0.d3.0 lvds_lane_0.nm.0 0.01765f
C359 lvds_lane_0.tp.0 lvds_lane_0.VB2.0 0.05309f
C360 lvds_bias_0.vf.0 EN 0.02265f
C361 RX1_O EN 0.00492f
C362 lvds_lane_2.tp.0 lvds_lane_0.VREF.0 14.925f
C363 lvds_lane_0.VREF.0 lvds_lane_2.gn.0 2.33633f
C364 lvds_lane_0.VREF.0 lvds_lane_0.VB2.0 24.5935f
C365 VDD lvds_lane_1.d3.0 4.25479f
C366 lvds_lane_0.d3.0 VDD 4.25479f
C367 lvds_lane_0.VREF.0 lvds_lane_1.tp.0 14.925f
C368 lvds_lane_0.VBP.0 lvds_lane_1.gn.0 0.26446f
C369 lvds_lane_0.VREF.0 lvds_bias_0.rdb_m2.0 0.09091f
C370 lvds_lane_1.nm.0 EN 0.02238f
C371 lvds_lane_0.nd.0 lvds_lane_0.i1.0 0.21598f
C372 lvds_bias_0.enb.0 lvds_bias_0.nmid.0 0.71708f
C373 lvds_lane_2.nd.0 lvds_lane_2.i1.0 0.21598f
C374 lvds_lane_0.ob.0 lvds_lane_0.VB2.0 0.57476f
C375 lvds_lane_0.VBP.0 EN 0.30684f
C376 lvds_lane_1.ob.0 lvds_lane_0.VREF.0 2.70252f
C377 lvds_bias_0.nrb.0 EN 0.24322f
C378 lvds_lane_1.d2b.0 lvds_lane_1.n3a.0 0.50895f
C379 lvds_lane_2.d2a.0 VDD 13.0234f
C380 RX2_O VSS 18.8961f
C381 RX1_O VSS 11.8271f
C382 RX0_O VSS 11.1616f
C383 EN VSS 37.0197f
C384 RX2_N VSS 3.34389f
C385 RX2_P VSS 3.63059f
C386 RX1_N VSS 3.34389f
C387 RX1_P VSS 3.63059f
C388 RX0_N VSS 3.34389f
C389 RX0_P VSS 3.63059f
C390 VDD VSS 0.74482p
C391 lvds_bias_0.rb_m3.0 VSS 1.32997f
C392 lvds_bias_0.rb_m2.0 VSS 1.18198f
C393 lvds_bias_0.rb_m1.0 VSS 1.29868f
C394 lvds_bias_0.rf_m1.0 VSS 1.40226f
C395 lvds_bias_0.vf.0 VSS 3.02831f
C396 lvds_bias_0.nrb.0 VSS 1.98311f
C397 lvds_lane_2.i2.0 VSS 4.24296f
C398 lvds_lane_2.i1.0 VSS 3.72118f
C399 lvds_lane_2.nm.0 VSS 0.31567f
C400 lvds_lane_2.nd.0 VSS 3.35102f
C401 lvds_lane_1.i2.0 VSS 4.24296f
C402 lvds_lane_1.i1.0 VSS 3.72118f
C403 lvds_lane_1.nm.0 VSS 0.31567f
C404 lvds_lane_1.nd.0 VSS 3.35102f
C405 lvds_lane_0.i2.0 VSS 4.24296f
C406 lvds_lane_0.i1.0 VSS 3.72118f
C407 lvds_lane_0.nm.0 VSS 0.31567f
C408 lvds_lane_0.nd.0 VSS 3.35102f
C409 lvds_lane_2.d3.0 VSS 5.75604f
C410 lvds_lane_2.n3a.0 VSS 3.16279f
C411 lvds_lane_1.d3.0 VSS 5.75604f
C412 lvds_lane_1.n3a.0 VSS 3.16279f
C413 lvds_lane_0.d3.0 VSS 5.75604f
C414 lvds_lane_0.n3a.0 VSS 3.16279f
C415 lvds_bias_0.rdb_m1.0 VSS 1.12023f
C416 lvds_bias_0.rdt_m3.0 VSS 1.81265f
C417 lvds_bias_0.rdb_m2.0 VSS 1.89154f
C418 lvds_bias_0.rdb_m3.0 VSS 1.13703f
C419 lvds_bias_0.rdt_m1.0 VSS 1.66241f
C420 lvds_bias_0.rdt_m2.0 VSS 1.18196f
C421 lvds_bias_0.nmid.0 VSS 4.29306f
C422 lvds_lane_2.sb.0 VSS 2.75864f
C423 lvds_lane_2.d2b.0 VSS 4.72656f
C424 lvds_lane_2.rlb_m1.0 VSS 1.11225f
C425 lvds_lane_2.rla_m1.0 VSS 1.48073f
C426 lvds_lane_2.sa.0 VSS 4.78816f
C427 lvds_lane_2.d2a.0 VSS 3.05391f
C428 lvds_lane_1.sb.0 VSS 2.75864f
C429 lvds_lane_1.d2b.0 VSS 4.72656f
C430 lvds_lane_1.rlb_m1.0 VSS 1.11225f
C431 lvds_lane_1.rla_m1.0 VSS 1.48073f
C432 lvds_lane_1.sa.0 VSS 4.78816f
C433 lvds_lane_1.d2a.0 VSS 3.05391f
C434 lvds_lane_0.sb.0 VSS 2.75864f
C435 lvds_lane_0.d2b.0 VSS 4.72656f
C436 lvds_lane_0.rlb_m1.0 VSS 1.11225f
C437 lvds_lane_0.rla_m1.0 VSS 1.48073f
C438 lvds_lane_0.sa.0 VSS 4.78816f
C439 lvds_lane_0.d2a.0 VSS 3.05391f
C440 lvds_lane_2.ts.0 VSS 5.5117f
C441 lvds_lane_2.tn.0 VSS 4.38043f
C442 lvds_lane_1.ts.0 VSS 5.5117f
C443 lvds_lane_1.tn.0 VSS 4.38043f
C444 lvds_lane_0.ts.0 VSS 5.5117f
C445 lvds_lane_0.tn.0 VSS 4.38043f
C446 lvds_bias_0.enb.0 VSS 8.34564f
C447 lvds_lane_2.ob.0 VSS 7.30967f
C448 lvds_lane_2.oa.0 VSS 7.54445f
C449 lvds_lane_1.ob.0 VSS 7.30967f
C450 lvds_lane_1.oa.0 VSS 7.54445f
C451 lvds_lane_0.ob.0 VSS 7.30967f
C452 lvds_lane_0.VBN.0 VSS 0.16633p
C453 lvds_lane_0.oa.0 VSS 7.54445f
C454 lvds_lane_2.fa.0 VSS 9.0556f
C455 lvds_lane_2.fb.0 VSS 7.93573f
C456 lvds_lane_1.fa.0 VSS 9.0556f
C457 lvds_lane_1.fb.0 VSS 7.93573f
C458 lvds_lane_0.fa.0 VSS 9.0556f
C459 lvds_lane_0.fb.0 VSS 7.93573f
C460 lvds_lane_0.VREF.0 VSS 59.87f
C461 lvds_lane_0.VB2.0 VSS 40.2263f
C462 lvds_lane_2.gn.0 VSS 13.9171f
C463 lvds_lane_2.gp.0 VSS 14.0995f
C464 lvds_lane_1.gn.0 VSS 13.9171f
C465 lvds_lane_1.gp.0 VSS 14.0995f
C466 lvds_lane_0.gn.0 VSS 13.9171f
C467 lvds_lane_0.VBP.0 VSS 20.6887f
C468 lvds_lane_0.gp.0 VSS 14.0995f
C469 lvds_lane_2.tp.0 VSS 0.1029p
C470 lvds_lane_1.tp.0 VSS 0.1029p
C471 lvds_lane_0.tp.0 VSS 0.1029p
.ends lvds_rx_x3
