* lvds_rx_x3: parasitic C on all nets (coupling and to substrate, cthresh 0) (flat copy of the hierarchy)
* GENERATED by layout/macro/run_macro.py (T10) from a GDS with sha256 a4d88aa55f6079d4f23155cfc3dc2cd6cc5577ff3afd60067faebfe1505cb473 -- do not edit by hand.
* Ports in the order of subckt lvds_rx_x3 of netlist/lvds_rx_lvs_ref.spice (Magic's own order was: RX0_O RX1_O RX2_O EN RX0_P RX0_N RX1_P RX1_N RX2_P RX2_N VDD VSS).
* NGSPICE file created from lvds_rx_x3_flat.ext - technology: gf180mcuD

.subckt lvds_rx_x3 VDD VSS RX0_P RX0_N RX1_P RX1_N RX2_P RX2_N EN RX0_O RX1_O RX2_O
X0 VSS VSS lvds_lane_2.fa.0 VSS nfet_03v3 ad=1.1p pd=5.88u as=0.65p ps=3.02u w=2.5u l=1u
X1 VSS VSS RX1_O VSS nfet_03v3 ad=1.76p pd=8.88u as=1.04p ps=4.52u w=4u l=0.28u
X2 lvds_lane_0.tp.0 lvds_lane_0.gn.0 lvds_lane_0.fb.0 lvds_lane_0.tp.0 pfet_03v3 ad=1.248p pd=5.32u as=1.248p ps=5.32u w=4.8u l=0.4u
X3 lvds_lane_0.d2b.0 lvds_lane_0.d2a.0 VDD VDD pfet_03v3 ad=0.52p pd=2.52u as=0.52p ps=2.52u w=2u l=0.28u
X4 lvds_lane_0.fb.0 lvds_lane_0.VREF.0 lvds_lane_0.tp.0 lvds_lane_0.tp.0 pfet_03v3 ad=1.248p pd=5.32u as=1.248p ps=5.32u w=4.8u l=0.4u
X5 VDD lvds_lane_0.VBP.0 lvds_lane_2.tp.0 VDD pfet_03v3 ad=1.3p pd=5.52u as=1.3p ps=5.52u w=5u l=1u
X6 lvds_lane_1.tp.0 lvds_lane_1.gn.0 lvds_lane_1.fb.0 lvds_lane_1.tp.0 pfet_03v3 ad=1.248p pd=5.32u as=1.248p ps=5.32u w=4.8u l=0.4u
X7 lvds_lane_1.fb.0 lvds_lane_0.VBN.0 VSS VSS nfet_03v3 ad=0.65p pd=3.02u as=0.65p ps=3.02u w=2.5u l=1u
X8 lvds_lane_0.VBP.0 lvds_lane_0.VBP.0 VDD VDD pfet_03v3 ad=1.3p pd=5.52u as=1.3p ps=5.52u w=5u l=1u
X9 lvds_lane_2.fa.0 lvds_lane_0.VREF.0 lvds_lane_2.tp.0 lvds_lane_2.tp.0 pfet_03v3 ad=1.248p pd=5.32u as=1.248p ps=5.32u w=4.8u l=0.4u
X10 VSS lvds_lane_0.VBN.0 lvds_lane_0.fb.0 VSS nfet_03v3 ad=0.65p pd=3.02u as=0.65p ps=3.02u w=2.5u l=1u
X11 VDD VDD VDD VDD pfet_03v3 ad=0.52p pd=2.52u as=0.29839n ps=1.38742m w=2u l=0.5u
X12 lvds_lane_1.tp.0 lvds_lane_0.VBP.0 VDD VDD pfet_03v3 ad=1.3p pd=5.52u as=1.3p ps=5.52u w=5u l=1u
X13 lvds_lane_0.n3a.0 lvds_lane_0.d2a.0 VDD VDD pfet_03v3 ad=0.52p pd=2.52u as=0.52p ps=2.52u w=2u l=0.28u
X14 VSS VSS lvds_lane_2.fa.0 VSS nfet_03v3 ad=1.9888p pd=9.92u as=1.1752p ps=5.04u w=4.52u l=0.5u
X15 lvds_lane_0.d2a.0 lvds_lane_0.d2b.0 VDD VDD pfet_03v3 ad=0.52p pd=2.52u as=0.52p ps=2.52u w=2u l=0.28u
X16 lvds_lane_1.n3a.0 lvds_lane_1.d2a.0 VDD VDD pfet_03v3 ad=0.52p pd=2.52u as=0.52p ps=2.52u w=2u l=0.28u
X17 lvds_lane_1.tn.0 lvds_lane_1.gp.0 lvds_lane_1.oa.0 VSS nfet_03v3 ad=1.235p pd=5.27u as=1.235p ps=5.27u w=4.75u l=0.5u
X18 lvds_lane_1.fb.0 lvds_lane_1.gn.0 lvds_lane_1.tp.0 lvds_lane_1.tp.0 pfet_03v3 ad=1.248p pd=5.32u as=1.248p ps=5.32u w=4.8u l=0.4u
X19 lvds_lane_2.tp.0 lvds_lane_0.VREF.0 lvds_lane_2.fb.0 lvds_lane_2.tp.0 pfet_03v3 ad=1.248p pd=5.32u as=1.248p ps=5.32u w=4.8u l=0.4u
X20 VSS lvds_lane_0.VBN.0 lvds_lane_1.fb.0 VSS nfet_03v3 ad=0.65p pd=3.02u as=0.65p ps=3.02u w=2.5u l=1u
X21 VSS lvds_lane_1.n3a.0 lvds_lane_1.d3.0 VSS nfet_03v3 ad=0.6734p pd=3.11u as=0.6734p ps=3.11u w=2.59u l=0.28u
X22 lvds_lane_2.tn.0 lvds_lane_0.VREF.0 lvds_lane_2.ob.0 VSS nfet_03v3 ad=1.235p pd=5.27u as=1.235p ps=5.27u w=4.75u l=0.5u
X23 lvds_lane_2.oa.0 lvds_lane_0.VB2.0 lvds_lane_2.fa.0 VSS nfet_03v3 ad=1.1752p pd=5.04u as=1.1752p ps=5.04u w=4.52u l=0.5u
X24 lvds_lane_0.tp.0 lvds_lane_0.gp.0 lvds_lane_0.fa.0 lvds_lane_0.tp.0 pfet_03v3 ad=1.248p pd=5.32u as=1.248p ps=5.32u w=4.8u l=0.4u
X25 lvds_lane_0.oa.0 lvds_lane_0.VREF.0 lvds_lane_0.tn.0 VSS nfet_03v3 ad=1.235p pd=5.27u as=1.235p ps=5.27u w=4.75u l=0.5u
X26 VDD lvds_lane_1.d2a.0 lvds_lane_1.d2a.0 VDD pfet_03v3 ad=0.52p pd=2.52u as=0.52p ps=2.52u w=2u l=0.28u
X27 lvds_lane_1.fb.0 lvds_lane_0.VREF.0 lvds_lane_1.tp.0 lvds_lane_1.tp.0 pfet_03v3 ad=1.248p pd=5.32u as=1.248p ps=5.32u w=4.8u l=0.4u
X28 lvds_lane_2.fb.0 lvds_lane_0.VB2.0 lvds_lane_2.ob.0 VSS nfet_03v3 ad=1.1752p pd=5.04u as=1.1752p ps=5.04u w=4.52u l=0.5u
X29 VSS lvds_lane_0.VREF.0 VSS VSS nfet_03v3 ad=8.8p pd=40.88u as=0.2658n ps=1.29442m w=20u l=25.13u
X30 lvds_lane_1.tn.0 lvds_lane_1.gp.0 lvds_lane_1.oa.0 VSS nfet_03v3 ad=1.235p pd=5.27u as=1.235p ps=5.27u w=4.75u l=0.5u
D0 lvds_lane_0.gp.0 VDD diode_pd2nw_03v3 pj=26u area=40p
X31 lvds_lane_2.tp.0 lvds_lane_2.gp.0 lvds_lane_2.fa.0 lvds_lane_2.tp.0 pfet_03v3 ad=1.248p pd=5.32u as=1.248p ps=5.32u w=4.8u l=0.4u
X32 lvds_lane_0.ob.0 lvds_lane_0.VB2.0 lvds_lane_0.fb.0 VSS nfet_03v3 ad=1.1752p pd=5.04u as=1.1752p ps=5.04u w=4.52u l=0.5u
X33 lvds_lane_0.nm.0 lvds_lane_0.d3.0 lvds_lane_0.nd.0 VSS nfet_03v3 ad=0.52p pd=2.52u as=0.52p ps=2.52u w=2u l=0.28u
X34 lvds_lane_0.ob.0 lvds_lane_0.VREF.0 lvds_lane_0.tn.0 VSS nfet_03v3 ad=1.235p pd=5.27u as=1.235p ps=5.27u w=4.75u l=0.5u
X35 lvds_lane_1.tn.0 lvds_lane_1.gn.0 lvds_lane_1.ob.0 VSS nfet_03v3 ad=1.235p pd=5.27u as=1.235p ps=5.27u w=4.75u l=0.5u
X36 RX0_O lvds_lane_0.i2.0 VSS VSS nfet_03v3 ad=1.04p pd=4.52u as=1.04p ps=4.52u w=4u l=0.28u
X37 VSS lvds_lane_0.VBN.0 lvds_lane_0.VBP.0 VSS nfet_03v3 ad=0.65p pd=3.02u as=0.65p ps=3.02u w=2.5u l=1u
X38 VDD lvds_lane_2.d2b.0 lvds_lane_2.d3.0 VDD pfet_03v3 ad=0.52p pd=2.52u as=0.52p ps=2.52u w=2u l=0.28u
X39 VDD lvds_lane_1.d2b.0 lvds_lane_1.d2b.0 VDD pfet_03v3 ad=0.52p pd=2.52u as=0.52p ps=2.52u w=2u l=0.28u
X40 lvds_lane_0.fa.0 lvds_lane_0.VREF.0 lvds_lane_0.tp.0 lvds_lane_0.tp.0 pfet_03v3 ad=1.248p pd=5.32u as=1.248p ps=5.32u w=4.8u l=0.4u
X41 lvds_lane_2.d2b.0 VDD VDD VDD pfet_03v3 ad=0.52p pd=2.52u as=0.88p ps=4.88u w=2u l=0.5u
X42 VDD lvds_lane_0.d2b.0 lvds_lane_0.d3.0 VDD pfet_03v3 ad=0.52p pd=2.52u as=0.52p ps=2.52u w=2u l=0.28u
X43 lvds_lane_1.fb.0 lvds_lane_1.gn.0 lvds_lane_1.tp.0 lvds_lane_1.tp.0 pfet_03v3 ad=1.248p pd=5.32u as=1.248p ps=5.32u w=4.8u l=0.4u
X44 lvds_lane_0.fa.0 lvds_lane_0.VBN.0 VSS VSS nfet_03v3 ad=0.65p pd=3.02u as=0.65p ps=3.02u w=2.5u l=1u
X45 lvds_lane_0.tn.0 lvds_lane_0.gp.0 lvds_lane_0.oa.0 VSS nfet_03v3 ad=1.235p pd=5.27u as=1.235p ps=5.27u w=4.75u l=0.5u
X46 lvds_lane_2.d3.0 lvds_lane_2.n3a.0 VSS VSS nfet_03v3 ad=0.6734p pd=3.11u as=0.6734p ps=3.11u w=2.59u l=0.28u
X47 lvds_lane_2.fb.0 lvds_lane_0.VREF.0 lvds_lane_2.tp.0 lvds_lane_2.tp.0 pfet_03v3 ad=1.248p pd=5.32u as=1.248p ps=5.32u w=4.8u l=0.4u
X48 lvds_lane_0.fa.0 lvds_lane_0.VREF.0 lvds_lane_0.tp.0 lvds_lane_0.tp.0 pfet_03v3 ad=1.248p pd=5.32u as=1.248p ps=5.32u w=4.8u l=0.4u
X49 lvds_lane_1.tp.0 lvds_lane_0.VREF.0 lvds_lane_1.fa.0 lvds_lane_1.tp.0 pfet_03v3 ad=1.248p pd=5.32u as=1.248p ps=5.32u w=4.8u l=0.4u
X50 lvds_lane_0.tn.0 lvds_lane_0.VBN.0 VSS VSS nfet_03v3 ad=0.65p pd=3.02u as=0.65p ps=3.02u w=2.5u l=1u
X51 lvds_lane_2.oa.0 lvds_lane_2.gp.0 lvds_lane_2.tn.0 VSS nfet_03v3 ad=1.235p pd=5.27u as=1.235p ps=5.27u w=4.75u l=0.5u
X52 RX2_O lvds_lane_2.i2.0 VSS VSS nfet_03v3 ad=1.04p pd=4.52u as=1.04p ps=4.52u w=4u l=0.28u
X53 VSS lvds_lane_0.VBN.0 lvds_lane_2.ts.0 VSS nfet_03v3 ad=0.65p pd=3.02u as=0.65p ps=3.02u w=2.5u l=1u
X54 lvds_lane_0.d2a.0 lvds_lane_0.d2b.0 VDD VDD pfet_03v3 ad=0.52p pd=2.52u as=0.52p ps=2.52u w=2u l=0.28u
X55 VDD lvds_lane_0.i2.0 RX0_O VDD pfet_03v3 ad=1.3p pd=5.52u as=1.3p ps=5.52u w=5u l=0.28u
X56 VSS lvds_bias_0.enb.0 lvds_lane_0.VB2.0 VSS nfet_03v3 ad=0.52p pd=2.52u as=0.52p ps=2.52u w=2u l=0.5u
X57 VDD lvds_lane_2.d3.0 lvds_lane_2.nd.0 VDD pfet_03v3 ad=0.78p pd=3.52u as=0.78p ps=3.52u w=3u l=0.28u
X58 lvds_lane_1.tp.0 lvds_lane_0.VREF.0 lvds_lane_1.fa.0 lvds_lane_1.tp.0 pfet_03v3 ad=1.248p pd=5.32u as=1.248p ps=5.32u w=4.8u l=0.4u
X59 VSS lvds_lane_0.VBN.0 lvds_lane_0.ts.0 VSS nfet_03v3 ad=0.65p pd=3.02u as=0.65p ps=3.02u w=2.5u l=1u
X60 lvds_lane_2.ob.0 lvds_lane_0.VREF.0 lvds_lane_2.tn.0 VSS nfet_03v3 ad=1.235p pd=5.27u as=1.235p ps=5.27u w=4.75u l=0.5u
X61 VDD VDD lvds_lane_0.i2.0 VDD pfet_03v3 ad=1.65p pd=8.38u as=0.975p ps=4.27u w=3.75u l=0.28u
X62 lvds_lane_0.d3.0 lvds_lane_0.d2b.0 VDD VDD pfet_03v3 ad=0.52p pd=2.52u as=0.52p ps=2.52u w=2u l=0.28u
X63 lvds_lane_0.tp.0 lvds_lane_0.gn.0 lvds_lane_0.fb.0 lvds_lane_0.tp.0 pfet_03v3 ad=1.248p pd=5.32u as=1.248p ps=5.32u w=4.8u l=0.4u
X64 lvds_lane_2.d2b.0 lvds_lane_2.d2b.0 VDD VDD pfet_03v3 ad=0.52p pd=2.52u as=0.52p ps=2.52u w=2u l=0.28u
X65 lvds_lane_0.fa.0 lvds_lane_0.VREF.0 lvds_lane_0.tp.0 lvds_lane_0.tp.0 pfet_03v3 ad=1.248p pd=5.32u as=1.248p ps=5.32u w=4.8u l=0.4u
X66 lvds_lane_1.fa.0 lvds_lane_0.VREF.0 lvds_lane_1.tp.0 lvds_lane_1.tp.0 pfet_03v3 ad=1.248p pd=5.32u as=1.248p ps=5.32u w=4.8u l=0.4u
X67 lvds_lane_0.d2a.0 VDD VDD VDD pfet_03v3 ad=0.52p pd=2.52u as=0.88p ps=4.88u w=2u l=0.28u
X68 lvds_lane_2.tp.0 lvds_lane_2.gp.0 lvds_lane_2.fa.0 lvds_lane_2.tp.0 pfet_03v3 ad=1.248p pd=5.32u as=1.248p ps=5.32u w=4.8u l=0.4u
X69 lvds_lane_1.d3.0 lvds_lane_1.d2b.0 VDD VDD pfet_03v3 ad=0.52p pd=2.52u as=0.52p ps=2.52u w=2u l=0.28u
X70 lvds_lane_0.ts.0 lvds_lane_0.sa.0 VSS ppolyf_u_1k r_width=2u r_length=3.17u
X71 lvds_lane_1.d2b.0 lvds_lane_1.d2a.0 VDD VDD pfet_03v3 ad=0.52p pd=2.52u as=0.52p ps=2.52u w=2u l=0.28u
X72 lvds_lane_0.tp.0 lvds_lane_0.VREF.0 lvds_lane_0.fb.0 lvds_lane_0.tp.0 pfet_03v3 ad=1.248p pd=5.32u as=1.248p ps=5.32u w=4.8u l=0.4u
X73 lvds_lane_1.tp.0 lvds_lane_1.gn.0 lvds_lane_1.fb.0 lvds_lane_1.tp.0 pfet_03v3 ad=1.248p pd=5.32u as=1.248p ps=5.32u w=4.8u l=0.4u
X74 VDD lvds_lane_2.i2.0 RX2_O VDD pfet_03v3 ad=1.3p pd=5.52u as=1.3p ps=5.52u w=5u l=0.28u
X75 lvds_lane_2.fa.0 lvds_lane_2.gp.0 lvds_lane_2.tp.0 lvds_lane_2.tp.0 pfet_03v3 ad=1.248p pd=5.32u as=1.248p ps=5.32u w=4.8u l=0.4u
X76 lvds_lane_1.sa.0 lvds_lane_1.oa.0 lvds_lane_1.d2a.0 VSS nfet_03v3 ad=1.1362p pd=4.89u as=1.1362p ps=4.89u w=4.37u l=0.5u
X77 VSS VSS VSS ppolyf_u_1k r_width=2u r_length=9.11u
X78 VDD lvds_lane_0.VBP.0 lvds_lane_0.tp.0 VDD pfet_03v3 ad=1.3p pd=5.52u as=1.3p ps=5.52u w=5u l=1u
X79 lvds_lane_1.fa.0 lvds_lane_1.gp.0 lvds_lane_1.tp.0 lvds_lane_1.tp.0 pfet_03v3 ad=1.248p pd=5.32u as=1.248p ps=5.32u w=4.8u l=0.4u
X80 lvds_lane_1.ob.0 lvds_lane_0.VREF.0 lvds_lane_1.tn.0 VSS nfet_03v3 ad=2.09p pd=10.38u as=1.235p ps=5.27u w=4.75u l=0.5u
X81 lvds_lane_0.tp.0 lvds_lane_0.VREF.0 lvds_lane_0.fa.0 lvds_lane_0.tp.0 pfet_03v3 ad=1.248p pd=5.32u as=1.248p ps=5.32u w=4.8u l=0.4u
X82 VSS VSS RX0_O VSS nfet_03v3 ad=1.76p pd=8.88u as=1.04p ps=4.52u w=4u l=0.28u
X83 VDD lvds_lane_0.d2b.0 lvds_lane_0.d2b.0 VDD pfet_03v3 ad=0.52p pd=2.52u as=0.52p ps=2.52u w=2u l=0.28u
X84 lvds_lane_0.fb.0 lvds_lane_0.gn.0 lvds_lane_0.tp.0 lvds_lane_0.tp.0 pfet_03v3 ad=1.248p pd=5.32u as=1.248p ps=5.32u w=4.8u l=0.4u
X85 lvds_lane_2.tp.0 lvds_lane_0.VREF.0 lvds_lane_2.fb.0 lvds_lane_2.tp.0 pfet_03v3 ad=1.248p pd=5.32u as=1.248p ps=5.32u w=4.8u l=0.4u
X86 VSS lvds_lane_0.VBN.0 lvds_lane_1.fb.0 VSS nfet_03v3 ad=0.65p pd=3.02u as=0.65p ps=3.02u w=2.5u l=1u
X87 VDD lvds_lane_0.VBP.0 lvds_lane_1.tp.0 VDD pfet_03v3 ad=1.3p pd=5.52u as=1.3p ps=5.52u w=5u l=1u
X88 lvds_lane_1.oa.0 lvds_lane_0.VB2.0 lvds_lane_1.fa.0 VSS nfet_03v3 ad=1.1752p pd=5.04u as=1.1752p ps=5.04u w=4.52u l=0.5u
X89 VDD lvds_lane_2.d2a.0 lvds_lane_2.d2b.0 VDD pfet_03v3 ad=0.52p pd=2.52u as=0.52p ps=2.52u w=2u l=0.28u
X90 VSS VSS VSS ppolyf_u_1k r_width=2u r_length=3.17u
X91 lvds_lane_2.ts.0 lvds_lane_0.VBN.0 VSS VSS nfet_03v3 ad=0.65p pd=3.02u as=0.65p ps=3.02u w=2.5u l=1u
X92 VSS VSS lvds_lane_1.fb.0 VSS nfet_03v3 ad=1.9888p pd=9.92u as=1.1752p ps=5.04u w=4.52u l=0.5u
X93 lvds_lane_0.tn.0 VSS VSS VSS nfet_03v3 ad=0.65p pd=3.02u as=1.1p ps=5.88u w=2.5u l=1u
X94 VDD lvds_lane_0.VBP.0 lvds_lane_1.tp.0 VDD pfet_03v3 ad=1.3p pd=5.52u as=1.3p ps=5.52u w=5u l=1u
X95 lvds_lane_0.oa.0 lvds_lane_0.VREF.0 lvds_lane_0.tn.0 VSS nfet_03v3 ad=1.235p pd=5.27u as=1.235p ps=5.27u w=4.75u l=0.5u
X96 VDD lvds_lane_0.d2a.0 lvds_lane_0.n3a.0 VDD pfet_03v3 ad=0.52p pd=2.52u as=0.52p ps=2.52u w=2u l=0.28u
X97 lvds_lane_0.ts.0 lvds_lane_0.VBN.0 VSS VSS nfet_03v3 ad=0.65p pd=3.02u as=0.65p ps=3.02u w=2.5u l=1u
X98 lvds_lane_2.i2.0 lvds_lane_2.i1.0 VDD VDD pfet_03v3 ad=0.975p pd=4.27u as=0.975p ps=4.27u w=3.75u l=0.28u
X99 VDD lvds_lane_2.d2b.0 lvds_lane_2.d2a.0 VDD pfet_03v3 ad=0.52p pd=2.52u as=0.52p ps=2.52u w=2u l=0.28u
X100 lvds_lane_1.oa.0 VSS VSS VSS nfet_03v3 ad=1.1752p pd=5.04u as=1.9888p ps=9.92u w=4.52u l=0.5u
X101 VDD lvds_lane_0.d2a.0 lvds_lane_0.d2a.0 VDD pfet_03v3 ad=0.52p pd=2.52u as=0.52p ps=2.52u w=2u l=0.28u
X102 lvds_lane_2.tp.0 lvds_lane_0.VREF.0 lvds_lane_2.fb.0 lvds_lane_2.tp.0 pfet_03v3 ad=1.248p pd=5.32u as=1.248p ps=5.32u w=4.8u l=0.4u
X103 VDD lvds_lane_1.d2a.0 lvds_lane_1.n3a.0 VDD pfet_03v3 ad=0.52p pd=2.52u as=0.52p ps=2.52u w=2u l=0.28u
X104 lvds_lane_1.ts.0 lvds_lane_0.VBN.0 VSS VSS nfet_03v3 ad=0.65p pd=3.02u as=0.65p ps=3.02u w=2.5u l=1u
X105 lvds_lane_1.tp.0 lvds_lane_1.gn.0 lvds_lane_1.fb.0 lvds_lane_1.tp.0 pfet_03v3 ad=1.248p pd=5.32u as=1.248p ps=5.32u w=4.8u l=0.4u
X106 lvds_lane_0.ob.0 lvds_lane_0.VREF.0 lvds_lane_0.tn.0 VSS nfet_03v3 ad=1.235p pd=5.27u as=1.235p ps=5.27u w=4.75u l=0.5u
X107 VSS VSS RX2_O VSS nfet_03v3 ad=1.76p pd=8.88u as=1.04p ps=4.52u w=4u l=0.28u
X108 lvds_lane_1.n3a.0 lvds_lane_1.n3a.0 VSS VSS nfet_03v3 ad=0.6734p pd=3.11u as=0.6734p ps=3.11u w=2.59u l=0.28u
X109 lvds_lane_0.tp.0 lvds_lane_0.VREF.0 lvds_lane_0.fa.0 lvds_lane_0.tp.0 pfet_03v3 ad=1.248p pd=5.32u as=1.248p ps=5.32u w=4.8u l=0.4u
X110 lvds_lane_2.fb.0 lvds_lane_0.VREF.0 lvds_lane_2.tp.0 lvds_lane_2.tp.0 pfet_03v3 ad=1.248p pd=5.32u as=1.248p ps=5.32u w=4.8u l=0.4u
X111 lvds_lane_1.oa.0 lvds_lane_1.gp.0 lvds_lane_1.tn.0 VSS nfet_03v3 ad=1.235p pd=5.27u as=1.235p ps=5.27u w=4.75u l=0.5u
X112 lvds_lane_2.tn.0 lvds_lane_0.VREF.0 lvds_lane_2.oa.0 VSS nfet_03v3 ad=1.235p pd=5.27u as=1.235p ps=5.27u w=4.75u l=0.5u
X113 lvds_lane_1.d2b.0 lvds_lane_1.d2b.0 VDD VDD pfet_03v3 ad=0.52p pd=2.52u as=0.52p ps=2.52u w=2u l=0.28u
X114 lvds_lane_0.oa.0 lvds_lane_0.VREF.0 lvds_lane_0.tn.0 VSS nfet_03v3 ad=1.235p pd=5.27u as=1.235p ps=5.27u w=4.75u l=0.5u
X115 lvds_lane_0.tp.0 lvds_lane_0.VBP.0 VDD VDD pfet_03v3 ad=1.3p pd=5.52u as=1.3p ps=5.52u w=5u l=1u
X116 VSS VSS VSS ppolyf_u_1k r_width=2u r_length=23.07u
X117 lvds_lane_0.fa.0 lvds_lane_0.gp.0 lvds_lane_0.tp.0 lvds_lane_0.tp.0 pfet_03v3 ad=1.248p pd=5.32u as=1.248p ps=5.32u w=4.8u l=0.4u
X118 lvds_lane_1.fa.0 lvds_lane_1.gp.0 lvds_lane_1.tp.0 lvds_lane_1.tp.0 pfet_03v3 ad=1.248p pd=5.32u as=1.248p ps=5.32u w=4.8u l=0.4u
X119 lvds_lane_1.ob.0 lvds_lane_1.gn.0 lvds_lane_1.tn.0 VSS nfet_03v3 ad=1.235p pd=5.27u as=1.235p ps=5.27u w=4.75u l=0.5u
X120 lvds_lane_1.tp.0 lvds_lane_0.VBP.0 VDD VDD pfet_03v3 ad=1.3p pd=5.52u as=1.3p ps=5.52u w=5u l=1u
X121 lvds_lane_2.tp.0 lvds_lane_0.VREF.0 lvds_lane_2.fa.0 lvds_lane_2.tp.0 pfet_03v3 ad=1.248p pd=5.32u as=1.248p ps=5.32u w=4.8u l=0.4u
X122 lvds_lane_1.d2a.0 lvds_lane_1.d2a.0 VDD VDD pfet_03v3 ad=0.52p pd=2.52u as=0.52p ps=2.52u w=2u l=0.28u
X123 lvds_lane_2.n3a.0 lvds_lane_2.d2a.0 VDD VDD pfet_03v3 ad=0.52p pd=2.52u as=0.52p ps=2.52u w=2u l=0.28u
X124 lvds_lane_1.ts.0 lvds_lane_1.sb.0 VSS ppolyf_u_1k r_width=2u r_length=3.17u
X125 lvds_lane_2.gp.0 RX2_P VDD ppolyf_u r_width=5u r_length=1.8u
X126 lvds_lane_0.tp.0 lvds_lane_0.gp.0 lvds_lane_0.fa.0 lvds_lane_0.tp.0 pfet_03v3 ad=1.248p pd=5.32u as=1.248p ps=5.32u w=4.8u l=0.4u
X127 lvds_lane_1.ob.0 lvds_lane_0.VREF.0 lvds_lane_1.tn.0 VSS nfet_03v3 ad=1.235p pd=5.27u as=1.235p ps=5.27u w=4.75u l=0.5u
X128 VSS lvds_lane_0.VBN.0 lvds_lane_0.tn.0 VSS nfet_03v3 ad=0.65p pd=3.02u as=0.65p ps=3.02u w=2.5u l=1u
X129 VDD EN lvds_lane_0.d2a.0 VDD pfet_03v3 ad=0.52p pd=2.52u as=0.52p ps=2.52u w=2u l=0.5u
X130 lvds_lane_0.tp.0 lvds_lane_0.gn.0 lvds_lane_0.fb.0 lvds_lane_0.tp.0 pfet_03v3 ad=1.248p pd=5.32u as=1.248p ps=5.32u w=4.8u l=0.4u
X131 lvds_lane_0.tp.0 lvds_lane_0.gn.0 lvds_lane_0.fb.0 lvds_lane_0.tp.0 pfet_03v3 ad=1.248p pd=5.32u as=1.248p ps=5.32u w=4.8u l=0.4u
X132 VSS lvds_lane_0.VBN.0 lvds_lane_1.fa.0 VSS nfet_03v3 ad=0.65p pd=3.02u as=0.65p ps=3.02u w=2.5u l=1u
X133 VSS VSS VSS VSS nfet_03v3 ad=1.1396p pd=6.06u as=0 ps=0 w=2.59u l=0.28u
X134 lvds_lane_2.ts.0 lvds_lane_0.VBN.0 VSS VSS nfet_03v3 ad=0.65p pd=3.02u as=0.65p ps=3.02u w=2.5u l=1u
X135 lvds_lane_1.fa.0 lvds_lane_0.VREF.0 lvds_lane_1.tp.0 lvds_lane_1.tp.0 pfet_03v3 ad=1.248p pd=5.32u as=1.248p ps=5.32u w=4.8u l=0.4u
X136 lvds_lane_2.fa.0 lvds_lane_0.VREF.0 lvds_lane_2.tp.0 lvds_lane_2.tp.0 pfet_03v3 ad=1.248p pd=5.32u as=1.248p ps=5.32u w=4.8u l=0.4u
X137 lvds_bias_0.nmid.0 EN VSS VSS nfet_03v3 ad=1.3p pd=5.52u as=1.3p ps=5.52u w=5u l=0.5u
X138 VDD VDD VDD VDD pfet_03v3 ad=1.3p pd=5.52u as=0 ps=0 w=5u l=1u
X139 lvds_lane_0.fa.0 lvds_lane_0.VBN.0 VSS VSS nfet_03v3 ad=0.65p pd=3.02u as=0.65p ps=3.02u w=2.5u l=1u
X140 VSS lvds_lane_0.VBN.0 lvds_lane_1.tn.0 VSS nfet_03v3 ad=0.65p pd=3.02u as=0.65p ps=3.02u w=2.5u l=1u
X141 VSS lvds_lane_0.VBN.0 lvds_lane_0.VBN.0 VSS nfet_03v3 ad=0.65p pd=3.02u as=0.65p ps=3.02u w=2.5u l=1u
X142 lvds_lane_2.d2a.0 VDD VDD VDD pfet_03v3 ad=0.52p pd=2.52u as=0.88p ps=4.88u w=2u l=0.5u
X143 lvds_lane_2.d2b.0 lvds_lane_2.ob.0 lvds_lane_2.sb.0 VSS nfet_03v3 ad=1.1362p pd=4.89u as=1.1362p ps=4.89u w=4.37u l=0.5u
X144 lvds_lane_0.VB2.0 lvds_lane_0.VBP.0 VDD VDD pfet_03v3 ad=1.3p pd=5.52u as=1.3p ps=5.52u w=5u l=1u
X145 lvds_lane_0.fb.0 lvds_lane_0.gn.0 lvds_lane_0.tp.0 lvds_lane_0.tp.0 pfet_03v3 ad=1.248p pd=5.32u as=1.248p ps=5.32u w=4.8u l=0.4u
X146 lvds_lane_2.tp.0 lvds_lane_0.VREF.0 lvds_lane_2.fa.0 lvds_lane_2.tp.0 pfet_03v3 ad=1.248p pd=5.32u as=1.248p ps=5.32u w=4.8u l=0.4u
X147 VDD lvds_bias_0.rdt_m1.0 VSS ppolyf_u_1k r_width=2u r_length=21.01u
X148 VSS lvds_lane_0.VBN.0 lvds_lane_1.ts.0 VSS nfet_03v3 ad=0.65p pd=3.02u as=0.65p ps=3.02u w=2.5u l=1u
X149 lvds_lane_2.tn.0 lvds_lane_0.VREF.0 lvds_lane_2.oa.0 VSS nfet_03v3 ad=1.235p pd=5.27u as=1.235p ps=5.27u w=4.75u l=0.5u
X150 lvds_bias_0.nmid.0 VSS VSS VSS nfet_03v3 ad=1.3p pd=5.52u as=2.2p ps=10.88u w=5u l=0.5u
X151 lvds_lane_0.sb.0 lvds_lane_0.ob.0 lvds_lane_0.d2b.0 VSS nfet_03v3 ad=1.1362p pd=4.89u as=1.1362p ps=4.89u w=4.37u l=0.5u
X152 VSS VSS lvds_lane_0.d2a.0 VSS nfet_03v3 ad=1.9228p pd=9.62u as=1.1362p ps=4.89u w=4.37u l=0.5u
X153 lvds_lane_2.fa.0 lvds_lane_0.VREF.0 lvds_lane_2.tp.0 lvds_lane_2.tp.0 pfet_03v3 ad=1.248p pd=5.32u as=1.248p ps=5.32u w=4.8u l=0.4u
X154 lvds_lane_1.tn.0 lvds_lane_1.gn.0 lvds_lane_1.ob.0 VSS nfet_03v3 ad=1.235p pd=5.27u as=1.235p ps=5.27u w=4.75u l=0.5u
X155 VDD EN lvds_bias_0.enb.0 VDD pfet_03v3 ad=0.65p pd=3.02u as=0.65p ps=3.02u w=2.5u l=0.28u
X156 lvds_lane_2.fb.0 lvds_lane_0.VB2.0 lvds_lane_2.ob.0 VSS nfet_03v3 ad=1.1752p pd=5.04u as=1.1752p ps=5.04u w=4.52u l=0.5u
X157 lvds_lane_2.tn.0 lvds_lane_0.VREF.0 lvds_lane_2.ob.0 VSS nfet_03v3 ad=1.235p pd=5.27u as=1.235p ps=5.27u w=4.75u l=0.5u
X158 lvds_lane_2.fa.0 lvds_lane_0.VREF.0 lvds_lane_2.tp.0 lvds_lane_2.tp.0 pfet_03v3 ad=1.248p pd=5.32u as=1.248p ps=5.32u w=4.8u l=0.4u
X159 lvds_lane_2.oa.0 lvds_lane_0.VB2.0 lvds_lane_2.fa.0 VSS nfet_03v3 ad=1.1752p pd=5.04u as=1.1752p ps=5.04u w=4.52u l=0.5u
X160 lvds_lane_0.fb.0 lvds_lane_0.gn.0 lvds_lane_0.tp.0 lvds_lane_0.tp.0 pfet_03v3 ad=1.248p pd=5.32u as=1.248p ps=5.32u w=4.8u l=0.4u
X161 lvds_lane_1.fb.0 lvds_lane_1.gn.0 lvds_lane_1.tp.0 lvds_lane_1.tp.0 pfet_03v3 ad=1.248p pd=5.32u as=1.248p ps=5.32u w=4.8u l=0.4u
X162 VSS lvds_lane_0.VBN.0 lvds_lane_2.fa.0 VSS nfet_03v3 ad=0.65p pd=3.02u as=0.65p ps=3.02u w=2.5u l=1u
X163 lvds_lane_2.fb.0 lvds_lane_0.VB2.0 lvds_lane_2.ob.0 VSS nfet_03v3 ad=1.1752p pd=5.04u as=1.1752p ps=5.04u w=4.52u l=0.5u
X164 lvds_lane_1.tn.0 lvds_lane_1.gp.0 lvds_lane_1.oa.0 VSS nfet_03v3 ad=1.235p pd=5.27u as=1.235p ps=5.27u w=4.75u l=0.5u
X165 VDD lvds_lane_1.d2b.0 lvds_lane_1.d3.0 VDD pfet_03v3 ad=0.52p pd=2.52u as=0.52p ps=2.52u w=2u l=0.28u
X166 lvds_lane_1.ts.0 lvds_lane_0.VBN.0 VSS VSS nfet_03v3 ad=0.65p pd=3.02u as=0.65p ps=3.02u w=2.5u l=1u
X167 VDD lvds_lane_0.VBP.0 lvds_lane_1.tp.0 VDD pfet_03v3 ad=1.3p pd=5.52u as=1.3p ps=5.52u w=5u l=1u
X168 VSS VSS VSS ppolyf_u_1k r_width=2u r_length=21.01u
X169 lvds_bias_0.rdb_m2.0 lvds_bias_0.rdb_m3.0 VSS ppolyf_u_1k r_width=2u r_length=19.26u
D1 lvds_lane_1.gn.0 VDD diode_pd2nw_03v3 pj=26u area=40p
X170 VDD lvds_lane_0.VBP.0 lvds_lane_2.tp.0 VDD pfet_03v3 ad=1.3p pd=5.52u as=1.3p ps=5.52u w=5u l=1u
X171 VDD lvds_lane_0.VBP.0 lvds_lane_0.VB2.0 VDD pfet_03v3 ad=1.3p pd=5.52u as=1.3p ps=5.52u w=5u l=1u
X172 lvds_lane_2.tp.0 lvds_lane_0.VREF.0 lvds_lane_2.fb.0 lvds_lane_2.tp.0 pfet_03v3 ad=1.248p pd=5.32u as=1.248p ps=5.32u w=4.8u l=0.4u
X173 VSS lvds_lane_0.VBN.0 lvds_lane_0.fa.0 VSS nfet_03v3 ad=0.65p pd=3.02u as=0.65p ps=3.02u w=2.5u l=1u
X174 lvds_lane_0.ob.0 lvds_lane_0.VB2.0 lvds_lane_0.fb.0 VSS nfet_03v3 ad=1.1752p pd=5.04u as=1.1752p ps=5.04u w=4.52u l=0.5u
X175 lvds_lane_1.fb.0 lvds_lane_0.VREF.0 lvds_lane_1.tp.0 lvds_lane_1.tp.0 pfet_03v3 ad=2.112p pd=10.48u as=1.248p ps=5.32u w=4.8u l=0.4u
X176 lvds_lane_0.oa.0 lvds_lane_0.VREF.0 lvds_lane_0.tn.0 VSS nfet_03v3 ad=1.235p pd=5.27u as=1.235p ps=5.27u w=4.75u l=0.5u
X177 lvds_lane_2.ob.0 lvds_lane_2.rlb_m1.0 VSS ppolyf_u_1k r_width=2u r_length=9.11u
X178 lvds_lane_2.gn.0 RX2_N VDD ppolyf_u r_width=5u r_length=1.8u
X179 lvds_lane_0.tp.0 lvds_lane_0.gn.0 lvds_lane_0.fb.0 lvds_lane_0.tp.0 pfet_03v3 ad=1.248p pd=5.32u as=1.248p ps=5.32u w=4.8u l=0.4u
X180 VSS VSS lvds_bias_0.vf.0 VSS nfet_03v3 ad=3.4804p pd=16.7u as=2.0566p ps=8.43u w=7.91u l=0.5u
X181 lvds_lane_0.ob.0 lvds_lane_0.VB2.0 lvds_lane_0.fb.0 VSS nfet_03v3 ad=1.1752p pd=5.04u as=1.1752p ps=5.04u w=4.52u l=0.5u
X182 lvds_lane_1.fb.0 lvds_lane_0.VBN.0 VSS VSS nfet_03v3 ad=0.65p pd=3.02u as=0.65p ps=3.02u w=2.5u l=1u
X183 lvds_lane_2.ob.0 lvds_lane_2.gn.0 lvds_lane_2.tn.0 VSS nfet_03v3 ad=1.235p pd=5.27u as=1.235p ps=5.27u w=4.75u l=0.5u
X184 lvds_lane_1.fb.0 lvds_lane_0.VREF.0 lvds_lane_1.tp.0 lvds_lane_1.tp.0 pfet_03v3 ad=1.248p pd=5.32u as=1.248p ps=5.32u w=4.8u l=0.4u
X185 lvds_lane_1.tn.0 lvds_lane_0.VBN.0 VSS VSS nfet_03v3 ad=0.65p pd=3.02u as=0.65p ps=3.02u w=2.5u l=1u
X186 VDD lvds_lane_2.nd.0 lvds_lane_2.i1.0 VDD pfet_03v3 ad=0.962p pd=4.22u as=0.962p ps=4.22u w=3.7u l=0.28u
X187 lvds_lane_1.tp.0 lvds_lane_0.VBP.0 VDD VDD pfet_03v3 ad=1.3p pd=5.52u as=1.3p ps=5.52u w=5u l=1u
X188 lvds_lane_2.fa.0 lvds_lane_0.VBN.0 VSS VSS nfet_03v3 ad=0.65p pd=3.02u as=0.65p ps=3.02u w=2.5u l=1u
X189 VSS VSS lvds_lane_1.d2b.0 VSS nfet_03v3 ad=1.9228p pd=9.62u as=1.1362p ps=4.89u w=4.37u l=0.5u
X190 lvds_lane_0.fa.0 lvds_lane_0.gp.0 lvds_lane_0.tp.0 lvds_lane_0.tp.0 pfet_03v3 ad=1.248p pd=5.32u as=1.248p ps=5.32u w=4.8u l=0.4u
X191 lvds_lane_0.tp.0 lvds_lane_0.VREF.0 lvds_lane_0.fa.0 lvds_lane_0.tp.0 pfet_03v3 ad=1.248p pd=5.32u as=1.248p ps=5.32u w=4.8u l=0.4u
X192 lvds_lane_1.fb.0 lvds_lane_1.gn.0 lvds_lane_1.tp.0 lvds_lane_1.tp.0 pfet_03v3 ad=1.248p pd=5.32u as=1.248p ps=5.32u w=4.8u l=0.4u
X193 lvds_lane_0.ob.0 VSS VSS VSS nfet_03v3 ad=1.1752p pd=5.04u as=1.9888p ps=9.92u w=4.52u l=0.5u
X194 VSS lvds_lane_0.VBN.0 lvds_lane_1.fb.0 VSS nfet_03v3 ad=0.65p pd=3.02u as=0.65p ps=3.02u w=2.5u l=1u
X195 lvds_lane_2.tn.0 lvds_lane_0.VBN.0 VSS VSS nfet_03v3 ad=0.65p pd=3.02u as=0.65p ps=3.02u w=2.5u l=1u
X196 lvds_lane_2.tp.0 lvds_lane_0.VBP.0 VDD VDD pfet_03v3 ad=1.3p pd=5.52u as=1.3p ps=5.52u w=5u l=1u
D2 VSS lvds_lane_1.gn.0 diode_nd2ps_03v3 pj=26u area=40p
X197 lvds_lane_2.fb.0 lvds_lane_0.VREF.0 lvds_lane_2.tp.0 lvds_lane_2.tp.0 pfet_03v3 ad=1.248p pd=5.32u as=1.248p ps=5.32u w=4.8u l=0.4u
X198 VSS lvds_lane_0.VBN.0 lvds_lane_1.ts.0 VSS nfet_03v3 ad=0.65p pd=3.02u as=0.65p ps=3.02u w=2.5u l=1u
X199 lvds_lane_2.d2a.0 VSS VSS VSS nfet_03v3 ad=1.1362p pd=4.89u as=1.9228p ps=9.62u w=4.37u l=0.5u
X200 lvds_lane_2.tp.0 lvds_lane_0.VBP.0 VDD VDD pfet_03v3 ad=1.3p pd=5.52u as=1.3p ps=5.52u w=5u l=1u
X201 lvds_lane_2.oa.0 lvds_lane_0.VREF.0 lvds_lane_2.tn.0 VSS nfet_03v3 ad=1.235p pd=5.27u as=1.235p ps=5.27u w=4.75u l=0.5u
X202 lvds_lane_1.i2.0 VDD VDD VDD pfet_03v3 ad=0.975p pd=4.27u as=1.65p ps=8.38u w=3.75u l=0.28u
X203 lvds_lane_0.VB2.0 VSS VSS VSS nfet_03v3 ad=2.0566p pd=8.43u as=3.4804p ps=16.7u w=7.91u l=0.5u
X204 VSS lvds_lane_0.VBN.0 lvds_lane_1.ts.0 VSS nfet_03v3 ad=0.65p pd=3.02u as=0.65p ps=3.02u w=2.5u l=1u
X205 VSS VSS VSS ppolyf_u_1k r_width=2u r_length=9.11u
X206 lvds_lane_1.fb.0 lvds_lane_0.VREF.0 lvds_lane_1.tp.0 lvds_lane_1.tp.0 pfet_03v3 ad=1.248p pd=5.32u as=1.248p ps=5.32u w=4.8u l=0.4u
X207 lvds_lane_0.tp.0 lvds_lane_0.gn.0 lvds_lane_0.fb.0 lvds_lane_0.tp.0 pfet_03v3 ad=1.248p pd=5.32u as=1.248p ps=5.32u w=4.8u l=0.4u
X208 lvds_lane_2.fb.0 lvds_lane_2.gn.0 lvds_lane_2.tp.0 lvds_lane_2.tp.0 pfet_03v3 ad=1.248p pd=5.32u as=1.248p ps=5.32u w=4.8u l=0.4u
X209 lvds_lane_0.fb.0 lvds_lane_0.VBN.0 VSS VSS nfet_03v3 ad=0.65p pd=3.02u as=0.65p ps=3.02u w=2.5u l=1u
X210 lvds_lane_2.ob.0 lvds_lane_2.gn.0 lvds_lane_2.tn.0 VSS nfet_03v3 ad=1.235p pd=5.27u as=1.235p ps=5.27u w=4.75u l=0.5u
X211 VDD lvds_lane_0.VBP.0 lvds_lane_1.tp.0 VDD pfet_03v3 ad=1.3p pd=5.52u as=1.3p ps=5.52u w=5u l=1u
X212 lvds_lane_1.fa.0 lvds_lane_0.VREF.0 lvds_lane_1.tp.0 lvds_lane_1.tp.0 pfet_03v3 ad=1.248p pd=5.32u as=1.248p ps=5.32u w=4.8u l=0.4u
X213 lvds_lane_2.tp.0 lvds_lane_2.gp.0 lvds_lane_2.fa.0 lvds_lane_2.tp.0 pfet_03v3 ad=1.248p pd=5.32u as=1.248p ps=5.32u w=4.8u l=0.4u
X214 lvds_lane_0.tp.0 lvds_lane_0.VBP.0 VDD VDD pfet_03v3 ad=1.3p pd=5.52u as=1.3p ps=5.52u w=5u l=1u
X215 VDD VDD VDD VDD pfet_03v3 ad=0.52p pd=2.52u as=0 ps=0 w=2u l=0.5u
X216 lvds_lane_0.VBP.0 VDD VDD VDD pfet_03v3 ad=1.3p pd=5.52u as=2.2p ps=10.88u w=5u l=1u
X217 lvds_lane_2.oa.0 lvds_lane_2.gp.0 lvds_lane_2.tn.0 VSS nfet_03v3 ad=1.235p pd=5.27u as=1.235p ps=5.27u w=4.75u l=0.5u
X218 VSS VSS lvds_lane_1.fa.0 VSS nfet_03v3 ad=1.9888p pd=9.92u as=1.1752p ps=5.04u w=4.52u l=0.5u
X219 lvds_lane_0.n3a.0 lvds_lane_0.d2a.0 VDD VDD pfet_03v3 ad=0.52p pd=2.52u as=0.52p ps=2.52u w=2u l=0.28u
X220 VSS lvds_lane_0.VBN.0 lvds_lane_2.fa.0 VSS nfet_03v3 ad=0.65p pd=3.02u as=0.65p ps=3.02u w=2.5u l=1u
X221 lvds_lane_0.tn.0 lvds_lane_0.gp.0 lvds_lane_0.oa.0 VSS nfet_03v3 ad=1.235p pd=5.27u as=1.235p ps=5.27u w=4.75u l=0.5u
X222 VDD lvds_lane_0.VBP.0 lvds_lane_0.VBP.0 VDD pfet_03v3 ad=1.3p pd=5.52u as=1.3p ps=5.52u w=5u l=1u
X223 lvds_lane_0.fb.0 lvds_lane_0.gn.0 lvds_lane_0.tp.0 lvds_lane_0.tp.0 pfet_03v3 ad=1.248p pd=5.32u as=1.248p ps=5.32u w=4.8u l=0.4u
X224 lvds_lane_1.tp.0 lvds_lane_0.VREF.0 lvds_lane_1.fb.0 lvds_lane_1.tp.0 pfet_03v3 ad=1.248p pd=5.32u as=1.248p ps=5.32u w=4.8u l=0.4u
X225 VSS lvds_lane_0.VBN.0 lvds_lane_0.fb.0 VSS nfet_03v3 ad=0.65p pd=3.02u as=0.65p ps=3.02u w=2.5u l=1u
X226 VDD lvds_lane_0.VBP.0 lvds_lane_2.tp.0 VDD pfet_03v3 ad=1.3p pd=5.52u as=1.3p ps=5.52u w=5u l=1u
X227 lvds_lane_1.fa.0 lvds_lane_1.gp.0 lvds_lane_1.tp.0 lvds_lane_1.tp.0 pfet_03v3 ad=1.248p pd=5.32u as=1.248p ps=5.32u w=4.8u l=0.4u
X228 lvds_lane_1.oa.0 lvds_lane_0.VB2.0 lvds_lane_1.fa.0 VSS nfet_03v3 ad=1.1752p pd=5.04u as=1.1752p ps=5.04u w=4.52u l=0.5u
X229 VSS VSS lvds_lane_2.tn.0 VSS nfet_03v3 ad=1.1p pd=5.88u as=0.65p ps=3.02u w=2.5u l=1u
X230 VSS lvds_lane_0.VBN.0 lvds_lane_1.fa.0 VSS nfet_03v3 ad=0.65p pd=3.02u as=0.65p ps=3.02u w=2.5u l=1u
X231 VSS VSS VSS ppolyf_u_1k r_width=2u r_length=22.27u
X232 lvds_lane_0.fb.0 lvds_lane_0.VREF.0 lvds_lane_0.tp.0 lvds_lane_0.tp.0 pfet_03v3 ad=1.248p pd=5.32u as=1.248p ps=5.32u w=4.8u l=0.4u
X233 lvds_lane_0.tn.0 lvds_lane_0.gp.0 lvds_lane_0.oa.0 VSS nfet_03v3 ad=1.235p pd=5.27u as=1.235p ps=5.27u w=4.75u l=0.5u
X234 VDD lvds_lane_0.d2a.0 lvds_lane_0.d2a.0 VDD pfet_03v3 ad=0.52p pd=2.52u as=0.52p ps=2.52u w=2u l=0.28u
X235 VDD lvds_lane_0.VBP.0 lvds_lane_2.tp.0 VDD pfet_03v3 ad=1.3p pd=5.52u as=1.3p ps=5.52u w=5u l=1u
X236 lvds_lane_2.tp.0 lvds_lane_2.gn.0 lvds_lane_2.fb.0 lvds_lane_2.tp.0 pfet_03v3 ad=1.248p pd=5.32u as=1.248p ps=5.32u w=4.8u l=0.4u
X237 lvds_lane_1.tp.0 lvds_lane_1.gp.0 lvds_lane_1.fa.0 lvds_lane_1.tp.0 pfet_03v3 ad=1.248p pd=5.32u as=1.248p ps=5.32u w=4.8u l=0.4u
X238 lvds_lane_0.tn.0 lvds_lane_0.gn.0 lvds_lane_0.ob.0 VSS nfet_03v3 ad=1.235p pd=5.27u as=1.235p ps=5.27u w=4.75u l=0.5u
X239 lvds_bias_0.nrb.0 VDD VDD VDD pfet_03v3 ad=1.3p pd=5.52u as=2.2p ps=10.88u w=5u l=0.5u
X240 lvds_lane_2.fa.0 lvds_lane_0.VBN.0 VSS VSS nfet_03v3 ad=0.65p pd=3.02u as=0.65p ps=3.02u w=2.5u l=1u
X241 VSS VSS lvds_lane_0.VBP.0 VSS nfet_03v3 ad=1.1p pd=5.88u as=0.65p ps=3.02u w=2.5u l=1u
X242 VDD lvds_lane_1.d2b.0 lvds_lane_1.d3.0 VDD pfet_03v3 ad=0.52p pd=2.52u as=0.52p ps=2.52u w=2u l=0.28u
X243 VDD lvds_lane_0.d2b.0 lvds_lane_0.d2b.0 VDD pfet_03v3 ad=0.52p pd=2.52u as=0.52p ps=2.52u w=2u l=0.28u
X244 lvds_lane_2.tn.0 lvds_lane_0.VREF.0 lvds_lane_2.ob.0 VSS nfet_03v3 ad=1.235p pd=5.27u as=2.09p ps=10.38u w=4.75u l=0.5u
X245 lvds_lane_2.tn.0 lvds_lane_0.VREF.0 lvds_lane_2.oa.0 VSS nfet_03v3 ad=1.235p pd=5.27u as=1.235p ps=5.27u w=4.75u l=0.5u
X246 lvds_lane_2.tp.0 lvds_lane_0.VBP.0 VDD VDD pfet_03v3 ad=1.3p pd=5.52u as=1.3p ps=5.52u w=5u l=1u
X247 lvds_lane_0.fb.0 lvds_lane_0.gn.0 lvds_lane_0.tp.0 lvds_lane_0.tp.0 pfet_03v3 ad=1.248p pd=5.32u as=1.248p ps=5.32u w=4.8u l=0.4u
X248 lvds_lane_1.d3.0 lvds_lane_1.n3a.0 VSS VSS nfet_03v3 ad=0.6734p pd=3.11u as=0.6734p ps=3.11u w=2.59u l=0.28u
X249 VSS VSS VSS VSS nfet_03v3 ad=0.52p pd=2.52u as=0 ps=0 w=2u l=0.5u
X250 lvds_bias_0.rb_m1.0 lvds_bias_0.nrb.0 VSS ppolyf_u_1k r_width=2u r_length=22.27u
X251 lvds_lane_0.tp.0 lvds_lane_0.VREF.0 lvds_lane_0.fa.0 lvds_lane_0.tp.0 pfet_03v3 ad=1.248p pd=5.32u as=1.248p ps=5.32u w=4.8u l=0.4u
X252 VSS lvds_lane_1.i1.0 lvds_lane_1.i2.0 VSS nfet_03v3 ad=0.78p pd=3.52u as=0.78p ps=3.52u w=3u l=0.28u
X253 VSS lvds_lane_1.i2.0 RX1_O VSS nfet_03v3 ad=1.04p pd=4.52u as=1.04p ps=4.52u w=4u l=0.28u
X254 lvds_lane_2.fb.0 lvds_lane_2.gn.0 lvds_lane_2.tp.0 lvds_lane_2.tp.0 pfet_03v3 ad=1.248p pd=5.32u as=1.248p ps=5.32u w=4.8u l=0.4u
X255 lvds_lane_1.oa.0 lvds_lane_1.gp.0 lvds_lane_1.tn.0 VSS nfet_03v3 ad=1.235p pd=5.27u as=1.235p ps=5.27u w=4.75u l=0.5u
X256 VDD VDD lvds_lane_1.tp.0 VDD pfet_03v3 ad=2.2p pd=10.88u as=1.3p ps=5.52u w=5u l=1u
X257 lvds_lane_2.fb.0 lvds_lane_0.VREF.0 lvds_lane_2.tp.0 lvds_lane_2.tp.0 pfet_03v3 ad=1.248p pd=5.32u as=1.248p ps=5.32u w=4.8u l=0.4u
X258 lvds_lane_0.VBN.0 VSS VSS VSS nfet_03v3 ad=0.52p pd=2.52u as=0.88p ps=4.88u w=2u l=0.5u
X259 VDD lvds_lane_1.d3.0 lvds_lane_1.nd.0 VDD pfet_03v3 ad=0.78p pd=3.52u as=0.78p ps=3.52u w=3u l=0.28u
X260 lvds_lane_0.tp.0 lvds_lane_0.VREF.0 lvds_lane_0.fa.0 lvds_lane_0.tp.0 pfet_03v3 ad=1.248p pd=5.32u as=1.248p ps=5.32u w=4.8u l=0.4u
X261 lvds_lane_1.fb.0 lvds_lane_1.gn.0 lvds_lane_1.tp.0 lvds_lane_1.tp.0 pfet_03v3 ad=1.248p pd=5.32u as=1.248p ps=5.32u w=4.8u l=0.4u
X262 lvds_lane_1.ob.0 lvds_lane_0.VREF.0 lvds_lane_1.tn.0 VSS nfet_03v3 ad=1.235p pd=5.27u as=1.235p ps=5.27u w=4.75u l=0.5u
X263 lvds_lane_1.fb.0 lvds_lane_0.VBN.0 VSS VSS nfet_03v3 ad=0.65p pd=3.02u as=0.65p ps=3.02u w=2.5u l=1u
X264 VSS lvds_lane_0.VBN.0 lvds_lane_2.tn.0 VSS nfet_03v3 ad=0.65p pd=3.02u as=0.65p ps=3.02u w=2.5u l=1u
X265 lvds_lane_2.d2a.0 lvds_lane_2.d2a.0 VDD VDD pfet_03v3 ad=0.52p pd=2.52u as=0.52p ps=2.52u w=2u l=0.28u
X266 VDD VDD VDD VDD pfet_03v3 ad=0.52p pd=2.52u as=0 ps=0 w=2u l=0.5u
X267 lvds_lane_1.d2b.0 lvds_lane_1.d2b.0 VDD VDD pfet_03v3 ad=0.52p pd=2.52u as=0.52p ps=2.52u w=2u l=0.28u
X268 lvds_lane_0.fa.0 lvds_lane_0.VREF.0 lvds_lane_0.tp.0 lvds_lane_0.tp.0 pfet_03v3 ad=1.248p pd=5.32u as=1.248p ps=5.32u w=4.8u l=0.4u
X269 lvds_lane_1.tp.0 lvds_lane_1.gp.0 lvds_lane_1.fa.0 lvds_lane_1.tp.0 pfet_03v3 ad=1.248p pd=5.32u as=1.248p ps=5.32u w=4.8u l=0.4u
X270 lvds_lane_1.tp.0 lvds_lane_1.gp.0 lvds_lane_1.fa.0 lvds_lane_1.tp.0 pfet_03v3 ad=1.248p pd=5.32u as=1.248p ps=5.32u w=4.8u l=0.4u
X271 lvds_lane_2.tp.0 lvds_lane_0.VREF.0 lvds_lane_2.fa.0 lvds_lane_2.tp.0 pfet_03v3 ad=1.248p pd=5.32u as=1.248p ps=5.32u w=4.8u l=0.4u
X272 lvds_lane_0.d3.0 lvds_lane_0.d2b.0 VDD VDD pfet_03v3 ad=0.52p pd=2.52u as=0.52p ps=2.52u w=2u l=0.28u
X273 RX1_O lvds_lane_1.i2.0 VDD VDD pfet_03v3 ad=1.3p pd=5.52u as=1.3p ps=5.52u w=5u l=0.28u
X274 lvds_lane_2.d2b.0 VSS VSS VSS nfet_03v3 ad=1.1362p pd=4.89u as=1.9228p ps=9.62u w=4.37u l=0.5u
X275 lvds_lane_0.tp.0 lvds_lane_0.gn.0 lvds_lane_0.fb.0 lvds_lane_0.tp.0 pfet_03v3 ad=1.248p pd=5.32u as=1.248p ps=5.32u w=4.8u l=0.4u
X276 VSS lvds_lane_2.n3a.0 lvds_lane_2.n3a.0 VSS nfet_03v3 ad=0.6734p pd=3.11u as=0.6734p ps=3.11u w=2.59u l=0.28u
X277 lvds_lane_0.d2b.0 lvds_lane_0.d2a.0 VDD VDD pfet_03v3 ad=0.52p pd=2.52u as=0.52p ps=2.52u w=2u l=0.28u
X278 lvds_lane_1.fa.0 lvds_lane_1.gp.0 lvds_lane_1.tp.0 lvds_lane_1.tp.0 pfet_03v3 ad=1.248p pd=5.32u as=1.248p ps=5.32u w=4.8u l=0.4u
X279 lvds_bias_0.nmid.0 lvds_bias_0.rdb_m3.0 VSS ppolyf_u_1k r_width=2u r_length=19.26u
X280 VSS VSS VSS ppolyf_u_1k r_width=2u r_length=3.17u
X281 lvds_lane_0.sa.0 lvds_lane_0.oa.0 lvds_lane_0.d2a.0 VSS nfet_03v3 ad=1.1362p pd=4.89u as=1.1362p ps=4.89u w=4.37u l=0.5u
X282 VSS VSS lvds_lane_1.ts.0 VSS nfet_03v3 ad=1.1p pd=5.88u as=0.65p ps=3.02u w=2.5u l=1u
X283 lvds_lane_2.tn.0 lvds_lane_0.VREF.0 lvds_lane_2.oa.0 VSS nfet_03v3 ad=1.235p pd=5.27u as=1.235p ps=5.27u w=4.75u l=0.5u
X284 lvds_lane_2.nd.0 VDD VDD VDD pfet_03v3 ad=0.78p pd=3.52u as=1.32p ps=6.88u w=3u l=0.28u
X285 lvds_lane_0.fa.0 lvds_lane_0.gp.0 lvds_lane_0.tp.0 lvds_lane_0.tp.0 pfet_03v3 ad=1.248p pd=5.32u as=1.248p ps=5.32u w=4.8u l=0.4u
X286 VDD VDD lvds_lane_1.d2b.0 VDD pfet_03v3 ad=0.88p pd=4.88u as=0.52p ps=2.52u w=2u l=0.28u
X287 lvds_lane_2.fb.0 lvds_lane_0.VB2.0 lvds_lane_2.ob.0 VSS nfet_03v3 ad=1.1752p pd=5.04u as=1.1752p ps=5.04u w=4.52u l=0.5u
X288 lvds_lane_0.ob.0 lvds_lane_0.VREF.0 lvds_lane_0.tn.0 VSS nfet_03v3 ad=2.09p pd=10.38u as=1.235p ps=5.27u w=4.75u l=0.5u
X289 lvds_lane_1.tn.0 lvds_lane_1.gn.0 lvds_lane_1.ob.0 VSS nfet_03v3 ad=1.235p pd=5.27u as=1.235p ps=5.27u w=4.75u l=0.5u
X290 lvds_lane_2.n3a.0 lvds_lane_2.d2a.0 VDD VDD pfet_03v3 ad=0.52p pd=2.52u as=0.52p ps=2.52u w=2u l=0.28u
X291 lvds_lane_1.i2.0 VSS VSS VSS nfet_03v3 ad=0.78p pd=3.52u as=1.32p ps=6.88u w=3u l=0.28u
X292 VDD lvds_lane_0.VBP.0 lvds_lane_0.tp.0 VDD pfet_03v3 ad=1.3p pd=5.52u as=1.3p ps=5.52u w=5u l=1u
X293 lvds_lane_1.tp.0 lvds_lane_0.VREF.0 lvds_lane_1.fb.0 lvds_lane_1.tp.0 pfet_03v3 ad=1.248p pd=5.32u as=1.248p ps=5.32u w=4.8u l=0.4u
X294 lvds_lane_2.fa.0 lvds_lane_2.gp.0 lvds_lane_2.tp.0 lvds_lane_2.tp.0 pfet_03v3 ad=1.248p pd=5.32u as=1.248p ps=5.32u w=4.8u l=0.4u
X295 lvds_lane_0.oa.0 lvds_lane_0.VB2.0 lvds_lane_0.fa.0 VSS nfet_03v3 ad=1.1752p pd=5.04u as=1.1752p ps=5.04u w=4.52u l=0.5u
X296 VSS lvds_lane_0.VBN.0 lvds_lane_0.fb.0 VSS nfet_03v3 ad=0.65p pd=3.02u as=0.65p ps=3.02u w=2.5u l=1u
X297 RX1_O VSS VSS VSS nfet_03v3 ad=1.04p pd=4.52u as=1.76p ps=8.88u w=4u l=0.28u
X298 VSS VSS lvds_lane_0.fb.0 VSS nfet_03v3 ad=1.9888p pd=9.92u as=1.1752p ps=5.04u w=4.52u l=0.5u
X299 VSS VSS VSS VSS nfet_03v3 ad=0.39p pd=2.02u as=0 ps=0 w=1.5u l=0.28u
X300 VDD lvds_lane_0.VBP.0 lvds_lane_1.tp.0 VDD pfet_03v3 ad=1.3p pd=5.52u as=1.3p ps=5.52u w=5u l=1u
X301 lvds_bias_0.rb_m1.0 lvds_bias_0.rb_m2.0 VSS ppolyf_u_1k r_width=2u r_length=22.27u
X302 VDD EN lvds_lane_0.VBP.0 VDD pfet_03v3 ad=0.52p pd=2.52u as=0.52p ps=2.52u w=2u l=0.5u
X303 lvds_lane_2.oa.0 lvds_lane_2.rla_m1.0 VSS ppolyf_u_1k r_width=2u r_length=9.11u
X304 lvds_lane_2.ts.0 lvds_lane_0.VBN.0 VSS VSS nfet_03v3 ad=0.65p pd=3.02u as=0.65p ps=3.02u w=2.5u l=1u
X305 VDD lvds_lane_0.VBP.0 lvds_lane_0.tp.0 VDD pfet_03v3 ad=1.3p pd=5.52u as=1.3p ps=5.52u w=5u l=1u
X306 lvds_lane_2.tp.0 lvds_lane_0.VREF.0 lvds_lane_2.fa.0 lvds_lane_2.tp.0 pfet_03v3 ad=1.248p pd=5.32u as=1.248p ps=5.32u w=4.8u l=0.4u
X307 VDD lvds_lane_1.d2b.0 lvds_lane_1.d2a.0 VDD pfet_03v3 ad=0.52p pd=2.52u as=0.52p ps=2.52u w=2u l=0.28u
X308 lvds_lane_0.oa.0 VSS VSS VSS nfet_03v3 ad=1.1752p pd=5.04u as=1.9888p ps=9.92u w=4.52u l=0.5u
X309 VDD VDD lvds_lane_2.n3a.0 VDD pfet_03v3 ad=0.88p pd=4.88u as=0.52p ps=2.52u w=2u l=0.28u
X310 lvds_lane_2.tp.0 lvds_lane_0.VREF.0 lvds_lane_2.fb.0 lvds_lane_2.tp.0 pfet_03v3 ad=1.248p pd=5.32u as=1.248p ps=5.32u w=4.8u l=0.4u
X311 VSS VSS VSS VSS nfet_03v3 ad=0.78p pd=3.52u as=0 ps=0 w=3u l=0.28u
X312 VSS lvds_lane_0.VBN.0 lvds_lane_0.VBP.0 VSS nfet_03v3 ad=0.65p pd=3.02u as=0.65p ps=3.02u w=2.5u l=1u
X313 VDD lvds_lane_0.d2a.0 lvds_lane_0.n3a.0 VDD pfet_03v3 ad=0.52p pd=2.52u as=0.52p ps=2.52u w=2u l=0.28u
X314 lvds_lane_0.ts.0 lvds_lane_0.VBN.0 VSS VSS nfet_03v3 ad=0.65p pd=3.02u as=0.65p ps=3.02u w=2.5u l=1u
X315 VSS VSS VSS VSS nfet_03v3 ad=0.6734p pd=3.11u as=0 ps=0 w=2.59u l=0.28u
X316 lvds_lane_0.tp.0 lvds_lane_0.gn.0 lvds_lane_0.fb.0 lvds_lane_0.tp.0 pfet_03v3 ad=1.248p pd=5.32u as=1.248p ps=5.32u w=4.8u l=0.4u
X317 lvds_lane_2.fa.0 lvds_lane_0.VREF.0 lvds_lane_2.tp.0 lvds_lane_2.tp.0 pfet_03v3 ad=1.248p pd=5.32u as=1.248p ps=5.32u w=4.8u l=0.4u
X318 VDD lvds_lane_1.i2.0 RX1_O VDD pfet_03v3 ad=1.3p pd=5.52u as=1.3p ps=5.52u w=5u l=0.28u
X319 lvds_lane_1.fb.0 lvds_lane_0.VREF.0 lvds_lane_1.tp.0 lvds_lane_1.tp.0 pfet_03v3 ad=1.248p pd=5.32u as=1.248p ps=5.32u w=4.8u l=0.4u
X320 lvds_lane_0.oa.0 lvds_lane_0.gp.0 lvds_lane_0.tn.0 VSS nfet_03v3 ad=1.235p pd=5.27u as=1.235p ps=5.27u w=4.75u l=0.5u
X321 lvds_lane_1.tn.0 lvds_lane_0.VREF.0 lvds_lane_1.oa.0 VSS nfet_03v3 ad=1.235p pd=5.27u as=1.235p ps=5.27u w=4.75u l=0.5u
X322 lvds_lane_0.d2b.0 lvds_lane_0.d2b.0 VDD VDD pfet_03v3 ad=0.52p pd=2.52u as=0.52p ps=2.52u w=2u l=0.28u
X323 lvds_lane_1.tp.0 lvds_lane_0.VREF.0 lvds_lane_1.fb.0 lvds_lane_1.tp.0 pfet_03v3 ad=1.248p pd=5.32u as=1.248p ps=5.32u w=4.8u l=0.4u
X324 VDD VDD lvds_lane_2.nd.0 VDD pfet_03v3 ad=1.32p pd=6.88u as=0.78p ps=3.52u w=3u l=0.28u
X325 lvds_lane_2.d2b.0 lvds_lane_2.d2a.0 VDD VDD pfet_03v3 ad=0.52p pd=2.52u as=0.52p ps=2.52u w=2u l=0.28u
X326 lvds_lane_0.fa.0 lvds_lane_0.gp.0 lvds_lane_0.tp.0 lvds_lane_0.tp.0 pfet_03v3 ad=1.248p pd=5.32u as=1.248p ps=5.32u w=4.8u l=0.4u
X327 lvds_lane_2.tp.0 lvds_lane_2.gn.0 lvds_lane_2.fb.0 lvds_lane_2.tp.0 pfet_03v3 ad=1.248p pd=5.32u as=1.248p ps=5.32u w=4.8u l=0.4u
X328 lvds_lane_0.ob.0 lvds_lane_0.gn.0 lvds_lane_0.tn.0 VSS nfet_03v3 ad=1.235p pd=5.27u as=1.235p ps=5.27u w=4.75u l=0.5u
X329 lvds_lane_0.tp.0 lvds_lane_0.VBP.0 VDD VDD pfet_03v3 ad=1.3p pd=5.52u as=1.3p ps=5.52u w=5u l=1u
X330 VDD lvds_lane_2.i1.0 lvds_lane_2.i2.0 VDD pfet_03v3 ad=0.975p pd=4.27u as=0.975p ps=4.27u w=3.75u l=0.28u
X331 lvds_lane_1.n3a.0 lvds_lane_1.d2a.0 VDD VDD pfet_03v3 ad=0.52p pd=2.52u as=0.52p ps=2.52u w=2u l=0.28u
X332 lvds_lane_0.d2a.0 lvds_lane_0.d2a.0 VDD VDD pfet_03v3 ad=0.52p pd=2.52u as=0.52p ps=2.52u w=2u l=0.28u
X333 lvds_lane_0.ts.0 lvds_lane_0.sb.0 VSS ppolyf_u_1k r_width=2u r_length=3.17u
X334 lvds_lane_1.gp.0 RX1_P VDD ppolyf_u r_width=5u r_length=1.8u
X335 lvds_lane_0.ob.0 lvds_lane_0.VREF.0 lvds_lane_0.tn.0 VSS nfet_03v3 ad=1.235p pd=5.27u as=1.235p ps=5.27u w=4.75u l=0.5u
X336 VSS lvds_lane_0.VBN.0 lvds_lane_0.fa.0 VSS nfet_03v3 ad=0.65p pd=3.02u as=0.65p ps=3.02u w=2.5u l=1u
X337 VSS VSS VSS VSS nfet_03v3 ad=1.1396p pd=6.06u as=0 ps=0 w=2.59u l=0.28u
X338 lvds_lane_2.ob.0 lvds_lane_2.gn.0 lvds_lane_2.tn.0 VSS nfet_03v3 ad=1.235p pd=5.27u as=1.235p ps=5.27u w=4.75u l=0.5u
X339 lvds_lane_1.tp.0 lvds_lane_0.VBP.0 VDD VDD pfet_03v3 ad=1.3p pd=5.52u as=1.3p ps=5.52u w=5u l=1u
X340 lvds_lane_0.fa.0 lvds_lane_0.VREF.0 lvds_lane_0.tp.0 lvds_lane_0.tp.0 pfet_03v3 ad=1.248p pd=5.32u as=1.248p ps=5.32u w=4.8u l=0.4u
X341 lvds_lane_1.fa.0 lvds_lane_0.VREF.0 lvds_lane_1.tp.0 lvds_lane_1.tp.0 pfet_03v3 ad=1.248p pd=5.32u as=1.248p ps=5.32u w=4.8u l=0.4u
X342 lvds_lane_1.tp.0 lvds_lane_1.gp.0 lvds_lane_1.fa.0 lvds_lane_1.tp.0 pfet_03v3 ad=1.248p pd=5.32u as=1.248p ps=5.32u w=4.8u l=0.4u
X343 VSS lvds_lane_0.VBN.0 lvds_lane_0.tn.0 VSS nfet_03v3 ad=0.65p pd=3.02u as=0.65p ps=3.02u w=2.5u l=1u
X344 lvds_lane_2.ts.0 VSS VSS VSS nfet_03v3 ad=0.65p pd=3.02u as=1.1p ps=5.88u w=2.5u l=1u
X345 lvds_lane_1.d2a.0 VDD VDD VDD pfet_03v3 ad=0.52p pd=2.52u as=0.88p ps=4.88u w=2u l=0.5u
X346 VSS VSS lvds_lane_1.fa.0 VSS nfet_03v3 ad=1.1p pd=5.88u as=0.65p ps=3.02u w=2.5u l=1u
X347 lvds_lane_2.ob.0 lvds_lane_2.gn.0 lvds_lane_2.tn.0 VSS nfet_03v3 ad=1.235p pd=5.27u as=1.235p ps=5.27u w=4.75u l=0.5u
X348 VSS lvds_lane_0.VBN.0 lvds_lane_0.ts.0 VSS nfet_03v3 ad=0.65p pd=3.02u as=0.65p ps=3.02u w=2.5u l=1u
X349 VSS lvds_lane_0.i2.0 RX0_O VSS nfet_03v3 ad=1.04p pd=4.52u as=1.04p ps=4.52u w=4u l=0.28u
X350 VSS lvds_lane_0.i1.0 lvds_lane_0.i2.0 VSS nfet_03v3 ad=0.78p pd=3.52u as=0.78p ps=3.52u w=3u l=0.28u
X351 lvds_lane_0.tn.0 lvds_lane_0.gn.0 lvds_lane_0.ob.0 VSS nfet_03v3 ad=1.235p pd=5.27u as=1.235p ps=5.27u w=4.75u l=0.5u
X352 lvds_bias_0.nrb.0 lvds_bias_0.enb.0 VDD VDD pfet_03v3 ad=1.3p pd=5.52u as=1.3p ps=5.52u w=5u l=0.5u
X353 lvds_lane_2.oa.0 lvds_lane_2.gp.0 lvds_lane_2.tn.0 VSS nfet_03v3 ad=1.235p pd=5.27u as=1.235p ps=5.27u w=4.75u l=0.5u
X354 VDD lvds_lane_2.d2b.0 lvds_lane_2.d2a.0 VDD pfet_03v3 ad=0.52p pd=2.52u as=0.52p ps=2.52u w=2u l=0.28u
X355 lvds_lane_1.fa.0 lvds_lane_0.VREF.0 lvds_lane_1.tp.0 lvds_lane_1.tp.0 pfet_03v3 ad=1.248p pd=5.32u as=1.248p ps=5.32u w=4.8u l=0.4u
X356 lvds_lane_1.oa.0 lvds_lane_0.VB2.0 lvds_lane_1.fa.0 VSS nfet_03v3 ad=1.1752p pd=5.04u as=1.1752p ps=5.04u w=4.52u l=0.5u
X357 lvds_lane_0.fb.0 lvds_lane_0.gn.0 lvds_lane_0.tp.0 lvds_lane_0.tp.0 pfet_03v3 ad=1.248p pd=5.32u as=1.248p ps=5.32u w=4.8u l=0.4u
X358 lvds_lane_0.tn.0 lvds_lane_0.gp.0 lvds_lane_0.oa.0 VSS nfet_03v3 ad=1.235p pd=5.27u as=1.235p ps=5.27u w=4.75u l=0.5u
X359 VDD lvds_lane_2.d2a.0 lvds_lane_2.d2b.0 VDD pfet_03v3 ad=0.52p pd=2.52u as=0.52p ps=2.52u w=2u l=0.28u
X360 VDD lvds_lane_0.d2b.0 lvds_lane_0.d3.0 VDD pfet_03v3 ad=0.52p pd=2.52u as=0.52p ps=2.52u w=2u l=0.28u
X361 lvds_lane_2.tp.0 lvds_lane_2.gp.0 lvds_lane_2.fa.0 lvds_lane_2.tp.0 pfet_03v3 ad=1.248p pd=5.32u as=1.248p ps=5.32u w=4.8u l=0.4u
X362 lvds_bias_0.nrb.0 lvds_bias_0.enb.0 VDD VDD pfet_03v3 ad=1.3p pd=5.52u as=1.3p ps=5.52u w=5u l=0.5u
X363 lvds_lane_1.fa.0 lvds_lane_0.VREF.0 lvds_lane_1.tp.0 lvds_lane_1.tp.0 pfet_03v3 ad=1.248p pd=5.32u as=1.248p ps=5.32u w=4.8u l=0.4u
X364 lvds_lane_2.fa.0 lvds_lane_2.gp.0 lvds_lane_2.tp.0 lvds_lane_2.tp.0 pfet_03v3 ad=1.248p pd=5.32u as=1.248p ps=5.32u w=4.8u l=0.4u
X365 lvds_lane_0.ts.0 lvds_lane_0.VBN.0 VSS VSS nfet_03v3 ad=0.65p pd=3.02u as=0.65p ps=3.02u w=2.5u l=1u
X366 VDD lvds_lane_0.VBP.0 lvds_lane_0.tp.0 VDD pfet_03v3 ad=1.3p pd=5.52u as=1.3p ps=5.52u w=5u l=1u
D3 lvds_lane_0.gn.0 VDD diode_pd2nw_03v3 pj=26u area=40p
X367 VSS lvds_lane_2.i1.0 lvds_lane_2.i2.0 VSS nfet_03v3 ad=0.78p pd=3.52u as=0.78p ps=3.52u w=3u l=0.28u
X368 VSS lvds_lane_2.i2.0 RX2_O VSS nfet_03v3 ad=1.04p pd=4.52u as=1.04p ps=4.52u w=4u l=0.28u
X369 lvds_lane_0.fb.0 lvds_lane_0.VREF.0 lvds_lane_0.tp.0 lvds_lane_0.tp.0 pfet_03v3 ad=2.112p pd=10.48u as=1.248p ps=5.32u w=4.8u l=0.4u
X370 lvds_lane_2.fa.0 lvds_lane_2.gp.0 lvds_lane_2.tp.0 lvds_lane_2.tp.0 pfet_03v3 ad=1.248p pd=5.32u as=1.248p ps=5.32u w=4.8u l=0.4u
X371 lvds_lane_2.tp.0 lvds_lane_2.gn.0 lvds_lane_2.fb.0 lvds_lane_2.tp.0 pfet_03v3 ad=1.248p pd=5.32u as=1.248p ps=5.32u w=4.8u l=0.4u
X372 lvds_bias_0.nrb.0 lvds_bias_0.enb.0 VDD VDD pfet_03v3 ad=1.3p pd=5.52u as=1.3p ps=5.52u w=5u l=0.5u
X373 RX0_O lvds_lane_0.i2.0 VDD VDD pfet_03v3 ad=1.3p pd=5.52u as=1.3p ps=5.52u w=5u l=0.28u
X374 lvds_lane_1.tn.0 lvds_lane_0.VREF.0 lvds_lane_1.ob.0 VSS nfet_03v3 ad=1.235p pd=5.27u as=1.235p ps=5.27u w=4.75u l=0.5u
X375 lvds_lane_0.fb.0 lvds_lane_0.VBN.0 VSS VSS nfet_03v3 ad=0.65p pd=3.02u as=0.65p ps=3.02u w=2.5u l=1u
X376 lvds_lane_1.ob.0 lvds_lane_1.gn.0 lvds_lane_1.tn.0 VSS nfet_03v3 ad=1.235p pd=5.27u as=1.235p ps=5.27u w=4.75u l=0.5u
X377 lvds_lane_2.tn.0 lvds_lane_0.VREF.0 lvds_lane_2.ob.0 VSS nfet_03v3 ad=1.235p pd=5.27u as=1.235p ps=5.27u w=4.75u l=0.5u
X378 lvds_lane_0.fb.0 lvds_lane_0.VREF.0 lvds_lane_0.tp.0 lvds_lane_0.tp.0 pfet_03v3 ad=1.248p pd=5.32u as=1.248p ps=5.32u w=4.8u l=0.4u
X379 VDD lvds_lane_2.d2a.0 lvds_lane_2.n3a.0 VDD pfet_03v3 ad=0.52p pd=2.52u as=0.52p ps=2.52u w=2u l=0.28u
X380 lvds_lane_1.fa.0 lvds_lane_0.VBN.0 VSS VSS nfet_03v3 ad=0.65p pd=3.02u as=0.65p ps=3.02u w=2.5u l=1u
X381 lvds_lane_0.tn.0 lvds_lane_0.VBN.0 VSS VSS nfet_03v3 ad=0.65p pd=3.02u as=0.65p ps=3.02u w=2.5u l=1u
X382 VDD lvds_lane_1.nd.0 lvds_lane_1.i1.0 VDD pfet_03v3 ad=0.962p pd=4.22u as=0.962p ps=4.22u w=3.7u l=0.28u
X383 VSS lvds_lane_0.VBN.0 lvds_lane_2.ts.0 VSS nfet_03v3 ad=0.65p pd=3.02u as=0.65p ps=3.02u w=2.5u l=1u
X384 lvds_lane_0.tp.0 lvds_lane_0.VBP.0 VDD VDD pfet_03v3 ad=1.3p pd=5.52u as=1.3p ps=5.52u w=5u l=1u
X385 lvds_lane_1.fb.0 lvds_lane_0.VB2.0 lvds_lane_1.ob.0 VSS nfet_03v3 ad=1.1752p pd=5.04u as=1.1752p ps=5.04u w=4.52u l=0.5u
X386 VSS VSS lvds_lane_0.d2b.0 VSS nfet_03v3 ad=1.9228p pd=9.62u as=1.1362p ps=4.89u w=4.37u l=0.5u
X387 lvds_lane_2.fa.0 lvds_lane_2.gp.0 lvds_lane_2.tp.0 lvds_lane_2.tp.0 pfet_03v3 ad=1.248p pd=5.32u as=1.248p ps=5.32u w=4.8u l=0.4u
X388 VSS lvds_lane_0.VBN.0 lvds_lane_0.fb.0 VSS nfet_03v3 ad=0.65p pd=3.02u as=0.65p ps=3.02u w=2.5u l=1u
X389 lvds_lane_1.tn.0 lvds_lane_0.VBN.0 VSS VSS nfet_03v3 ad=0.65p pd=3.02u as=0.65p ps=3.02u w=2.5u l=1u
X390 lvds_lane_1.tp.0 lvds_lane_0.VBP.0 VDD VDD pfet_03v3 ad=1.3p pd=5.52u as=1.3p ps=5.52u w=5u l=1u
X391 lvds_lane_0.fb.0 lvds_lane_0.gn.0 lvds_lane_0.tp.0 lvds_lane_0.tp.0 pfet_03v3 ad=1.248p pd=5.32u as=1.248p ps=5.32u w=4.8u l=0.4u
X392 RX2_O lvds_lane_2.i2.0 VDD VDD pfet_03v3 ad=1.3p pd=5.52u as=1.3p ps=5.52u w=5u l=0.28u
X393 VDD lvds_lane_0.VBP.0 lvds_lane_0.VBP.0 VDD pfet_03v3 ad=1.3p pd=5.52u as=1.3p ps=5.52u w=5u l=1u
X394 VSS lvds_lane_0.VBN.0 lvds_lane_0.ts.0 VSS nfet_03v3 ad=0.65p pd=3.02u as=0.65p ps=3.02u w=2.5u l=1u
X395 lvds_lane_0.i2.0 VSS VSS VSS nfet_03v3 ad=0.78p pd=3.52u as=1.32p ps=6.88u w=3u l=0.28u
X396 lvds_lane_1.d2a.0 VSS VSS VSS nfet_03v3 ad=1.1362p pd=4.89u as=1.9228p ps=9.62u w=4.37u l=0.5u
D4 VSS lvds_lane_0.gn.0 diode_nd2ps_03v3 pj=26u area=40p
X397 RX0_O VSS VSS VSS nfet_03v3 ad=1.04p pd=4.52u as=1.76p ps=8.88u w=4u l=0.28u
X398 VSS VSS VSS VSS nfet_03v3 ad=0.39p pd=2.02u as=0 ps=0 w=1.5u l=0.28u
X399 lvds_lane_1.oa.0 lvds_lane_0.VREF.0 lvds_lane_1.tn.0 VSS nfet_03v3 ad=1.235p pd=5.27u as=1.235p ps=5.27u w=4.75u l=0.5u
X400 lvds_lane_0.i2.0 VDD VDD VDD pfet_03v3 ad=0.975p pd=4.27u as=1.65p ps=8.38u w=3.75u l=0.28u
X401 lvds_lane_1.d2b.0 VDD VDD VDD pfet_03v3 ad=0.52p pd=2.52u as=0.88p ps=4.88u w=2u l=0.5u
X402 lvds_lane_2.fb.0 lvds_lane_0.VBN.0 VSS VSS nfet_03v3 ad=0.65p pd=3.02u as=0.65p ps=3.02u w=2.5u l=1u
X403 VSS lvds_lane_0.VBN.0 lvds_lane_0.ts.0 VSS nfet_03v3 ad=0.65p pd=3.02u as=0.65p ps=3.02u w=2.5u l=1u
X404 VSS VSS VSS VSS nfet_03v3 ad=0.78p pd=3.52u as=0 ps=0 w=3u l=0.28u
X405 VSS VSS VSS ppolyf_u_1k r_width=2u r_length=9.11u
X406 lvds_lane_0.fb.0 lvds_lane_0.VREF.0 lvds_lane_0.tp.0 lvds_lane_0.tp.0 pfet_03v3 ad=1.248p pd=5.32u as=1.248p ps=5.32u w=4.8u l=0.4u
X407 lvds_lane_1.fb.0 lvds_lane_0.VREF.0 lvds_lane_1.tp.0 lvds_lane_1.tp.0 pfet_03v3 ad=1.248p pd=5.32u as=1.248p ps=5.32u w=4.8u l=0.4u
X408 lvds_lane_2.fa.0 lvds_lane_0.VBN.0 VSS VSS nfet_03v3 ad=0.65p pd=3.02u as=0.65p ps=3.02u w=2.5u l=1u
X409 lvds_lane_2.i1.0 VDD VDD VDD pfet_03v3 ad=0.962p pd=4.22u as=1.628p ps=8.28u w=3.7u l=0.28u
X410 VDD lvds_lane_0.VBP.0 lvds_lane_0.tp.0 VDD pfet_03v3 ad=1.3p pd=5.52u as=1.3p ps=5.52u w=5u l=1u
X411 lvds_lane_0.fa.0 lvds_lane_0.VREF.0 lvds_lane_0.tp.0 lvds_lane_0.tp.0 pfet_03v3 ad=1.248p pd=5.32u as=1.248p ps=5.32u w=4.8u l=0.4u
X412 VSS lvds_lane_0.VBN.0 lvds_lane_1.ts.0 VSS nfet_03v3 ad=0.65p pd=3.02u as=0.65p ps=3.02u w=2.5u l=1u
X413 lvds_lane_2.i2.0 VSS VSS VSS nfet_03v3 ad=0.78p pd=3.52u as=1.32p ps=6.88u w=3u l=0.28u
X414 RX2_O VSS VSS VSS nfet_03v3 ad=1.04p pd=4.52u as=1.76p ps=8.88u w=4u l=0.28u
X415 lvds_lane_0.VBP.0 lvds_lane_0.VBN.0 VSS VSS nfet_03v3 ad=0.65p pd=3.02u as=0.65p ps=3.02u w=2.5u l=1u
X416 lvds_lane_2.tp.0 lvds_lane_0.VBP.0 VDD VDD pfet_03v3 ad=1.3p pd=5.52u as=1.3p ps=5.52u w=5u l=1u
X417 lvds_lane_1.tp.0 lvds_lane_1.gp.0 lvds_lane_1.fa.0 lvds_lane_1.tp.0 pfet_03v3 ad=1.248p pd=5.32u as=1.248p ps=5.32u w=4.8u l=0.4u
X418 lvds_lane_2.tp.0 lvds_lane_2.gp.0 lvds_lane_2.fa.0 lvds_lane_2.tp.0 pfet_03v3 ad=1.248p pd=5.32u as=1.248p ps=5.32u w=4.8u l=0.4u
X419 VDD lvds_lane_0.i2.0 RX0_O VDD pfet_03v3 ad=1.3p pd=5.52u as=1.3p ps=5.52u w=5u l=0.28u
X420 VDD VDD VDD VDD pfet_03v3 ad=0.52p pd=2.52u as=0 ps=0 w=2u l=0.5u
X421 VSS VSS lvds_lane_0.fa.0 VSS nfet_03v3 ad=1.9888p pd=9.92u as=1.1752p ps=5.04u w=4.52u l=0.5u
X422 VSS lvds_lane_0.VBN.0 lvds_lane_1.fa.0 VSS nfet_03v3 ad=0.65p pd=3.02u as=0.65p ps=3.02u w=2.5u l=1u
X423 VSS VSS VSS VSS nfet_03v3 ad=0.78p pd=3.52u as=0 ps=0 w=3u l=0.28u
X424 lvds_bias_0.rdt_m2.0 lvds_bias_0.rdt_m1.0 VSS ppolyf_u_1k r_width=2u r_length=21.01u
X425 lvds_lane_0.tp.0 lvds_lane_0.VREF.0 lvds_lane_0.fb.0 lvds_lane_0.tp.0 pfet_03v3 ad=1.248p pd=5.32u as=1.248p ps=5.32u w=4.8u l=0.4u
X426 lvds_lane_2.fa.0 lvds_lane_0.VB2.0 lvds_lane_2.oa.0 VSS nfet_03v3 ad=1.1752p pd=5.04u as=1.1752p ps=5.04u w=4.52u l=0.5u
X427 lvds_lane_0.fa.0 lvds_lane_0.gp.0 lvds_lane_0.tp.0 lvds_lane_0.tp.0 pfet_03v3 ad=1.248p pd=5.32u as=1.248p ps=5.32u w=4.8u l=0.4u
X428 lvds_lane_0.oa.0 lvds_lane_0.VB2.0 lvds_lane_0.fa.0 VSS nfet_03v3 ad=1.1752p pd=5.04u as=1.1752p ps=5.04u w=4.52u l=0.5u
X429 VSS lvds_lane_0.VBN.0 lvds_lane_2.fb.0 VSS nfet_03v3 ad=0.65p pd=3.02u as=0.65p ps=3.02u w=2.5u l=1u
X430 VSS VSS lvds_lane_1.tn.0 VSS nfet_03v3 ad=1.1p pd=5.88u as=0.65p ps=3.02u w=2.5u l=1u
X431 VDD lvds_lane_2.rla_m1.0 VSS ppolyf_u_1k r_width=2u r_length=9.11u
X432 VDD lvds_lane_0.VBP.0 lvds_lane_1.tp.0 VDD pfet_03v3 ad=1.3p pd=5.52u as=1.3p ps=5.52u w=5u l=1u
X433 lvds_lane_2.tp.0 lvds_lane_0.VREF.0 lvds_lane_2.fa.0 lvds_lane_2.tp.0 pfet_03v3 ad=1.248p pd=5.32u as=1.248p ps=5.32u w=4.8u l=0.4u
X434 VSS lvds_lane_0.VBN.0 lvds_lane_0.fa.0 VSS nfet_03v3 ad=0.65p pd=3.02u as=0.65p ps=3.02u w=2.5u l=1u
X435 VDD lvds_lane_2.i2.0 RX2_O VDD pfet_03v3 ad=1.3p pd=5.52u as=1.3p ps=5.52u w=5u l=0.28u
X436 lvds_lane_1.tp.0 lvds_lane_1.gn.0 lvds_lane_1.fb.0 lvds_lane_1.tp.0 pfet_03v3 ad=1.248p pd=5.32u as=1.248p ps=5.32u w=4.8u l=0.4u
X437 lvds_lane_2.fa.0 lvds_lane_0.VB2.0 lvds_lane_2.oa.0 VSS nfet_03v3 ad=1.1752p pd=5.04u as=1.1752p ps=5.04u w=4.52u l=0.5u
X438 VDD lvds_lane_2.rlb_m1.0 VSS ppolyf_u_1k r_width=2u r_length=9.11u
X439 lvds_lane_0.tp.0 lvds_lane_0.gp.0 lvds_lane_0.fa.0 lvds_lane_0.tp.0 pfet_03v3 ad=1.248p pd=5.32u as=1.248p ps=5.32u w=4.8u l=0.4u
X440 lvds_lane_2.fa.0 lvds_lane_2.gp.0 lvds_lane_2.tp.0 lvds_lane_2.tp.0 pfet_03v3 ad=1.248p pd=5.32u as=1.248p ps=5.32u w=4.8u l=0.4u
X441 lvds_lane_2.fa.0 VSS VSS VSS nfet_03v3 ad=0.65p pd=3.02u as=1.1p ps=5.88u w=2.5u l=1u
X442 lvds_bias_0.rb_m3.0 lvds_bias_0.rb_m2.0 VSS ppolyf_u_1k r_width=2u r_length=22.27u
X443 VDD EN lvds_lane_2.d2b.0 VDD pfet_03v3 ad=0.52p pd=2.52u as=0.52p ps=2.52u w=2u l=0.5u
X444 VDD lvds_lane_0.d2b.0 lvds_lane_0.d3.0 VDD pfet_03v3 ad=0.52p pd=2.52u as=0.52p ps=2.52u w=2u l=0.28u
X445 lvds_lane_2.fb.0 lvds_lane_0.VBN.0 VSS VSS nfet_03v3 ad=0.65p pd=3.02u as=0.65p ps=3.02u w=2.5u l=1u
X446 lvds_lane_1.tn.0 lvds_lane_0.VREF.0 lvds_lane_1.ob.0 VSS nfet_03v3 ad=1.235p pd=5.27u as=2.09p ps=10.38u w=4.75u l=0.5u
X447 lvds_lane_1.tn.0 lvds_lane_0.VREF.0 lvds_lane_1.oa.0 VSS nfet_03v3 ad=1.235p pd=5.27u as=1.235p ps=5.27u w=4.75u l=0.5u
X448 lvds_lane_1.ts.0 lvds_lane_0.VBN.0 VSS VSS nfet_03v3 ad=0.65p pd=3.02u as=0.65p ps=3.02u w=2.5u l=1u
X449 VDD lvds_lane_1.d2a.0 lvds_lane_1.d2b.0 VDD pfet_03v3 ad=0.52p pd=2.52u as=0.52p ps=2.52u w=2u l=0.28u
X450 VSS VSS VSS ppolyf_u_1k r_width=2u r_length=3.17u
X451 lvds_lane_2.tp.0 lvds_lane_0.VBP.0 VDD VDD pfet_03v3 ad=1.3p pd=5.52u as=1.3p ps=5.52u w=5u l=1u
X452 lvds_lane_1.fb.0 lvds_lane_1.gn.0 lvds_lane_1.tp.0 lvds_lane_1.tp.0 pfet_03v3 ad=1.248p pd=5.32u as=1.248p ps=5.32u w=4.8u l=0.4u
X453 lvds_lane_0.oa.0 lvds_lane_0.gp.0 lvds_lane_0.tn.0 VSS nfet_03v3 ad=1.235p pd=5.27u as=1.235p ps=5.27u w=4.75u l=0.5u
X454 lvds_lane_1.i2.0 lvds_lane_1.i1.0 VDD VDD pfet_03v3 ad=0.975p pd=4.27u as=0.975p ps=4.27u w=3.75u l=0.28u
X455 VDD VDD lvds_lane_0.tp.0 VDD pfet_03v3 ad=2.2p pd=10.88u as=1.3p ps=5.52u w=5u l=1u
X456 lvds_lane_1.tp.0 lvds_lane_0.VREF.0 lvds_lane_1.fb.0 lvds_lane_1.tp.0 pfet_03v3 ad=1.248p pd=5.32u as=1.248p ps=5.32u w=4.8u l=0.4u
D5 lvds_lane_2.gp.0 VDD diode_pd2nw_03v3 pj=26u area=40p
X457 lvds_lane_2.tp.0 lvds_lane_0.VREF.0 lvds_lane_2.fb.0 lvds_lane_2.tp.0 pfet_03v3 ad=1.248p pd=5.32u as=1.248p ps=5.32u w=4.8u l=0.4u
X458 VDD lvds_lane_0.d3.0 lvds_lane_0.nd.0 VDD pfet_03v3 ad=0.78p pd=3.52u as=0.78p ps=3.52u w=3u l=0.28u
X459 lvds_lane_2.tn.0 lvds_lane_2.gn.0 lvds_lane_2.ob.0 VSS nfet_03v3 ad=1.235p pd=5.27u as=1.235p ps=5.27u w=4.75u l=0.5u
X460 VDD lvds_lane_2.d2a.0 lvds_lane_2.n3a.0 VDD pfet_03v3 ad=0.52p pd=2.52u as=0.52p ps=2.52u w=2u l=0.28u
X461 lvds_lane_0.fb.0 lvds_lane_0.gn.0 lvds_lane_0.tp.0 lvds_lane_0.tp.0 pfet_03v3 ad=1.248p pd=5.32u as=1.248p ps=5.32u w=4.8u l=0.4u
X462 lvds_lane_2.fa.0 lvds_lane_0.VBN.0 VSS VSS nfet_03v3 ad=0.65p pd=3.02u as=0.65p ps=3.02u w=2.5u l=1u
X463 lvds_lane_0.ob.0 lvds_lane_0.VREF.0 lvds_lane_0.tn.0 VSS nfet_03v3 ad=1.235p pd=5.27u as=1.235p ps=5.27u w=4.75u l=0.5u
X464 lvds_lane_0.VBP.0 lvds_lane_0.VBP.0 VDD VDD pfet_03v3 ad=1.3p pd=5.52u as=1.3p ps=5.52u w=5u l=1u
X465 lvds_lane_0.fb.0 lvds_lane_0.VBN.0 VSS VSS nfet_03v3 ad=0.65p pd=3.02u as=0.65p ps=3.02u w=2.5u l=1u
X466 VSS lvds_lane_0.VBN.0 lvds_lane_1.tn.0 VSS nfet_03v3 ad=0.65p pd=3.02u as=0.65p ps=3.02u w=2.5u l=1u
X467 VDD VDD VDD VDD pfet_03v3 ad=0.52p pd=2.52u as=0 ps=0 w=2u l=0.5u
X468 lvds_lane_0.d2b.0 lvds_lane_0.d2b.0 VDD VDD pfet_03v3 ad=0.52p pd=2.52u as=0.52p ps=2.52u w=2u l=0.28u
X469 lvds_lane_2.oa.0 lvds_lane_2.gp.0 lvds_lane_2.tn.0 VSS nfet_03v3 ad=1.235p pd=5.27u as=1.235p ps=5.27u w=4.75u l=0.5u
X470 lvds_lane_2.tp.0 lvds_lane_0.VBP.0 VDD VDD pfet_03v3 ad=1.3p pd=5.52u as=1.3p ps=5.52u w=5u l=1u
X471 lvds_lane_0.tp.0 lvds_lane_0.gp.0 lvds_lane_0.fa.0 lvds_lane_0.tp.0 pfet_03v3 ad=1.248p pd=5.32u as=1.248p ps=5.32u w=4.8u l=0.4u
X472 lvds_lane_0.tp.0 lvds_lane_0.gp.0 lvds_lane_0.fa.0 lvds_lane_0.tp.0 pfet_03v3 ad=1.248p pd=5.32u as=1.248p ps=5.32u w=4.8u l=0.4u
X473 lvds_lane_1.tp.0 lvds_lane_0.VREF.0 lvds_lane_1.fa.0 lvds_lane_1.tp.0 pfet_03v3 ad=1.248p pd=5.32u as=1.248p ps=5.32u w=4.8u l=0.4u
X474 lvds_lane_2.tn.0 lvds_lane_0.VREF.0 lvds_lane_2.oa.0 VSS nfet_03v3 ad=1.235p pd=5.27u as=1.235p ps=5.27u w=4.75u l=0.5u
X475 VSS lvds_lane_0.n3a.0 lvds_lane_0.d3.0 VSS nfet_03v3 ad=0.6734p pd=3.11u as=0.6734p ps=3.11u w=2.59u l=0.28u
X476 VSS lvds_lane_1.n3a.0 lvds_lane_1.n3a.0 VSS nfet_03v3 ad=0.6734p pd=3.11u as=0.6734p ps=3.11u w=2.59u l=0.28u
X477 lvds_lane_0.fa.0 lvds_lane_0.gp.0 lvds_lane_0.tp.0 lvds_lane_0.tp.0 pfet_03v3 ad=1.248p pd=5.32u as=1.248p ps=5.32u w=4.8u l=0.4u
X478 lvds_lane_1.tp.0 lvds_lane_0.VREF.0 lvds_lane_1.fa.0 lvds_lane_1.tp.0 pfet_03v3 ad=1.248p pd=5.32u as=1.248p ps=5.32u w=4.8u l=0.4u
X479 VSS VSS lvds_lane_0.ts.0 VSS nfet_03v3 ad=1.1p pd=5.88u as=0.65p ps=3.02u w=2.5u l=1u
X480 VSS lvds_lane_0.VBN.0 lvds_lane_2.fa.0 VSS nfet_03v3 ad=0.65p pd=3.02u as=0.65p ps=3.02u w=2.5u l=1u
X481 VSS lvds_lane_0.VBN.0 lvds_lane_0.VBN.0 VSS nfet_03v3 ad=0.65p pd=3.02u as=0.65p ps=3.02u w=2.5u l=1u
X482 VSS lvds_lane_0.VBN.0 lvds_lane_2.fb.0 VSS nfet_03v3 ad=0.65p pd=3.02u as=0.65p ps=3.02u w=2.5u l=1u
X483 VSS lvds_lane_0.VBN.0 lvds_lane_2.tn.0 VSS nfet_03v3 ad=0.65p pd=3.02u as=0.65p ps=3.02u w=2.5u l=1u
X484 lvds_lane_1.nd.0 VDD VDD VDD pfet_03v3 ad=0.78p pd=3.52u as=1.32p ps=6.88u w=3u l=0.28u
X485 VDD VDD lvds_lane_0.d2b.0 VDD pfet_03v3 ad=0.88p pd=4.88u as=0.52p ps=2.52u w=2u l=0.28u
X486 lvds_lane_0.tn.0 lvds_lane_0.gn.0 lvds_lane_0.ob.0 VSS nfet_03v3 ad=1.235p pd=5.27u as=1.235p ps=5.27u w=4.75u l=0.5u
X487 lvds_lane_1.ts.0 lvds_lane_0.VBN.0 VSS VSS nfet_03v3 ad=0.65p pd=3.02u as=0.65p ps=3.02u w=2.5u l=1u
X488 VSS VSS VSS VSS nfet_03v3 ad=0.39p pd=2.02u as=0 ps=0 w=1.5u l=0.28u
X489 lvds_lane_1.n3a.0 lvds_lane_1.d2a.0 VDD VDD pfet_03v3 ad=0.52p pd=2.52u as=0.52p ps=2.52u w=2u l=0.28u
X490 VDD lvds_lane_0.VBP.0 lvds_lane_2.tp.0 VDD pfet_03v3 ad=1.3p pd=5.52u as=1.3p ps=5.52u w=5u l=1u
X491 lvds_lane_0.tp.0 lvds_lane_0.VREF.0 lvds_lane_0.fb.0 lvds_lane_0.tp.0 pfet_03v3 ad=1.248p pd=5.32u as=1.248p ps=5.32u w=4.8u l=0.4u
X492 lvds_lane_1.fa.0 lvds_lane_1.gp.0 lvds_lane_1.tp.0 lvds_lane_1.tp.0 pfet_03v3 ad=1.248p pd=5.32u as=1.248p ps=5.32u w=4.8u l=0.4u
X493 lvds_lane_1.d2b.0 lvds_lane_1.ob.0 lvds_lane_1.sb.0 VSS nfet_03v3 ad=1.1362p pd=4.89u as=1.1362p ps=4.89u w=4.37u l=0.5u
X494 lvds_lane_1.tp.0 lvds_lane_0.VREF.0 lvds_lane_1.fa.0 lvds_lane_1.tp.0 pfet_03v3 ad=1.248p pd=5.32u as=1.248p ps=5.32u w=4.8u l=0.4u
X495 lvds_lane_1.tn.0 lvds_lane_0.VREF.0 lvds_lane_1.oa.0 VSS nfet_03v3 ad=1.235p pd=5.27u as=1.235p ps=5.27u w=4.75u l=0.5u
X496 VDD lvds_lane_0.VBP.0 lvds_lane_0.tp.0 VDD pfet_03v3 ad=1.3p pd=5.52u as=1.3p ps=5.52u w=5u l=1u
X497 lvds_lane_1.oa.0 lvds_lane_1.rla_m1.0 VSS ppolyf_u_1k r_width=2u r_length=9.11u
X498 lvds_lane_2.tp.0 lvds_lane_2.gp.0 lvds_lane_2.fa.0 lvds_lane_2.tp.0 pfet_03v3 ad=1.248p pd=5.32u as=1.248p ps=5.32u w=4.8u l=0.4u
X499 lvds_bias_0.nrb.0 lvds_bias_0.enb.0 VDD VDD pfet_03v3 ad=1.3p pd=5.52u as=1.3p ps=5.52u w=5u l=0.5u
X500 VDD lvds_lane_0.d2b.0 lvds_lane_0.d2a.0 VDD pfet_03v3 ad=0.52p pd=2.52u as=0.52p ps=2.52u w=2u l=0.28u
X501 lvds_lane_1.fa.0 lvds_lane_0.VREF.0 lvds_lane_1.tp.0 lvds_lane_1.tp.0 pfet_03v3 ad=1.248p pd=5.32u as=1.248p ps=5.32u w=4.8u l=0.4u
X502 VDD VDD lvds_lane_1.n3a.0 VDD pfet_03v3 ad=0.88p pd=4.88u as=0.52p ps=2.52u w=2u l=0.28u
X503 lvds_lane_1.fb.0 lvds_lane_0.VB2.0 lvds_lane_1.ob.0 VSS nfet_03v3 ad=1.1752p pd=5.04u as=1.1752p ps=5.04u w=4.52u l=0.5u
X504 lvds_lane_2.fb.0 lvds_lane_0.VBN.0 VSS VSS nfet_03v3 ad=0.65p pd=3.02u as=0.65p ps=3.02u w=2.5u l=1u
X505 lvds_lane_1.tn.0 lvds_lane_0.VREF.0 lvds_lane_1.ob.0 VSS nfet_03v3 ad=1.235p pd=5.27u as=1.235p ps=5.27u w=4.75u l=0.5u
X506 VSS VSS VSS VSS nfet_03v3 ad=0.6734p pd=3.11u as=0 ps=0 w=2.59u l=0.28u
X507 lvds_lane_1.fa.0 lvds_lane_0.VREF.0 lvds_lane_1.tp.0 lvds_lane_1.tp.0 pfet_03v3 ad=1.248p pd=5.32u as=1.248p ps=5.32u w=4.8u l=0.4u
X508 VSS lvds_lane_0.VBN.0 lvds_lane_1.fa.0 VSS nfet_03v3 ad=0.65p pd=3.02u as=0.65p ps=3.02u w=2.5u l=1u
X509 lvds_lane_2.tn.0 lvds_lane_0.VBN.0 VSS VSS nfet_03v3 ad=0.65p pd=3.02u as=0.65p ps=3.02u w=2.5u l=1u
X510 lvds_lane_2.tp.0 VDD VDD VDD pfet_03v3 ad=1.3p pd=5.52u as=2.2p ps=10.88u w=5u l=1u
X511 lvds_lane_1.fb.0 lvds_lane_0.VB2.0 lvds_lane_1.ob.0 VSS nfet_03v3 ad=1.1752p pd=5.04u as=1.1752p ps=5.04u w=4.52u l=0.5u
X512 VDD lvds_lane_0.VBP.0 lvds_lane_0.VBP.0 VDD pfet_03v3 ad=1.3p pd=5.52u as=1.3p ps=5.52u w=5u l=1u
X513 lvds_lane_0.tn.0 lvds_lane_0.VREF.0 lvds_lane_0.oa.0 VSS nfet_03v3 ad=1.235p pd=5.27u as=1.235p ps=5.27u w=4.75u l=0.5u
X514 VDD lvds_lane_2.d2b.0 lvds_lane_2.d3.0 VDD pfet_03v3 ad=0.52p pd=2.52u as=0.52p ps=2.52u w=2u l=0.28u
X515 VDD lvds_lane_0.VBP.0 lvds_lane_1.tp.0 VDD pfet_03v3 ad=1.3p pd=5.52u as=1.3p ps=5.52u w=5u l=1u
X516 lvds_lane_0.fb.0 lvds_lane_0.VREF.0 lvds_lane_0.tp.0 lvds_lane_0.tp.0 pfet_03v3 ad=1.248p pd=5.32u as=1.248p ps=5.32u w=4.8u l=0.4u
X517 lvds_lane_0.tp.0 lvds_lane_0.VREF.0 lvds_lane_0.fb.0 lvds_lane_0.tp.0 pfet_03v3 ad=1.248p pd=5.32u as=1.248p ps=5.32u w=4.8u l=0.4u
X518 lvds_lane_1.tp.0 lvds_lane_0.VREF.0 lvds_lane_1.fb.0 lvds_lane_1.tp.0 pfet_03v3 ad=1.248p pd=5.32u as=1.248p ps=5.32u w=4.8u l=0.4u
X519 VDD lvds_lane_2.d2b.0 lvds_lane_2.d2a.0 VDD pfet_03v3 ad=0.52p pd=2.52u as=0.52p ps=2.52u w=2u l=0.28u
X520 lvds_lane_1.ob.0 lvds_lane_1.rlb_m1.0 VSS ppolyf_u_1k r_width=2u r_length=9.11u
X521 lvds_lane_2.tp.0 lvds_lane_2.gn.0 lvds_lane_2.fb.0 lvds_lane_2.tp.0 pfet_03v3 ad=1.248p pd=5.32u as=1.248p ps=5.32u w=4.8u l=0.4u
X522 VDD VDD lvds_lane_1.nd.0 VDD pfet_03v3 ad=1.32p pd=6.88u as=0.78p ps=3.52u w=3u l=0.28u
X523 lvds_lane_1.gn.0 RX1_N VDD ppolyf_u r_width=5u r_length=1.8u
X524 lvds_lane_2.tp.0 lvds_lane_0.VREF.0 lvds_lane_2.fb.0 lvds_lane_2.tp.0 pfet_03v3 ad=1.248p pd=5.32u as=1.248p ps=5.32u w=4.8u l=0.4u
X525 lvds_lane_2.d2b.0 lvds_lane_2.d2a.0 VDD VDD pfet_03v3 ad=0.52p pd=2.52u as=0.52p ps=2.52u w=2u l=0.28u
X526 lvds_lane_0.n3a.0 lvds_lane_0.d2a.0 VDD VDD pfet_03v3 ad=0.52p pd=2.52u as=0.52p ps=2.52u w=2u l=0.28u
X527 lvds_lane_0.tp.0 lvds_lane_0.VBP.0 VDD VDD pfet_03v3 ad=1.3p pd=5.52u as=1.3p ps=5.52u w=5u l=1u
X528 lvds_lane_0.fa.0 lvds_lane_0.VREF.0 lvds_lane_0.tp.0 lvds_lane_0.tp.0 pfet_03v3 ad=1.248p pd=5.32u as=1.248p ps=5.32u w=4.8u l=0.4u
X529 VSS VSS lvds_bias_0.nmid.0 VSS nfet_03v3 ad=2.2p pd=10.88u as=1.3p ps=5.52u w=5u l=0.5u
X530 lvds_lane_0.tp.0 lvds_lane_0.gp.0 lvds_lane_0.fa.0 lvds_lane_0.tp.0 pfet_03v3 ad=1.248p pd=5.32u as=1.248p ps=5.32u w=4.8u l=0.4u
X531 lvds_lane_1.fb.0 lvds_lane_0.VREF.0 lvds_lane_1.tp.0 lvds_lane_1.tp.0 pfet_03v3 ad=1.248p pd=5.32u as=1.248p ps=5.32u w=4.8u l=0.4u
X532 lvds_lane_2.fb.0 lvds_lane_0.VREF.0 lvds_lane_2.tp.0 lvds_lane_2.tp.0 pfet_03v3 ad=1.248p pd=5.32u as=1.248p ps=5.32u w=4.8u l=0.4u
X533 lvds_lane_0.d2a.0 VDD VDD VDD pfet_03v3 ad=0.52p pd=2.52u as=0.88p ps=4.88u w=2u l=0.5u
X534 lvds_lane_1.tp.0 lvds_lane_0.VBP.0 VDD VDD pfet_03v3 ad=1.3p pd=5.52u as=1.3p ps=5.52u w=5u l=1u
X535 VSS VSS lvds_lane_0.fa.0 VSS nfet_03v3 ad=1.1p pd=5.88u as=0.65p ps=3.02u w=2.5u l=1u
X536 lvds_lane_2.d2a.0 lvds_lane_2.oa.0 lvds_lane_2.sa.0 VSS nfet_03v3 ad=1.1362p pd=4.89u as=1.1362p ps=4.89u w=4.37u l=0.5u
X537 lvds_lane_2.nd.0 EN VDD VDD pfet_03v3 ad=0.78p pd=3.52u as=0.78p ps=3.52u w=3u l=0.28u
X538 VSS EN lvds_bias_0.nmid.0 VSS nfet_03v3 ad=1.3p pd=5.52u as=1.3p ps=5.52u w=5u l=0.5u
X539 VDD lvds_lane_0.VBP.0 lvds_lane_0.VBP.0 VDD pfet_03v3 ad=1.3p pd=5.52u as=1.3p ps=5.52u w=5u l=1u
X540 lvds_lane_2.tp.0 lvds_lane_2.gp.0 lvds_lane_2.fa.0 lvds_lane_2.tp.0 pfet_03v3 ad=1.248p pd=5.32u as=1.248p ps=5.32u w=4.8u l=0.4u
X541 lvds_lane_2.d3.0 lvds_lane_2.d2b.0 VDD VDD pfet_03v3 ad=0.52p pd=2.52u as=0.52p ps=2.52u w=2u l=0.28u
X542 VSS lvds_lane_0.VBN.0 lvds_lane_2.tn.0 VSS nfet_03v3 ad=0.65p pd=3.02u as=0.65p ps=3.02u w=2.5u l=1u
X543 lvds_lane_2.oa.0 lvds_lane_0.VREF.0 lvds_lane_2.tn.0 VSS nfet_03v3 ad=1.235p pd=5.27u as=1.235p ps=5.27u w=4.75u l=0.5u
X544 VDD lvds_lane_0.VBP.0 lvds_lane_2.tp.0 VDD pfet_03v3 ad=1.3p pd=5.52u as=1.3p ps=5.52u w=5u l=1u
X545 lvds_lane_0.fa.0 lvds_lane_0.VREF.0 lvds_lane_0.tp.0 lvds_lane_0.tp.0 pfet_03v3 ad=1.248p pd=5.32u as=1.248p ps=5.32u w=4.8u l=0.4u
X546 lvds_lane_0.oa.0 lvds_lane_0.VB2.0 lvds_lane_0.fa.0 VSS nfet_03v3 ad=1.1752p pd=5.04u as=1.1752p ps=5.04u w=4.52u l=0.5u
X547 lvds_lane_2.i1.0 VSS VSS VSS nfet_03v3 ad=0.39p pd=2.02u as=0.66p ps=3.88u w=1.5u l=0.28u
X548 lvds_lane_1.ob.0 lvds_lane_1.gn.0 lvds_lane_1.tn.0 VSS nfet_03v3 ad=1.235p pd=5.27u as=1.235p ps=5.27u w=4.75u l=0.5u
X549 lvds_lane_1.fb.0 lvds_lane_1.gn.0 lvds_lane_1.tp.0 lvds_lane_1.tp.0 pfet_03v3 ad=1.248p pd=5.32u as=1.248p ps=5.32u w=4.8u l=0.4u
X550 lvds_lane_2.ob.0 lvds_lane_0.VB2.0 lvds_lane_2.fb.0 VSS nfet_03v3 ad=1.1752p pd=5.04u as=1.1752p ps=5.04u w=4.52u l=0.5u
X551 VDD lvds_lane_1.d2a.0 lvds_lane_1.d2b.0 VDD pfet_03v3 ad=0.52p pd=2.52u as=0.52p ps=2.52u w=2u l=0.28u
X552 lvds_lane_0.n3a.0 lvds_lane_0.n3a.0 VSS VSS nfet_03v3 ad=0.6734p pd=3.11u as=0.6734p ps=3.11u w=2.59u l=0.28u
X553 lvds_lane_2.ob.0 lvds_lane_0.VREF.0 lvds_lane_2.tn.0 VSS nfet_03v3 ad=1.235p pd=5.27u as=1.235p ps=5.27u w=4.75u l=0.5u
X554 lvds_lane_0.fa.0 lvds_lane_0.VREF.0 lvds_lane_0.tp.0 lvds_lane_0.tp.0 pfet_03v3 ad=1.248p pd=5.32u as=1.248p ps=5.32u w=4.8u l=0.4u
X555 lvds_lane_1.fa.0 lvds_lane_1.gp.0 lvds_lane_1.tp.0 lvds_lane_1.tp.0 pfet_03v3 ad=1.248p pd=5.32u as=1.248p ps=5.32u w=4.8u l=0.4u
X556 lvds_lane_2.fa.0 lvds_lane_0.VB2.0 lvds_lane_2.oa.0 VSS nfet_03v3 ad=1.1752p pd=5.04u as=1.1752p ps=5.04u w=4.52u l=0.5u
X557 lvds_lane_2.tp.0 lvds_lane_0.VREF.0 lvds_lane_2.fa.0 lvds_lane_2.tp.0 pfet_03v3 ad=1.248p pd=5.32u as=1.248p ps=5.32u w=4.8u l=0.4u
D6 VSS lvds_lane_2.gp.0 diode_nd2ps_03v3 pj=26u area=40p
X558 lvds_lane_1.oa.0 lvds_lane_1.gp.0 lvds_lane_1.tn.0 VSS nfet_03v3 ad=1.235p pd=5.27u as=1.235p ps=5.27u w=4.75u l=0.5u
X559 lvds_lane_2.tn.0 lvds_lane_0.VBN.0 VSS VSS nfet_03v3 ad=0.65p pd=3.02u as=0.65p ps=3.02u w=2.5u l=1u
X560 VSS VSS VSS VSS nfet_03v3 ad=0.52p pd=2.52u as=0 ps=0 w=2u l=0.28u
X561 lvds_lane_1.tp.0 lvds_lane_1.gn.0 lvds_lane_1.fb.0 lvds_lane_1.tp.0 pfet_03v3 ad=1.248p pd=5.32u as=1.248p ps=5.32u w=4.8u l=0.4u
X562 lvds_lane_2.fa.0 lvds_lane_0.VB2.0 lvds_lane_2.oa.0 VSS nfet_03v3 ad=1.1752p pd=5.04u as=1.1752p ps=5.04u w=4.52u l=0.5u
X563 lvds_lane_2.fa.0 lvds_lane_0.VREF.0 lvds_lane_2.tp.0 lvds_lane_2.tp.0 pfet_03v3 ad=1.248p pd=5.32u as=1.248p ps=5.32u w=4.8u l=0.4u
X564 lvds_lane_0.ob.0 lvds_lane_0.gn.0 lvds_lane_0.tn.0 VSS nfet_03v3 ad=1.235p pd=5.27u as=1.235p ps=5.27u w=4.75u l=0.5u
X565 lvds_lane_0.tn.0 lvds_lane_0.VREF.0 lvds_lane_0.ob.0 VSS nfet_03v3 ad=1.235p pd=5.27u as=1.235p ps=5.27u w=4.75u l=0.5u
X566 lvds_lane_1.tn.0 lvds_lane_0.VREF.0 lvds_lane_1.ob.0 VSS nfet_03v3 ad=1.235p pd=5.27u as=1.235p ps=5.27u w=4.75u l=0.5u
X567 VDD lvds_lane_1.d2a.0 lvds_lane_1.n3a.0 VDD pfet_03v3 ad=0.52p pd=2.52u as=0.52p ps=2.52u w=2u l=0.28u
X568 lvds_lane_0.fa.0 lvds_lane_0.VBN.0 VSS VSS nfet_03v3 ad=0.65p pd=3.02u as=0.65p ps=3.02u w=2.5u l=1u
X569 VDD lvds_lane_0.nd.0 lvds_lane_0.i1.0 VDD pfet_03v3 ad=0.962p pd=4.22u as=0.962p ps=4.22u w=3.7u l=0.28u
X570 lvds_lane_2.d2a.0 lvds_lane_2.d2b.0 VDD VDD pfet_03v3 ad=0.52p pd=2.52u as=0.52p ps=2.52u w=2u l=0.28u
X571 VDD lvds_lane_0.VBP.0 lvds_lane_1.tp.0 VDD pfet_03v3 ad=1.3p pd=5.52u as=1.3p ps=5.52u w=5u l=1u
X572 lvds_lane_0.fb.0 lvds_lane_0.VB2.0 lvds_lane_0.ob.0 VSS nfet_03v3 ad=1.1752p pd=5.04u as=1.1752p ps=5.04u w=4.52u l=0.5u
X573 lvds_lane_0.tn.0 lvds_lane_0.VBN.0 VSS VSS nfet_03v3 ad=0.65p pd=3.02u as=0.65p ps=3.02u w=2.5u l=1u
X574 lvds_lane_2.tn.0 lvds_lane_2.gp.0 lvds_lane_2.oa.0 VSS nfet_03v3 ad=1.235p pd=5.27u as=1.235p ps=5.27u w=4.75u l=0.5u
X575 lvds_lane_0.tp.0 lvds_lane_0.VBP.0 VDD VDD pfet_03v3 ad=1.3p pd=5.52u as=1.3p ps=5.52u w=5u l=1u
X576 VDD VDD lvds_lane_2.i2.0 VDD pfet_03v3 ad=1.65p pd=8.38u as=0.975p ps=4.27u w=3.75u l=0.28u
X577 VSS lvds_lane_0.VBN.0 lvds_lane_2.ts.0 VSS nfet_03v3 ad=0.65p pd=3.02u as=0.65p ps=3.02u w=2.5u l=1u
X578 lvds_lane_2.tp.0 lvds_lane_0.VREF.0 lvds_lane_2.fb.0 lvds_lane_2.tp.0 pfet_03v3 ad=1.248p pd=5.32u as=2.112p ps=10.48u w=4.8u l=0.4u
X579 lvds_lane_0.d2a.0 VSS VSS VSS nfet_03v3 ad=1.1362p pd=4.89u as=1.9228p ps=9.62u w=4.37u l=0.5u
X580 lvds_lane_2.fa.0 lvds_lane_0.VREF.0 lvds_lane_2.tp.0 lvds_lane_2.tp.0 pfet_03v3 ad=1.248p pd=5.32u as=1.248p ps=5.32u w=4.8u l=0.4u
X581 lvds_lane_1.fa.0 lvds_lane_0.VBN.0 VSS VSS nfet_03v3 ad=0.65p pd=3.02u as=0.65p ps=3.02u w=2.5u l=1u
X582 lvds_lane_2.tn.0 lvds_lane_2.gn.0 lvds_lane_2.ob.0 VSS nfet_03v3 ad=1.235p pd=5.27u as=1.235p ps=5.27u w=4.75u l=0.5u
X583 lvds_lane_0.oa.0 lvds_lane_0.VREF.0 lvds_lane_0.tn.0 VSS nfet_03v3 ad=1.235p pd=5.27u as=1.235p ps=5.27u w=4.75u l=0.5u
X584 lvds_lane_2.nd.0 VSS VSS VSS nfet_03v3 ad=0.52p pd=2.52u as=0.88p ps=4.88u w=2u l=0.28u
X585 lvds_lane_0.d2b.0 VDD VDD VDD pfet_03v3 ad=0.52p pd=2.52u as=0.88p ps=4.88u w=2u l=0.5u
X586 VSS VSS VSS ppolyf_u_1k r_width=2u r_length=21.01u
X587 lvds_lane_2.ts.0 lvds_lane_2.sa.0 VSS ppolyf_u_1k r_width=2u r_length=3.17u
X588 lvds_lane_1.tp.0 lvds_lane_0.VBP.0 VDD VDD pfet_03v3 ad=1.3p pd=5.52u as=1.3p ps=5.52u w=5u l=1u
X589 lvds_lane_2.tp.0 lvds_lane_0.VREF.0 lvds_lane_2.fb.0 lvds_lane_2.tp.0 pfet_03v3 ad=1.248p pd=5.32u as=1.248p ps=5.32u w=4.8u l=0.4u
X590 lvds_lane_1.fb.0 lvds_lane_0.VBN.0 VSS VSS nfet_03v3 ad=0.65p pd=3.02u as=0.65p ps=3.02u w=2.5u l=1u
X591 lvds_lane_2.tn.0 lvds_lane_0.VREF.0 lvds_lane_2.ob.0 VSS nfet_03v3 ad=1.235p pd=5.27u as=1.235p ps=5.27u w=4.75u l=0.5u
X592 lvds_lane_0.fb.0 lvds_lane_0.VREF.0 lvds_lane_0.tp.0 lvds_lane_0.tp.0 pfet_03v3 ad=1.248p pd=5.32u as=1.248p ps=5.32u w=4.8u l=0.4u
X593 lvds_lane_2.n3a.0 VDD VDD VDD pfet_03v3 ad=0.52p pd=2.52u as=0.88p ps=4.88u w=2u l=0.28u
X594 lvds_lane_0.VREF.0 lvds_bias_0.rdb_m1.0 VSS ppolyf_u_1k r_width=2u r_length=19.26u
X595 lvds_lane_2.tp.0 lvds_lane_0.VREF.0 lvds_lane_2.fb.0 lvds_lane_2.tp.0 pfet_03v3 ad=1.248p pd=5.32u as=1.248p ps=5.32u w=4.8u l=0.4u
X596 lvds_lane_1.i1.0 VDD VDD VDD pfet_03v3 ad=0.962p pd=4.22u as=1.628p ps=8.28u w=3.7u l=0.28u
X597 VSS lvds_lane_0.VBN.0 lvds_lane_0.ts.0 VSS nfet_03v3 ad=0.65p pd=3.02u as=0.65p ps=3.02u w=2.5u l=1u
X598 VSS EN lvds_lane_2.nm.0 VSS nfet_03v3 ad=0.52p pd=2.52u as=0.52p ps=2.52u w=2u l=0.28u
X599 VSS lvds_lane_2.nd.0 lvds_lane_2.i1.0 VSS nfet_03v3 ad=0.39p pd=2.02u as=0.39p ps=2.02u w=1.5u l=0.28u
X600 lvds_lane_0.tp.0 lvds_lane_0.gp.0 lvds_lane_0.fa.0 lvds_lane_0.tp.0 pfet_03v3 ad=1.248p pd=5.32u as=1.248p ps=5.32u w=4.8u l=0.4u
X601 lvds_lane_1.tp.0 lvds_lane_1.gp.0 lvds_lane_1.fa.0 lvds_lane_1.tp.0 pfet_03v3 ad=1.248p pd=5.32u as=1.248p ps=5.32u w=4.8u l=0.4u
X602 lvds_lane_1.fb.0 lvds_lane_0.VREF.0 lvds_lane_1.tp.0 lvds_lane_1.tp.0 pfet_03v3 ad=1.248p pd=5.32u as=1.248p ps=5.32u w=4.8u l=0.4u
X603 lvds_lane_2.fb.0 lvds_lane_0.VREF.0 lvds_lane_2.tp.0 lvds_lane_2.tp.0 pfet_03v3 ad=1.248p pd=5.32u as=1.248p ps=5.32u w=4.8u l=0.4u
X604 VDD lvds_lane_2.d2b.0 lvds_lane_2.d2b.0 VDD pfet_03v3 ad=0.52p pd=2.52u as=0.52p ps=2.52u w=2u l=0.28u
X605 lvds_lane_2.fb.0 lvds_lane_2.gn.0 lvds_lane_2.tp.0 lvds_lane_2.tp.0 pfet_03v3 ad=1.248p pd=5.32u as=1.248p ps=5.32u w=4.8u l=0.4u
X606 lvds_lane_1.d2a.0 lvds_lane_1.d2a.0 VDD VDD pfet_03v3 ad=0.52p pd=2.52u as=0.52p ps=2.52u w=2u l=0.28u
X607 VSS lvds_lane_0.VBN.0 lvds_lane_0.fa.0 VSS nfet_03v3 ad=0.65p pd=3.02u as=0.65p ps=3.02u w=2.5u l=1u
X608 lvds_lane_1.fa.0 lvds_lane_0.VB2.0 lvds_lane_1.oa.0 VSS nfet_03v3 ad=1.1752p pd=5.04u as=1.1752p ps=5.04u w=4.52u l=0.5u
X609 VSS lvds_lane_0.VBN.0 lvds_lane_1.fb.0 VSS nfet_03v3 ad=0.65p pd=3.02u as=0.65p ps=3.02u w=2.5u l=1u
X610 VSS VSS lvds_lane_0.tn.0 VSS nfet_03v3 ad=1.1p pd=5.88u as=0.65p ps=3.02u w=2.5u l=1u
X611 RX1_O VDD VDD VDD pfet_03v3 ad=1.3p pd=5.52u as=2.2p ps=10.88u w=5u l=0.28u
X612 lvds_lane_1.d2b.0 VSS VSS VSS nfet_03v3 ad=1.1362p pd=4.89u as=1.9228p ps=9.62u w=4.37u l=0.5u
X613 lvds_lane_2.ts.0 lvds_lane_0.VBN.0 VSS VSS nfet_03v3 ad=0.65p pd=3.02u as=0.65p ps=3.02u w=2.5u l=1u
X614 VDD lvds_lane_0.VBP.0 lvds_lane_0.tp.0 VDD pfet_03v3 ad=1.3p pd=5.52u as=1.3p ps=5.52u w=5u l=1u
X615 lvds_lane_1.tp.0 lvds_lane_0.VREF.0 lvds_lane_1.fa.0 lvds_lane_1.tp.0 pfet_03v3 ad=1.248p pd=5.32u as=1.248p ps=5.32u w=4.8u l=0.4u
X616 VSS VSS VSS ppolyf_u_1k r_width=2u r_length=3.17u
X617 lvds_lane_0.tp.0 lvds_lane_0.gn.0 lvds_lane_0.fb.0 lvds_lane_0.tp.0 pfet_03v3 ad=1.248p pd=5.32u as=1.248p ps=5.32u w=4.8u l=0.4u
X618 lvds_lane_1.fa.0 lvds_lane_0.VB2.0 lvds_lane_1.oa.0 VSS nfet_03v3 ad=1.1752p pd=5.04u as=1.1752p ps=5.04u w=4.52u l=0.5u
X619 lvds_lane_2.d3.0 lvds_lane_2.d2b.0 VDD VDD pfet_03v3 ad=0.52p pd=2.52u as=0.52p ps=2.52u w=2u l=0.28u
X620 VDD lvds_lane_1.rlb_m1.0 VSS ppolyf_u_1k r_width=2u r_length=9.11u
X621 lvds_lane_1.tn.0 lvds_lane_0.VREF.0 lvds_lane_1.oa.0 VSS nfet_03v3 ad=1.235p pd=5.27u as=1.235p ps=5.27u w=4.75u l=0.5u
X622 lvds_bias_0.rf_m1.0 lvds_bias_0.vf.0 VSS ppolyf_u_1k r_width=2u r_length=23.07u
X623 lvds_lane_2.tp.0 lvds_lane_0.VREF.0 lvds_lane_2.fa.0 lvds_lane_2.tp.0 pfet_03v3 ad=1.248p pd=5.32u as=1.248p ps=5.32u w=4.8u l=0.4u
X624 lvds_lane_1.fa.0 VSS VSS VSS nfet_03v3 ad=0.65p pd=3.02u as=1.1p ps=5.88u w=2.5u l=1u
X625 lvds_lane_1.fb.0 lvds_lane_0.VB2.0 lvds_lane_1.ob.0 VSS nfet_03v3 ad=1.1752p pd=5.04u as=1.1752p ps=5.04u w=4.52u l=0.5u
X626 lvds_lane_0.tn.0 lvds_lane_0.VREF.0 lvds_lane_0.ob.0 VSS nfet_03v3 ad=1.235p pd=5.27u as=2.09p ps=10.38u w=4.75u l=0.5u
X627 lvds_lane_0.tn.0 lvds_lane_0.VREF.0 lvds_lane_0.oa.0 VSS nfet_03v3 ad=1.235p pd=5.27u as=1.235p ps=5.27u w=4.75u l=0.5u
X628 lvds_lane_0.ts.0 lvds_lane_0.VBN.0 VSS VSS nfet_03v3 ad=0.65p pd=3.02u as=0.65p ps=3.02u w=2.5u l=1u
X629 VDD lvds_lane_0.d2a.0 lvds_lane_0.d2b.0 VDD pfet_03v3 ad=0.52p pd=2.52u as=0.52p ps=2.52u w=2u l=0.28u
X630 VSS VSS VSS ppolyf_u_1k r_width=2u r_length=3.17u
X631 lvds_lane_1.tp.0 lvds_lane_0.VREF.0 lvds_lane_1.fa.0 lvds_lane_1.tp.0 pfet_03v3 ad=1.248p pd=5.32u as=1.248p ps=5.32u w=4.8u l=0.4u
X632 lvds_lane_1.ts.0 lvds_lane_0.VBN.0 VSS VSS nfet_03v3 ad=0.65p pd=3.02u as=0.65p ps=3.02u w=2.5u l=1u
X633 lvds_lane_1.i1.0 VSS VSS VSS nfet_03v3 ad=0.39p pd=2.02u as=0.66p ps=3.88u w=1.5u l=0.28u
X634 lvds_lane_0.i2.0 lvds_lane_0.i1.0 VDD VDD pfet_03v3 ad=0.975p pd=4.27u as=0.975p ps=4.27u w=3.75u l=0.28u
X635 lvds_lane_0.fb.0 lvds_lane_0.gn.0 lvds_lane_0.tp.0 lvds_lane_0.tp.0 pfet_03v3 ad=1.248p pd=5.32u as=1.248p ps=5.32u w=4.8u l=0.4u
X636 lvds_lane_1.tp.0 lvds_lane_0.VREF.0 lvds_lane_1.fb.0 lvds_lane_1.tp.0 pfet_03v3 ad=1.248p pd=5.32u as=1.248p ps=5.32u w=4.8u l=0.4u
X637 lvds_lane_2.tp.0 lvds_lane_2.gp.0 lvds_lane_2.fa.0 lvds_lane_2.tp.0 pfet_03v3 ad=1.248p pd=5.32u as=1.248p ps=5.32u w=4.8u l=0.4u
X638 lvds_lane_0.tp.0 lvds_lane_0.VREF.0 lvds_lane_0.fb.0 lvds_lane_0.tp.0 pfet_03v3 ad=1.248p pd=5.32u as=1.248p ps=5.32u w=4.8u l=0.4u
X639 VSS lvds_bias_0.enb.0 lvds_lane_0.VBN.0 VSS nfet_03v3 ad=0.52p pd=2.52u as=0.52p ps=2.52u w=2u l=0.5u
X640 lvds_lane_2.tp.0 lvds_lane_2.gn.0 lvds_lane_2.fb.0 lvds_lane_2.tp.0 pfet_03v3 ad=1.248p pd=5.32u as=1.248p ps=5.32u w=4.8u l=0.4u
D7 lvds_lane_1.gp.0 VDD diode_pd2nw_03v3 pj=26u area=40p
X641 lvds_lane_1.tn.0 lvds_lane_1.gn.0 lvds_lane_1.ob.0 VSS nfet_03v3 ad=1.235p pd=5.27u as=1.235p ps=5.27u w=4.75u l=0.5u
X642 VSS VSS VSS VSS nfet_03v3 ad=0.52p pd=2.52u as=0 ps=0 w=2u l=0.28u
X643 VDD lvds_lane_1.d2a.0 lvds_lane_1.n3a.0 VDD pfet_03v3 ad=0.52p pd=2.52u as=0.52p ps=2.52u w=2u l=0.28u
X644 lvds_lane_2.fb.0 lvds_lane_2.gn.0 lvds_lane_2.tp.0 lvds_lane_2.tp.0 pfet_03v3 ad=1.248p pd=5.32u as=1.248p ps=5.32u w=4.8u l=0.4u
X645 lvds_lane_1.fa.0 lvds_lane_0.VBN.0 VSS VSS nfet_03v3 ad=0.65p pd=3.02u as=0.65p ps=3.02u w=2.5u l=1u
X646 lvds_lane_2.fa.0 lvds_lane_0.VBN.0 VSS VSS nfet_03v3 ad=0.65p pd=3.02u as=0.65p ps=3.02u w=2.5u l=1u
X647 VDD VDD VDD VDD pfet_03v3 ad=0.962p pd=4.22u as=0 ps=0 w=3.7u l=0.28u
X648 VSS lvds_lane_0.VBN.0 lvds_lane_0.tn.0 VSS nfet_03v3 ad=0.65p pd=3.02u as=0.65p ps=3.02u w=2.5u l=1u
X649 lvds_lane_1.tp.0 lvds_lane_0.VBP.0 VDD VDD pfet_03v3 ad=1.3p pd=5.52u as=1.3p ps=5.52u w=5u l=1u
X650 lvds_lane_0.tp.0 lvds_lane_0.VREF.0 lvds_lane_0.fa.0 lvds_lane_0.tp.0 pfet_03v3 ad=1.248p pd=5.32u as=1.248p ps=5.32u w=4.8u l=0.4u
X651 lvds_lane_1.tn.0 lvds_lane_0.VREF.0 lvds_lane_1.oa.0 VSS nfet_03v3 ad=1.235p pd=5.27u as=1.235p ps=5.27u w=4.75u l=0.5u
X652 lvds_lane_2.sb.0 lvds_lane_2.ob.0 lvds_lane_2.d2b.0 VSS nfet_03v3 ad=1.1362p pd=4.89u as=1.1362p ps=4.89u w=4.37u l=0.5u
X653 lvds_lane_1.d2b.0 lvds_lane_1.d2a.0 VDD VDD pfet_03v3 ad=0.52p pd=2.52u as=0.52p ps=2.52u w=2u l=0.28u
X654 lvds_lane_1.tp.0 lvds_lane_1.gn.0 lvds_lane_1.fb.0 lvds_lane_1.tp.0 pfet_03v3 ad=1.248p pd=5.32u as=1.248p ps=5.32u w=4.8u l=0.4u
X655 lvds_lane_0.tp.0 lvds_lane_0.VREF.0 lvds_lane_0.fa.0 lvds_lane_0.tp.0 pfet_03v3 ad=1.248p pd=5.32u as=1.248p ps=5.32u w=4.8u l=0.4u
X656 VDD lvds_lane_1.i1.0 lvds_lane_1.i2.0 VDD pfet_03v3 ad=0.975p pd=4.27u as=0.975p ps=4.27u w=3.75u l=0.28u
X657 VSS EN lvds_bias_0.enb.0 VSS nfet_03v3 ad=0.44p pd=2.88u as=0.44p ps=2.88u w=1u l=0.28u
X658 lvds_lane_2.fb.0 lvds_lane_0.VREF.0 lvds_lane_2.tp.0 lvds_lane_2.tp.0 pfet_03v3 ad=1.248p pd=5.32u as=1.248p ps=5.32u w=4.8u l=0.4u
X659 VSS lvds_lane_0.VBN.0 lvds_lane_1.fa.0 VSS nfet_03v3 ad=0.65p pd=3.02u as=0.65p ps=3.02u w=2.5u l=1u
X660 VSS lvds_lane_0.VBN.0 lvds_lane_2.fb.0 VSS nfet_03v3 ad=0.65p pd=3.02u as=0.65p ps=3.02u w=2.5u l=1u
X661 VSS lvds_lane_0.VBN.0 lvds_lane_1.tn.0 VSS nfet_03v3 ad=0.65p pd=3.02u as=0.65p ps=3.02u w=2.5u l=1u
X662 VDD VDD RX1_O VDD pfet_03v3 ad=2.2p pd=10.88u as=1.3p ps=5.52u w=5u l=0.28u
X663 lvds_lane_1.ob.0 lvds_lane_1.gn.0 lvds_lane_1.tn.0 VSS nfet_03v3 ad=1.235p pd=5.27u as=1.235p ps=5.27u w=4.75u l=0.5u
X664 lvds_lane_0.nd.0 VDD VDD VDD pfet_03v3 ad=0.78p pd=3.52u as=1.32p ps=6.88u w=3u l=0.28u
X665 lvds_lane_2.n3a.0 lvds_lane_2.d2a.0 VDD VDD pfet_03v3 ad=0.52p pd=2.52u as=0.52p ps=2.52u w=2u l=0.28u
X666 VSS lvds_lane_0.VBN.0 lvds_lane_2.fa.0 VSS nfet_03v3 ad=0.65p pd=3.02u as=0.65p ps=3.02u w=2.5u l=1u
X667 lvds_lane_2.ob.0 lvds_lane_0.VB2.0 lvds_lane_2.fb.0 VSS nfet_03v3 ad=1.1752p pd=5.04u as=1.1752p ps=5.04u w=4.52u l=0.5u
X668 lvds_lane_0.ts.0 lvds_lane_0.VBN.0 VSS VSS nfet_03v3 ad=0.65p pd=3.02u as=0.65p ps=3.02u w=2.5u l=1u
X669 lvds_lane_0.n3a.0 lvds_lane_0.d2a.0 VDD VDD pfet_03v3 ad=0.52p pd=2.52u as=0.52p ps=2.52u w=2u l=0.28u
X670 lvds_lane_1.nd.0 VSS VSS VSS nfet_03v3 ad=0.52p pd=2.52u as=0.88p ps=4.88u w=2u l=0.28u
X671 lvds_lane_2.d2a.0 lvds_lane_2.d2b.0 VDD VDD pfet_03v3 ad=0.52p pd=2.52u as=0.52p ps=2.52u w=2u l=0.28u
X672 lvds_lane_2.oa.0 lvds_lane_0.VREF.0 lvds_lane_2.tn.0 VSS nfet_03v3 ad=1.235p pd=5.27u as=1.235p ps=5.27u w=4.75u l=0.5u
X673 lvds_lane_0.fa.0 lvds_lane_0.gp.0 lvds_lane_0.tp.0 lvds_lane_0.tp.0 pfet_03v3 ad=1.248p pd=5.32u as=1.248p ps=5.32u w=4.8u l=0.4u
X674 lvds_lane_1.ts.0 VSS VSS VSS nfet_03v3 ad=0.65p pd=3.02u as=1.1p ps=5.88u w=2.5u l=1u
X675 lvds_lane_0.d2b.0 lvds_lane_0.ob.0 lvds_lane_0.sb.0 VSS nfet_03v3 ad=1.1362p pd=4.89u as=1.1362p ps=4.89u w=4.37u l=0.5u
X676 lvds_lane_0.tp.0 lvds_lane_0.VREF.0 lvds_lane_0.fa.0 lvds_lane_0.tp.0 pfet_03v3 ad=1.248p pd=5.32u as=1.248p ps=5.32u w=4.8u l=0.4u
X677 lvds_lane_2.tp.0 lvds_lane_2.gn.0 lvds_lane_2.fb.0 lvds_lane_2.tp.0 pfet_03v3 ad=1.248p pd=5.32u as=1.248p ps=5.32u w=4.8u l=0.4u
X678 lvds_lane_2.ob.0 lvds_lane_0.VB2.0 lvds_lane_2.fb.0 VSS nfet_03v3 ad=1.1752p pd=5.04u as=1.1752p ps=5.04u w=4.52u l=0.5u
X679 lvds_lane_0.tn.0 lvds_lane_0.VREF.0 lvds_lane_0.oa.0 VSS nfet_03v3 ad=1.235p pd=5.27u as=1.235p ps=5.27u w=4.75u l=0.5u
X680 lvds_lane_1.ob.0 lvds_lane_1.gn.0 lvds_lane_1.tn.0 VSS nfet_03v3 ad=1.235p pd=5.27u as=1.235p ps=5.27u w=4.75u l=0.5u
X681 lvds_lane_0.d3.0 lvds_lane_0.n3a.0 VSS VSS nfet_03v3 ad=0.6734p pd=3.11u as=0.6734p ps=3.11u w=2.59u l=0.28u
X682 lvds_lane_0.oa.0 lvds_lane_0.rla_m1.0 VSS ppolyf_u_1k r_width=2u r_length=9.11u
X683 lvds_lane_0.fa.0 lvds_lane_0.VREF.0 lvds_lane_0.tp.0 lvds_lane_0.tp.0 pfet_03v3 ad=1.248p pd=5.32u as=1.248p ps=5.32u w=4.8u l=0.4u
X684 VDD VDD lvds_lane_0.n3a.0 VDD pfet_03v3 ad=0.88p pd=4.88u as=0.52p ps=2.52u w=2u l=0.28u
X685 lvds_lane_2.tp.0 lvds_lane_2.gp.0 lvds_lane_2.fa.0 lvds_lane_2.tp.0 pfet_03v3 ad=1.248p pd=5.32u as=1.248p ps=5.32u w=4.8u l=0.4u
X686 lvds_lane_0.fb.0 lvds_lane_0.VB2.0 lvds_lane_0.ob.0 VSS nfet_03v3 ad=1.1752p pd=5.04u as=1.1752p ps=5.04u w=4.52u l=0.5u
X687 VSS EN lvds_lane_1.nm.0 VSS nfet_03v3 ad=0.52p pd=2.52u as=0.52p ps=2.52u w=2u l=0.28u
X688 VSS lvds_lane_1.nd.0 lvds_lane_1.i1.0 VSS nfet_03v3 ad=0.39p pd=2.02u as=0.39p ps=2.02u w=1.5u l=0.28u
X689 lvds_lane_1.fb.0 lvds_lane_0.VBN.0 VSS VSS nfet_03v3 ad=0.65p pd=3.02u as=0.65p ps=3.02u w=2.5u l=1u
X690 lvds_lane_0.tn.0 lvds_lane_0.VREF.0 lvds_lane_0.ob.0 VSS nfet_03v3 ad=1.235p pd=5.27u as=1.235p ps=5.27u w=4.75u l=0.5u
X691 lvds_lane_1.oa.0 lvds_lane_1.gp.0 lvds_lane_1.tn.0 VSS nfet_03v3 ad=1.235p pd=5.27u as=1.235p ps=5.27u w=4.75u l=0.5u
X692 VDD lvds_lane_1.d2b.0 lvds_lane_1.d2a.0 VDD pfet_03v3 ad=0.52p pd=2.52u as=0.52p ps=2.52u w=2u l=0.28u
X693 lvds_lane_2.tp.0 lvds_lane_0.VREF.0 lvds_lane_2.fa.0 lvds_lane_2.tp.0 pfet_03v3 ad=1.248p pd=5.32u as=1.248p ps=5.32u w=4.8u l=0.4u
X694 lvds_lane_2.ob.0 VSS VSS VSS nfet_03v3 ad=1.1752p pd=5.04u as=1.9888p ps=9.92u w=4.52u l=0.5u
X695 lvds_lane_1.tn.0 lvds_lane_0.VBN.0 VSS VSS nfet_03v3 ad=0.65p pd=3.02u as=0.65p ps=3.02u w=2.5u l=1u
X696 lvds_lane_1.tp.0 VDD VDD VDD pfet_03v3 ad=1.3p pd=5.52u as=2.2p ps=10.88u w=5u l=1u
X697 lvds_lane_0.fa.0 lvds_lane_0.VREF.0 lvds_lane_0.tp.0 lvds_lane_0.tp.0 pfet_03v3 ad=1.248p pd=5.32u as=1.248p ps=5.32u w=4.8u l=0.4u
X698 VSS lvds_lane_0.VBN.0 lvds_lane_0.fa.0 VSS nfet_03v3 ad=0.65p pd=3.02u as=0.65p ps=3.02u w=2.5u l=1u
X699 lvds_lane_0.fb.0 lvds_lane_0.VB2.0 lvds_lane_0.ob.0 VSS nfet_03v3 ad=1.1752p pd=5.04u as=1.1752p ps=5.04u w=4.52u l=0.5u
X700 VDD lvds_lane_0.VBP.0 lvds_lane_0.VB2.0 VDD pfet_03v3 ad=1.3p pd=5.52u as=1.3p ps=5.52u w=5u l=1u
X701 lvds_lane_1.tp.0 lvds_lane_1.gp.0 lvds_lane_1.fa.0 lvds_lane_1.tp.0 pfet_03v3 ad=1.248p pd=5.32u as=1.248p ps=5.32u w=4.8u l=0.4u
X702 VDD lvds_lane_1.d2b.0 lvds_lane_1.d3.0 VDD pfet_03v3 ad=0.52p pd=2.52u as=0.52p ps=2.52u w=2u l=0.28u
X703 VDD lvds_lane_0.VBP.0 lvds_lane_0.tp.0 VDD pfet_03v3 ad=1.3p pd=5.52u as=1.3p ps=5.52u w=5u l=1u
X704 lvds_lane_0.tp.0 lvds_lane_0.VREF.0 lvds_lane_0.fb.0 lvds_lane_0.tp.0 pfet_03v3 ad=1.248p pd=5.32u as=1.248p ps=5.32u w=4.8u l=0.4u
X705 lvds_lane_1.fa.0 lvds_lane_1.gp.0 lvds_lane_1.tp.0 lvds_lane_1.tp.0 pfet_03v3 ad=1.248p pd=5.32u as=1.248p ps=5.32u w=4.8u l=0.4u
X706 VDD lvds_lane_1.d2b.0 lvds_lane_1.d2a.0 VDD pfet_03v3 ad=0.52p pd=2.52u as=0.52p ps=2.52u w=2u l=0.28u
X707 lvds_lane_2.fa.0 lvds_lane_0.VREF.0 lvds_lane_2.tp.0 lvds_lane_2.tp.0 pfet_03v3 ad=1.248p pd=5.32u as=1.248p ps=5.32u w=4.8u l=0.4u
X708 lvds_bias_0.vf.0 lvds_lane_0.VB2.0 lvds_lane_0.VB2.0 VSS nfet_03v3 ad=2.0566p pd=8.43u as=2.0566p ps=8.43u w=7.91u l=0.5u
X709 RX0_O VDD VDD VDD pfet_03v3 ad=1.3p pd=5.52u as=2.2p ps=10.88u w=5u l=0.28u
X710 VDD VDD lvds_lane_0.nd.0 VDD pfet_03v3 ad=1.32p pd=6.88u as=0.78p ps=3.52u w=3u l=0.28u
X711 VDD lvds_lane_2.d2b.0 lvds_lane_2.d3.0 VDD pfet_03v3 ad=0.52p pd=2.52u as=0.52p ps=2.52u w=2u l=0.28u
X712 lvds_lane_0.ob.0 lvds_lane_0.rlb_m1.0 VSS ppolyf_u_1k r_width=2u r_length=9.11u
X713 lvds_lane_2.tn.0 lvds_lane_2.gp.0 lvds_lane_2.oa.0 VSS nfet_03v3 ad=1.235p pd=5.27u as=1.235p ps=5.27u w=4.75u l=0.5u
X714 lvds_lane_0.gn.0 RX0_N VDD ppolyf_u r_width=5u r_length=1.8u
X715 lvds_lane_2.fa.0 lvds_lane_0.VBN.0 VSS VSS nfet_03v3 ad=0.65p pd=3.02u as=0.65p ps=3.02u w=2.5u l=1u
X716 lvds_lane_1.tp.0 lvds_lane_0.VREF.0 lvds_lane_1.fb.0 lvds_lane_1.tp.0 pfet_03v3 ad=1.248p pd=5.32u as=1.248p ps=5.32u w=4.8u l=0.4u
X717 RX1_O lvds_lane_1.i2.0 VDD VDD pfet_03v3 ad=1.3p pd=5.52u as=1.3p ps=5.52u w=5u l=0.28u
X718 VSS VSS VSS VSS nfet_03v3 ad=0.52p pd=2.52u as=0 ps=0 w=2u l=0.5u
X719 lvds_lane_2.fb.0 lvds_lane_0.VBN.0 VSS VSS nfet_03v3 ad=0.65p pd=3.02u as=0.65p ps=3.02u w=2.5u l=1u
X720 lvds_lane_2.tn.0 lvds_lane_0.VBN.0 VSS VSS nfet_03v3 ad=0.65p pd=3.02u as=0.65p ps=3.02u w=2.5u l=1u
X721 VSS lvds_lane_0.VBN.0 lvds_lane_1.ts.0 VSS nfet_03v3 ad=0.65p pd=3.02u as=0.65p ps=3.02u w=2.5u l=1u
X722 lvds_lane_2.tp.0 lvds_lane_0.VBP.0 VDD VDD pfet_03v3 ad=1.3p pd=5.52u as=1.3p ps=5.52u w=5u l=1u
X723 lvds_lane_1.fa.0 lvds_lane_1.gp.0 lvds_lane_1.tp.0 lvds_lane_1.tp.0 pfet_03v3 ad=1.248p pd=5.32u as=1.248p ps=5.32u w=4.8u l=0.4u
X724 lvds_lane_0.VB2.0 VSS VSS VSS nfet_03v3 ad=0.52p pd=2.52u as=0.88p ps=4.88u w=2u l=0.5u
X725 RX2_O VDD VDD VDD pfet_03v3 ad=1.3p pd=5.52u as=2.2p ps=10.88u w=5u l=0.28u
X726 lvds_bias_0.enb.0 VDD VDD VDD pfet_03v3 ad=0.65p pd=3.02u as=1.1p ps=5.88u w=2.5u l=0.28u
X727 lvds_lane_0.VREF.0 lvds_bias_0.rdt_m3.0 VSS ppolyf_u_1k r_width=2u r_length=21.01u
X728 lvds_lane_0.fb.0 lvds_lane_0.VREF.0 lvds_lane_0.tp.0 lvds_lane_0.tp.0 pfet_03v3 ad=1.248p pd=5.32u as=1.248p ps=5.32u w=4.8u l=0.4u
X729 lvds_lane_1.fb.0 lvds_lane_0.VREF.0 lvds_lane_1.tp.0 lvds_lane_1.tp.0 pfet_03v3 ad=1.248p pd=5.32u as=1.248p ps=5.32u w=4.8u l=0.4u
X730 lvds_lane_2.d3.0 lvds_lane_2.d2b.0 VDD VDD pfet_03v3 ad=0.52p pd=2.52u as=0.52p ps=2.52u w=2u l=0.28u
X731 lvds_lane_0.tp.0 lvds_lane_0.VBP.0 VDD VDD pfet_03v3 ad=1.3p pd=5.52u as=1.3p ps=5.52u w=5u l=1u
X732 lvds_lane_2.tp.0 lvds_lane_2.gn.0 lvds_lane_2.fb.0 lvds_lane_2.tp.0 pfet_03v3 ad=1.248p pd=5.32u as=1.248p ps=5.32u w=4.8u l=0.4u
X733 lvds_lane_2.tn.0 lvds_lane_2.gp.0 lvds_lane_2.oa.0 VSS nfet_03v3 ad=1.235p pd=5.27u as=1.235p ps=5.27u w=4.75u l=0.5u
X734 VSS lvds_lane_0.VBN.0 lvds_lane_2.fb.0 VSS nfet_03v3 ad=0.65p pd=3.02u as=0.65p ps=3.02u w=2.5u l=1u
X735 lvds_lane_1.nd.0 EN VDD VDD pfet_03v3 ad=0.78p pd=3.52u as=0.78p ps=3.52u w=3u l=0.28u
X736 lvds_lane_2.d2a.0 VDD VDD VDD pfet_03v3 ad=0.52p pd=2.52u as=0.88p ps=4.88u w=2u l=0.28u
X737 lvds_lane_1.d2a.0 lvds_lane_1.oa.0 lvds_lane_1.sa.0 VSS nfet_03v3 ad=1.1362p pd=4.89u as=1.1362p ps=4.89u w=4.37u l=0.5u
X738 lvds_lane_1.tp.0 lvds_lane_1.gp.0 lvds_lane_1.fa.0 lvds_lane_1.tp.0 pfet_03v3 ad=1.248p pd=5.32u as=1.248p ps=5.32u w=4.8u l=0.4u
X739 VSS lvds_lane_0.VBN.0 lvds_lane_0.VBN.0 VSS nfet_03v3 ad=0.65p pd=3.02u as=0.65p ps=3.02u w=2.5u l=1u
X740 lvds_lane_0.i1.0 VSS VSS VSS nfet_03v3 ad=0.39p pd=2.02u as=0.66p ps=3.88u w=1.5u l=0.28u
X741 VSS lvds_lane_0.VBN.0 lvds_lane_1.tn.0 VSS nfet_03v3 ad=0.65p pd=3.02u as=0.65p ps=3.02u w=2.5u l=1u
X742 lvds_lane_0.VBP.0 lvds_lane_0.VBN.0 VSS VSS nfet_03v3 ad=0.65p pd=3.02u as=0.65p ps=3.02u w=2.5u l=1u
X743 lvds_lane_1.d3.0 lvds_lane_1.d2b.0 VDD VDD pfet_03v3 ad=0.52p pd=2.52u as=0.52p ps=2.52u w=2u l=0.28u
X744 VDD lvds_lane_0.VBP.0 lvds_lane_1.tp.0 VDD pfet_03v3 ad=1.3p pd=5.52u as=1.3p ps=5.52u w=5u l=1u
X745 lvds_lane_2.fb.0 lvds_lane_0.VREF.0 lvds_lane_2.tp.0 lvds_lane_2.tp.0 pfet_03v3 ad=1.248p pd=5.32u as=1.248p ps=5.32u w=4.8u l=0.4u
X746 lvds_lane_2.tn.0 lvds_lane_2.gp.0 lvds_lane_2.oa.0 VSS nfet_03v3 ad=1.235p pd=5.27u as=1.235p ps=5.27u w=4.75u l=0.5u
X747 VDD lvds_lane_2.d2a.0 lvds_lane_2.d2a.0 VDD pfet_03v3 ad=0.52p pd=2.52u as=0.52p ps=2.52u w=2u l=0.28u
X748 VSS VSS VSS ppolyf_u_1k r_width=2u r_length=9.11u
X749 VDD lvds_lane_0.VBP.0 lvds_lane_2.tp.0 VDD pfet_03v3 ad=1.3p pd=5.52u as=1.3p ps=5.52u w=5u l=1u
X750 lvds_lane_1.fa.0 lvds_lane_0.VBN.0 VSS VSS nfet_03v3 ad=0.65p pd=3.02u as=0.65p ps=3.02u w=2.5u l=1u
X751 lvds_lane_0.ob.0 lvds_lane_0.gn.0 lvds_lane_0.tn.0 VSS nfet_03v3 ad=1.235p pd=5.27u as=1.235p ps=5.27u w=4.75u l=0.5u
X752 lvds_lane_0.fb.0 lvds_lane_0.gn.0 lvds_lane_0.tp.0 lvds_lane_0.tp.0 pfet_03v3 ad=1.248p pd=5.32u as=1.248p ps=5.32u w=4.8u l=0.4u
X753 VSS VSS VSS VSS nfet_03v3 ad=0.52p pd=2.52u as=0 ps=0 w=2u l=0.28u
X754 lvds_lane_2.tn.0 lvds_lane_2.gn.0 lvds_lane_2.ob.0 VSS nfet_03v3 ad=1.235p pd=5.27u as=1.235p ps=5.27u w=4.75u l=0.5u
X755 VDD lvds_lane_0.d2a.0 lvds_lane_0.d2b.0 VDD pfet_03v3 ad=0.52p pd=2.52u as=0.52p ps=2.52u w=2u l=0.28u
X756 lvds_lane_1.tp.0 lvds_lane_0.VBP.0 VDD VDD pfet_03v3 ad=1.3p pd=5.52u as=1.3p ps=5.52u w=5u l=1u
X757 lvds_lane_1.fa.0 lvds_lane_0.VB2.0 lvds_lane_1.oa.0 VSS nfet_03v3 ad=1.1752p pd=5.04u as=1.1752p ps=5.04u w=4.52u l=0.5u
X758 lvds_lane_0.fa.0 lvds_lane_0.gp.0 lvds_lane_0.tp.0 lvds_lane_0.tp.0 pfet_03v3 ad=1.248p pd=5.32u as=1.248p ps=5.32u w=4.8u l=0.4u
X759 lvds_lane_1.tp.0 lvds_lane_0.VREF.0 lvds_lane_1.fa.0 lvds_lane_1.tp.0 pfet_03v3 ad=1.248p pd=5.32u as=1.248p ps=5.32u w=4.8u l=0.4u
X760 lvds_lane_2.tp.0 lvds_lane_0.VREF.0 lvds_lane_2.fa.0 lvds_lane_2.tp.0 pfet_03v3 ad=1.248p pd=5.32u as=1.248p ps=5.32u w=4.8u l=0.4u
D8 VSS lvds_lane_1.gp.0 diode_nd2ps_03v3 pj=26u area=40p
X761 lvds_lane_0.oa.0 lvds_lane_0.gp.0 lvds_lane_0.tn.0 VSS nfet_03v3 ad=1.235p pd=5.27u as=1.235p ps=5.27u w=4.75u l=0.5u
X762 lvds_lane_1.tn.0 lvds_lane_0.VBN.0 VSS VSS nfet_03v3 ad=0.65p pd=3.02u as=0.65p ps=3.02u w=2.5u l=1u
X763 VDD lvds_bias_0.enb.0 lvds_bias_0.nrb.0 VDD pfet_03v3 ad=1.3p pd=5.52u as=1.3p ps=5.52u w=5u l=0.5u
X764 lvds_lane_0.tp.0 lvds_lane_0.gn.0 lvds_lane_0.fb.0 lvds_lane_0.tp.0 pfet_03v3 ad=1.248p pd=5.32u as=1.248p ps=5.32u w=4.8u l=0.4u
X765 lvds_lane_2.fb.0 lvds_lane_2.gn.0 lvds_lane_2.tp.0 lvds_lane_2.tp.0 pfet_03v3 ad=1.248p pd=5.32u as=1.248p ps=5.32u w=4.8u l=0.4u
X766 lvds_lane_1.fa.0 lvds_lane_0.VB2.0 lvds_lane_1.oa.0 VSS nfet_03v3 ad=1.1752p pd=5.04u as=1.1752p ps=5.04u w=4.52u l=0.5u
X767 lvds_lane_2.tn.0 VSS VSS VSS nfet_03v3 ad=0.65p pd=3.02u as=1.1p ps=5.88u w=2.5u l=1u
X768 lvds_lane_2.tp.0 lvds_lane_0.VREF.0 lvds_lane_2.fa.0 lvds_lane_2.tp.0 pfet_03v3 ad=1.248p pd=5.32u as=1.248p ps=5.32u w=4.8u l=0.4u
X769 lvds_lane_2.oa.0 lvds_lane_0.VREF.0 lvds_lane_2.tn.0 VSS nfet_03v3 ad=1.235p pd=5.27u as=1.235p ps=5.27u w=4.75u l=0.5u
X770 VDD lvds_lane_2.d2a.0 lvds_lane_2.n3a.0 VDD pfet_03v3 ad=0.52p pd=2.52u as=0.52p ps=2.52u w=2u l=0.28u
X771 lvds_lane_0.tn.0 lvds_lane_0.VREF.0 lvds_lane_0.ob.0 VSS nfet_03v3 ad=1.235p pd=5.27u as=1.235p ps=5.27u w=4.75u l=0.5u
X772 VDD lvds_lane_0.d2a.0 lvds_lane_0.n3a.0 VDD pfet_03v3 ad=0.52p pd=2.52u as=0.52p ps=2.52u w=2u l=0.28u
X773 VDD lvds_lane_1.rla_m1.0 VSS ppolyf_u_1k r_width=2u r_length=9.11u
X774 VDD lvds_lane_2.d2a.0 lvds_lane_2.d2a.0 VDD pfet_03v3 ad=0.52p pd=2.52u as=0.52p ps=2.52u w=2u l=0.28u
X775 lvds_lane_0.gp.0 RX0_P VDD ppolyf_u r_width=5u r_length=1.8u
X776 VDD VDD RX0_O VDD pfet_03v3 ad=2.2p pd=10.88u as=1.3p ps=5.52u w=5u l=0.28u
X777 VDD lvds_lane_0.VBP.0 lvds_lane_0.tp.0 VDD pfet_03v3 ad=1.3p pd=5.52u as=1.3p ps=5.52u w=5u l=1u
X778 lvds_lane_1.tn.0 lvds_lane_1.gp.0 lvds_lane_1.oa.0 VSS nfet_03v3 ad=1.235p pd=5.27u as=1.235p ps=5.27u w=4.75u l=0.5u
X779 lvds_lane_2.ob.0 lvds_lane_0.VREF.0 lvds_lane_2.tn.0 VSS nfet_03v3 ad=1.235p pd=5.27u as=1.235p ps=5.27u w=4.75u l=0.5u
X780 VSS VSS VSS VSS nfet_03v3 ad=1.1396p pd=6.06u as=0 ps=0 w=2.59u l=0.28u
X781 lvds_lane_1.tp.0 lvds_lane_0.VREF.0 lvds_lane_1.fb.0 lvds_lane_1.tp.0 pfet_03v3 ad=1.248p pd=5.32u as=2.112p ps=10.48u w=4.8u l=0.4u
X782 lvds_lane_0.nd.0 VSS VSS VSS nfet_03v3 ad=0.52p pd=2.52u as=0.88p ps=4.88u w=2u l=0.28u
X783 lvds_lane_1.fa.0 lvds_lane_1.gp.0 lvds_lane_1.tp.0 lvds_lane_1.tp.0 pfet_03v3 ad=1.248p pd=5.32u as=1.248p ps=5.32u w=4.8u l=0.4u
X784 lvds_lane_0.VB2.0 lvds_lane_0.VBP.0 VDD VDD pfet_03v3 ad=1.3p pd=5.52u as=1.3p ps=5.52u w=5u l=1u
X785 lvds_lane_2.fa.0 lvds_lane_0.VREF.0 lvds_lane_2.tp.0 lvds_lane_2.tp.0 pfet_03v3 ad=1.248p pd=5.32u as=1.248p ps=5.32u w=4.8u l=0.4u
X786 lvds_lane_1.tn.0 lvds_lane_1.gn.0 lvds_lane_1.ob.0 VSS nfet_03v3 ad=1.235p pd=5.27u as=1.235p ps=5.27u w=4.75u l=0.5u
X787 lvds_lane_2.oa.0 lvds_lane_0.VREF.0 lvds_lane_2.tn.0 VSS nfet_03v3 ad=1.235p pd=5.27u as=1.235p ps=5.27u w=4.75u l=0.5u
X788 lvds_lane_0.fa.0 lvds_lane_0.VBN.0 VSS VSS nfet_03v3 ad=0.65p pd=3.02u as=0.65p ps=3.02u w=2.5u l=1u
X789 lvds_lane_2.tp.0 lvds_lane_0.VBP.0 VDD VDD pfet_03v3 ad=1.3p pd=5.52u as=1.3p ps=5.52u w=5u l=1u
X790 lvds_lane_2.fa.0 lvds_lane_2.gp.0 lvds_lane_2.tp.0 lvds_lane_2.tp.0 pfet_03v3 ad=1.248p pd=5.32u as=1.248p ps=5.32u w=4.8u l=0.4u
X791 VDD EN lvds_lane_1.d2b.0 VDD pfet_03v3 ad=0.52p pd=2.52u as=0.52p ps=2.52u w=2u l=0.5u
X792 lvds_lane_0.tp.0 lvds_lane_0.VBP.0 VDD VDD pfet_03v3 ad=1.3p pd=5.52u as=1.3p ps=5.52u w=5u l=1u
X793 lvds_lane_0.fb.0 lvds_lane_0.VBN.0 VSS VSS nfet_03v3 ad=0.65p pd=3.02u as=0.65p ps=3.02u w=2.5u l=1u
X794 lvds_lane_1.fb.0 lvds_lane_0.VBN.0 VSS VSS nfet_03v3 ad=0.65p pd=3.02u as=0.65p ps=3.02u w=2.5u l=1u
X795 VDD VDD RX2_O VDD pfet_03v3 ad=2.2p pd=10.88u as=1.3p ps=5.52u w=5u l=0.28u
X796 VSS lvds_lane_0.nd.0 lvds_lane_0.i1.0 VSS nfet_03v3 ad=0.39p pd=2.02u as=0.39p ps=2.02u w=1.5u l=0.28u
X797 VSS EN lvds_lane_0.nm.0 VSS nfet_03v3 ad=0.52p pd=2.52u as=0.52p ps=2.52u w=2u l=0.28u
X798 lvds_lane_1.tn.0 lvds_lane_0.VREF.0 lvds_lane_1.ob.0 VSS nfet_03v3 ad=1.235p pd=5.27u as=1.235p ps=5.27u w=4.75u l=0.5u
X799 lvds_lane_1.n3a.0 VDD VDD VDD pfet_03v3 ad=0.52p pd=2.52u as=0.88p ps=4.88u w=2u l=0.28u
X800 lvds_lane_1.tp.0 lvds_lane_0.VBP.0 VDD VDD pfet_03v3 ad=1.3p pd=5.52u as=1.3p ps=5.52u w=5u l=1u
X801 lvds_lane_1.tp.0 lvds_lane_0.VREF.0 lvds_lane_1.fb.0 lvds_lane_1.tp.0 pfet_03v3 ad=1.248p pd=5.32u as=1.248p ps=5.32u w=4.8u l=0.4u
X802 lvds_lane_0.i1.0 VDD VDD VDD pfet_03v3 ad=0.962p pd=4.22u as=1.628p ps=8.28u w=3.7u l=0.28u
X803 lvds_lane_0.tp.0 lvds_lane_0.gp.0 lvds_lane_0.fa.0 lvds_lane_0.tp.0 pfet_03v3 ad=1.248p pd=5.32u as=1.248p ps=5.32u w=4.8u l=0.4u
X804 VDD EN lvds_lane_2.d2a.0 VDD pfet_03v3 ad=0.52p pd=2.52u as=0.52p ps=2.52u w=2u l=0.5u
X805 lvds_lane_0.fb.0 lvds_lane_0.VREF.0 lvds_lane_0.tp.0 lvds_lane_0.tp.0 pfet_03v3 ad=1.248p pd=5.32u as=1.248p ps=5.32u w=4.8u l=0.4u
X806 lvds_lane_1.fb.0 lvds_lane_0.VREF.0 lvds_lane_1.tp.0 lvds_lane_1.tp.0 pfet_03v3 ad=1.248p pd=5.32u as=1.248p ps=5.32u w=4.8u l=0.4u
X807 lvds_lane_2.fa.0 lvds_lane_2.gp.0 lvds_lane_2.tp.0 lvds_lane_2.tp.0 pfet_03v3 ad=1.248p pd=5.32u as=1.248p ps=5.32u w=4.8u l=0.4u
X808 VSS lvds_lane_0.VBN.0 lvds_lane_2.tn.0 VSS nfet_03v3 ad=0.65p pd=3.02u as=0.65p ps=3.02u w=2.5u l=1u
X809 lvds_lane_1.tp.0 lvds_lane_0.VREF.0 lvds_lane_1.fb.0 lvds_lane_1.tp.0 pfet_03v3 ad=1.248p pd=5.32u as=1.248p ps=5.32u w=4.8u l=0.4u
X810 lvds_lane_2.tp.0 lvds_lane_2.gn.0 lvds_lane_2.fb.0 lvds_lane_2.tp.0 pfet_03v3 ad=1.248p pd=5.32u as=1.248p ps=5.32u w=4.8u l=0.4u
X811 lvds_lane_2.ob.0 lvds_lane_0.VREF.0 lvds_lane_2.tn.0 VSS nfet_03v3 ad=2.09p pd=10.38u as=1.235p ps=5.27u w=4.75u l=0.5u
X812 VDD lvds_lane_0.VBP.0 lvds_lane_2.tp.0 VDD pfet_03v3 ad=1.3p pd=5.52u as=1.3p ps=5.52u w=5u l=1u
X813 lvds_lane_1.oa.0 lvds_lane_1.gp.0 lvds_lane_1.tn.0 VSS nfet_03v3 ad=1.235p pd=5.27u as=1.235p ps=5.27u w=4.75u l=0.5u
X814 lvds_lane_2.fb.0 lvds_lane_2.gn.0 lvds_lane_2.tp.0 lvds_lane_2.tp.0 pfet_03v3 ad=1.248p pd=5.32u as=1.248p ps=5.32u w=4.8u l=0.4u
X815 VSS VSS lvds_lane_2.fb.0 VSS nfet_03v3 ad=1.9888p pd=9.92u as=1.1752p ps=5.04u w=4.52u l=0.5u
X816 lvds_lane_0.d2a.0 lvds_lane_0.d2a.0 VDD VDD pfet_03v3 ad=0.52p pd=2.52u as=0.52p ps=2.52u w=2u l=0.28u
X817 VSS VSS lvds_lane_2.d2a.0 VSS nfet_03v3 ad=1.9228p pd=9.62u as=1.1362p ps=4.89u w=4.37u l=0.5u
X818 lvds_lane_0.fa.0 lvds_lane_0.VB2.0 lvds_lane_0.oa.0 VSS nfet_03v3 ad=1.1752p pd=5.04u as=1.1752p ps=5.04u w=4.52u l=0.5u
X819 VSS lvds_lane_0.VBN.0 lvds_lane_0.fb.0 VSS nfet_03v3 ad=0.65p pd=3.02u as=0.65p ps=3.02u w=2.5u l=1u
X820 RX0_O lvds_lane_0.i2.0 VDD VDD pfet_03v3 ad=1.3p pd=5.52u as=1.3p ps=5.52u w=5u l=0.28u
X821 lvds_lane_0.d2b.0 VSS VSS VSS nfet_03v3 ad=1.1362p pd=4.89u as=1.9228p ps=9.62u w=4.37u l=0.5u
X822 lvds_lane_0.tp.0 lvds_lane_0.VREF.0 lvds_lane_0.fa.0 lvds_lane_0.tp.0 pfet_03v3 ad=1.248p pd=5.32u as=1.248p ps=5.32u w=4.8u l=0.4u
X823 VSS VSS VSS ppolyf_u_1k r_width=2u r_length=3.17u
X824 lvds_lane_2.ts.0 lvds_lane_0.VBN.0 VSS VSS nfet_03v3 ad=0.65p pd=3.02u as=0.65p ps=3.02u w=2.5u l=1u
X825 lvds_lane_0.fa.0 lvds_lane_0.VB2.0 lvds_lane_0.oa.0 VSS nfet_03v3 ad=1.1752p pd=5.04u as=1.1752p ps=5.04u w=4.52u l=0.5u
X826 lvds_lane_1.d3.0 lvds_lane_1.d2b.0 VDD VDD pfet_03v3 ad=0.52p pd=2.52u as=0.52p ps=2.52u w=2u l=0.28u
X827 lvds_lane_2.tp.0 lvds_lane_2.gn.0 lvds_lane_2.fb.0 lvds_lane_2.tp.0 pfet_03v3 ad=1.248p pd=5.32u as=1.248p ps=5.32u w=4.8u l=0.4u
X828 VDD lvds_lane_0.rlb_m1.0 VSS ppolyf_u_1k r_width=2u r_length=9.11u
X829 lvds_lane_2.fb.0 lvds_lane_2.gn.0 lvds_lane_2.tp.0 lvds_lane_2.tp.0 pfet_03v3 ad=1.248p pd=5.32u as=1.248p ps=5.32u w=4.8u l=0.4u
X830 lvds_lane_0.tn.0 lvds_lane_0.VREF.0 lvds_lane_0.oa.0 VSS nfet_03v3 ad=1.235p pd=5.27u as=1.235p ps=5.27u w=4.75u l=0.5u
X831 VSS lvds_lane_0.VBN.0 lvds_lane_1.fb.0 VSS nfet_03v3 ad=0.65p pd=3.02u as=0.65p ps=3.02u w=2.5u l=1u
X832 lvds_lane_2.d2b.0 lvds_lane_2.d2b.0 VDD VDD pfet_03v3 ad=0.52p pd=2.52u as=0.52p ps=2.52u w=2u l=0.28u
X833 lvds_lane_0.fa.0 VSS VSS VSS nfet_03v3 ad=0.65p pd=3.02u as=1.1p ps=5.88u w=2.5u l=1u
X834 RX2_O lvds_lane_2.i2.0 VDD VDD pfet_03v3 ad=1.3p pd=5.52u as=1.3p ps=5.52u w=5u l=0.28u
X835 lvds_lane_0.fb.0 lvds_lane_0.VB2.0 lvds_lane_0.ob.0 VSS nfet_03v3 ad=1.1752p pd=5.04u as=1.1752p ps=5.04u w=4.52u l=0.5u
X836 VDD lvds_lane_0.VBP.0 lvds_lane_1.tp.0 VDD pfet_03v3 ad=1.3p pd=5.52u as=1.3p ps=5.52u w=5u l=1u
X837 lvds_lane_1.tp.0 lvds_lane_1.gp.0 lvds_lane_1.fa.0 lvds_lane_1.tp.0 pfet_03v3 ad=1.248p pd=5.32u as=1.248p ps=5.32u w=4.8u l=0.4u
X838 lvds_lane_0.ts.0 lvds_lane_0.VBN.0 VSS VSS nfet_03v3 ad=0.65p pd=3.02u as=0.65p ps=3.02u w=2.5u l=1u
X839 lvds_lane_0.VBP.0 lvds_lane_0.VBN.0 VSS VSS nfet_03v3 ad=0.65p pd=3.02u as=0.65p ps=3.02u w=2.5u l=1u
X840 lvds_lane_0.tp.0 lvds_lane_0.VREF.0 lvds_lane_0.fa.0 lvds_lane_0.tp.0 pfet_03v3 ad=1.248p pd=5.32u as=1.248p ps=5.32u w=4.8u l=0.4u
X841 lvds_lane_2.ts.0 lvds_lane_2.sb.0 VSS ppolyf_u_1k r_width=2u r_length=3.17u
X842 lvds_lane_0.tp.0 lvds_lane_0.VREF.0 lvds_lane_0.fb.0 lvds_lane_0.tp.0 pfet_03v3 ad=1.248p pd=5.32u as=1.248p ps=5.32u w=4.8u l=0.4u
X843 lvds_lane_2.fa.0 lvds_lane_2.gp.0 lvds_lane_2.tp.0 lvds_lane_2.tp.0 pfet_03v3 ad=1.248p pd=5.32u as=1.248p ps=5.32u w=4.8u l=0.4u
X844 lvds_bias_0.rb_m3.0 lvds_lane_0.VBN.0 VSS ppolyf_u_1k r_width=2u r_length=22.27u
X845 lvds_lane_0.tn.0 lvds_lane_0.gn.0 lvds_lane_0.ob.0 VSS nfet_03v3 ad=1.235p pd=5.27u as=1.235p ps=5.27u w=4.75u l=0.5u
X846 VDD lvds_lane_0.d2a.0 lvds_lane_0.n3a.0 VDD pfet_03v3 ad=0.52p pd=2.52u as=0.52p ps=2.52u w=2u l=0.28u
X847 lvds_lane_1.fb.0 lvds_lane_1.gn.0 lvds_lane_1.tp.0 lvds_lane_1.tp.0 pfet_03v3 ad=1.248p pd=5.32u as=1.248p ps=5.32u w=4.8u l=0.4u
X848 lvds_lane_0.fa.0 lvds_lane_0.VBN.0 VSS VSS nfet_03v3 ad=0.65p pd=3.02u as=0.65p ps=3.02u w=2.5u l=1u
X849 VDD VDD VDD VDD pfet_03v3 ad=0.962p pd=4.22u as=0 ps=0 w=3.7u l=0.28u
X850 lvds_lane_0.tp.0 lvds_lane_0.VBP.0 VDD VDD pfet_03v3 ad=1.3p pd=5.52u as=1.3p ps=5.52u w=5u l=1u
X851 VSS lvds_lane_0.VBN.0 lvds_lane_2.ts.0 VSS nfet_03v3 ad=0.65p pd=3.02u as=0.65p ps=3.02u w=2.5u l=1u
X852 lvds_lane_0.tn.0 lvds_lane_0.VREF.0 lvds_lane_0.oa.0 VSS nfet_03v3 ad=1.235p pd=5.27u as=1.235p ps=5.27u w=4.75u l=0.5u
X853 lvds_lane_0.d2b.0 lvds_lane_0.d2a.0 VDD VDD pfet_03v3 ad=0.52p pd=2.52u as=0.52p ps=2.52u w=2u l=0.28u
X854 lvds_lane_0.tp.0 lvds_lane_0.gn.0 lvds_lane_0.fb.0 lvds_lane_0.tp.0 pfet_03v3 ad=1.248p pd=5.32u as=1.248p ps=5.32u w=4.8u l=0.4u
X855 lvds_lane_1.tp.0 lvds_lane_1.gn.0 lvds_lane_1.fb.0 lvds_lane_1.tp.0 pfet_03v3 ad=1.248p pd=5.32u as=1.248p ps=5.32u w=4.8u l=0.4u
X856 lvds_lane_2.tn.0 lvds_lane_2.gn.0 lvds_lane_2.ob.0 VSS nfet_03v3 ad=1.235p pd=5.27u as=1.235p ps=5.27u w=4.75u l=0.5u
X857 lvds_lane_1.d2b.0 lvds_lane_1.d2a.0 VDD VDD pfet_03v3 ad=0.52p pd=2.52u as=0.52p ps=2.52u w=2u l=0.28u
X858 lvds_lane_1.fb.0 lvds_lane_0.VREF.0 lvds_lane_1.tp.0 lvds_lane_1.tp.0 pfet_03v3 ad=1.248p pd=5.32u as=1.248p ps=5.32u w=4.8u l=0.4u
X859 lvds_lane_2.tp.0 lvds_lane_2.gn.0 lvds_lane_2.fb.0 lvds_lane_2.tp.0 pfet_03v3 ad=1.248p pd=5.32u as=1.248p ps=5.32u w=4.8u l=0.4u
X860 VSS lvds_lane_0.VBN.0 lvds_lane_0.fa.0 VSS nfet_03v3 ad=0.65p pd=3.02u as=0.65p ps=3.02u w=2.5u l=1u
X861 VDD lvds_lane_0.i1.0 lvds_lane_0.i2.0 VDD pfet_03v3 ad=0.975p pd=4.27u as=0.975p ps=4.27u w=3.75u l=0.28u
X862 lvds_lane_2.tn.0 lvds_lane_2.gp.0 lvds_lane_2.oa.0 VSS nfet_03v3 ad=1.235p pd=5.27u as=1.235p ps=5.27u w=4.75u l=0.5u
X863 VSS lvds_lane_0.VBN.0 lvds_lane_1.fb.0 VSS nfet_03v3 ad=0.65p pd=3.02u as=0.65p ps=3.02u w=2.5u l=1u
X864 VSS lvds_lane_0.VBN.0 lvds_lane_0.tn.0 VSS nfet_03v3 ad=0.65p pd=3.02u as=0.65p ps=3.02u w=2.5u l=1u
X865 lvds_lane_1.n3a.0 lvds_lane_1.d2a.0 VDD VDD pfet_03v3 ad=0.52p pd=2.52u as=0.52p ps=2.52u w=2u l=0.28u
X866 lvds_lane_2.ts.0 lvds_lane_0.VBN.0 VSS VSS nfet_03v3 ad=0.65p pd=3.02u as=0.65p ps=3.02u w=2.5u l=1u
D9 lvds_lane_2.gn.0 VDD diode_pd2nw_03v3 pj=26u area=40p
X867 lvds_lane_0.ob.0 lvds_lane_0.gn.0 lvds_lane_0.tn.0 VSS nfet_03v3 ad=1.235p pd=5.27u as=1.235p ps=5.27u w=4.75u l=0.5u
X868 lvds_lane_2.fb.0 lvds_lane_0.VREF.0 lvds_lane_2.tp.0 lvds_lane_2.tp.0 pfet_03v3 ad=2.112p pd=10.48u as=1.248p ps=5.32u w=4.8u l=0.4u
X869 lvds_lane_1.d2a.0 lvds_lane_1.d2b.0 VDD VDD pfet_03v3 ad=0.52p pd=2.52u as=0.52p ps=2.52u w=2u l=0.28u
X870 lvds_lane_0.ts.0 VSS VSS VSS nfet_03v3 ad=0.65p pd=3.02u as=1.1p ps=5.88u w=2.5u l=1u
X871 lvds_lane_2.n3a.0 lvds_lane_2.d2a.0 VDD VDD pfet_03v3 ad=0.52p pd=2.52u as=0.52p ps=2.52u w=2u l=0.28u
X872 lvds_lane_2.fb.0 lvds_lane_2.gn.0 lvds_lane_2.tp.0 lvds_lane_2.tp.0 pfet_03v3 ad=1.248p pd=5.32u as=1.248p ps=5.32u w=4.8u l=0.4u
X873 lvds_lane_0.ob.0 lvds_lane_0.gn.0 lvds_lane_0.tn.0 VSS nfet_03v3 ad=1.235p pd=5.27u as=1.235p ps=5.27u w=4.75u l=0.5u
X874 VDD lvds_bias_0.enb.0 lvds_bias_0.nrb.0 VDD pfet_03v3 ad=1.3p pd=5.52u as=1.3p ps=5.52u w=5u l=0.5u
X875 VDD VDD lvds_bias_0.nrb.0 VDD pfet_03v3 ad=2.2p pd=10.88u as=1.3p ps=5.52u w=5u l=0.5u
X876 VSS lvds_lane_2.n3a.0 lvds_lane_2.d3.0 VSS nfet_03v3 ad=0.6734p pd=3.11u as=0.6734p ps=3.11u w=2.59u l=0.28u
X877 lvds_lane_1.tp.0 lvds_lane_1.gp.0 lvds_lane_1.fa.0 lvds_lane_1.tp.0 pfet_03v3 ad=1.248p pd=5.32u as=1.248p ps=5.32u w=4.8u l=0.4u
X878 lvds_lane_1.oa.0 lvds_lane_0.VREF.0 lvds_lane_1.tn.0 VSS nfet_03v3 ad=1.235p pd=5.27u as=1.235p ps=5.27u w=4.75u l=0.5u
X879 lvds_lane_0.fb.0 lvds_lane_0.VBN.0 VSS VSS nfet_03v3 ad=0.65p pd=3.02u as=0.65p ps=3.02u w=2.5u l=1u
X880 lvds_lane_0.oa.0 lvds_lane_0.gp.0 lvds_lane_0.tn.0 VSS nfet_03v3 ad=1.235p pd=5.27u as=1.235p ps=5.27u w=4.75u l=0.5u
X881 VDD lvds_lane_0.d2b.0 lvds_lane_0.d2a.0 VDD pfet_03v3 ad=0.52p pd=2.52u as=0.52p ps=2.52u w=2u l=0.28u
X882 VSS VSS lvds_lane_2.d2b.0 VSS nfet_03v3 ad=1.9228p pd=9.62u as=1.1362p ps=4.89u w=4.37u l=0.5u
X883 VSS lvds_lane_0.VBN.0 lvds_lane_2.fb.0 VSS nfet_03v3 ad=0.65p pd=3.02u as=0.65p ps=3.02u w=2.5u l=1u
X884 VDD lvds_bias_0.enb.0 lvds_bias_0.nrb.0 VDD pfet_03v3 ad=1.3p pd=5.52u as=1.3p ps=5.52u w=5u l=0.5u
X885 lvds_lane_2.fb.0 lvds_lane_2.gn.0 lvds_lane_2.tp.0 lvds_lane_2.tp.0 pfet_03v3 ad=1.248p pd=5.32u as=1.248p ps=5.32u w=4.8u l=0.4u
X886 lvds_lane_0.tn.0 lvds_lane_0.VBN.0 VSS VSS nfet_03v3 ad=0.65p pd=3.02u as=0.65p ps=3.02u w=2.5u l=1u
X887 lvds_lane_0.tp.0 VDD VDD VDD pfet_03v3 ad=1.3p pd=5.52u as=2.2p ps=10.88u w=5u l=1u
X888 lvds_lane_1.ob.0 lvds_lane_0.VB2.0 lvds_lane_1.fb.0 VSS nfet_03v3 ad=1.1752p pd=5.04u as=1.1752p ps=5.04u w=4.52u l=0.5u
X889 VSS lvds_lane_0.VBN.0 lvds_lane_2.ts.0 VSS nfet_03v3 ad=0.65p pd=3.02u as=0.65p ps=3.02u w=2.5u l=1u
D10 VSS lvds_lane_2.gn.0 diode_nd2ps_03v3 pj=26u area=40p
X890 lvds_lane_0.tp.0 lvds_lane_0.gp.0 lvds_lane_0.fa.0 lvds_lane_0.tp.0 pfet_03v3 ad=1.248p pd=5.32u as=1.248p ps=5.32u w=4.8u l=0.4u
X891 lvds_lane_1.ob.0 lvds_lane_0.VREF.0 lvds_lane_1.tn.0 VSS nfet_03v3 ad=1.235p pd=5.27u as=1.235p ps=5.27u w=4.75u l=0.5u
X892 lvds_lane_0.VBN.0 VSS VSS VSS nfet_03v3 ad=0.65p pd=3.02u as=1.1p ps=5.88u w=2.5u l=1u
X893 VDD lvds_lane_2.d2b.0 lvds_lane_2.d2b.0 VDD pfet_03v3 ad=0.52p pd=2.52u as=0.52p ps=2.52u w=2u l=0.28u
X894 VDD lvds_lane_0.d2b.0 lvds_lane_0.d3.0 VDD pfet_03v3 ad=0.52p pd=2.52u as=0.52p ps=2.52u w=2u l=0.28u
X895 VDD lvds_lane_0.VBP.0 lvds_lane_0.VBP.0 VDD pfet_03v3 ad=1.3p pd=5.52u as=1.3p ps=5.52u w=5u l=1u
X896 lvds_lane_2.nm.0 lvds_lane_2.d3.0 lvds_lane_2.nd.0 VSS nfet_03v3 ad=0.52p pd=2.52u as=0.52p ps=2.52u w=2u l=0.28u
X897 lvds_lane_2.i2.0 VDD VDD VDD pfet_03v3 ad=0.975p pd=4.27u as=1.65p ps=8.38u w=3.75u l=0.28u
X898 lvds_lane_0.fa.0 lvds_lane_0.gp.0 lvds_lane_0.tp.0 lvds_lane_0.tp.0 pfet_03v3 ad=1.248p pd=5.32u as=1.248p ps=5.32u w=4.8u l=0.4u
X899 lvds_lane_1.fa.0 lvds_lane_0.VREF.0 lvds_lane_1.tp.0 lvds_lane_1.tp.0 pfet_03v3 ad=1.248p pd=5.32u as=1.248p ps=5.32u w=4.8u l=0.4u
X900 VDD lvds_lane_1.d2b.0 lvds_lane_1.d3.0 VDD pfet_03v3 ad=0.52p pd=2.52u as=0.52p ps=2.52u w=2u l=0.28u
X901 VDD lvds_lane_0.d2b.0 lvds_lane_0.d2a.0 VDD pfet_03v3 ad=0.52p pd=2.52u as=0.52p ps=2.52u w=2u l=0.28u
X902 lvds_lane_1.tn.0 lvds_lane_1.gp.0 lvds_lane_1.oa.0 VSS nfet_03v3 ad=1.235p pd=5.27u as=1.235p ps=5.27u w=4.75u l=0.5u
X903 lvds_bias_0.rdt_m2.0 lvds_bias_0.rdt_m3.0 VSS ppolyf_u_1k r_width=2u r_length=21.01u
X904 lvds_lane_1.fa.0 lvds_lane_0.VBN.0 VSS VSS nfet_03v3 ad=0.65p pd=3.02u as=0.65p ps=3.02u w=2.5u l=1u
X905 VSS lvds_lane_0.n3a.0 lvds_lane_0.n3a.0 VSS nfet_03v3 ad=0.6734p pd=3.11u as=0.6734p ps=3.11u w=2.59u l=0.28u
X906 VSS lvds_lane_0.VBN.0 lvds_lane_2.ts.0 VSS nfet_03v3 ad=0.65p pd=3.02u as=0.65p ps=3.02u w=2.5u l=1u
X907 lvds_lane_0.tp.0 lvds_lane_0.VREF.0 lvds_lane_0.fb.0 lvds_lane_0.tp.0 pfet_03v3 ad=1.248p pd=5.32u as=1.248p ps=5.32u w=4.8u l=0.4u
X908 lvds_lane_2.fb.0 lvds_lane_0.VREF.0 lvds_lane_2.tp.0 lvds_lane_2.tp.0 pfet_03v3 ad=1.248p pd=5.32u as=1.248p ps=5.32u w=4.8u l=0.4u
X909 VSS VSS VSS ppolyf_u_1k r_width=2u r_length=9.11u
X910 lvds_lane_1.fa.0 lvds_lane_0.VREF.0 lvds_lane_1.tp.0 lvds_lane_1.tp.0 pfet_03v3 ad=1.248p pd=5.32u as=1.248p ps=5.32u w=4.8u l=0.4u
X911 lvds_lane_1.tn.0 lvds_lane_0.VBN.0 VSS VSS nfet_03v3 ad=0.65p pd=3.02u as=0.65p ps=3.02u w=2.5u l=1u
X912 lvds_lane_2.fa.0 lvds_lane_0.VREF.0 lvds_lane_2.tp.0 lvds_lane_2.tp.0 pfet_03v3 ad=1.248p pd=5.32u as=1.248p ps=5.32u w=4.8u l=0.4u
X913 VSS lvds_lane_0.VBN.0 lvds_lane_0.ts.0 VSS nfet_03v3 ad=0.65p pd=3.02u as=0.65p ps=3.02u w=2.5u l=1u
X914 lvds_lane_1.d2a.0 lvds_lane_1.d2b.0 VDD VDD pfet_03v3 ad=0.52p pd=2.52u as=0.52p ps=2.52u w=2u l=0.28u
X915 lvds_lane_0.fa.0 lvds_lane_0.gp.0 lvds_lane_0.tp.0 lvds_lane_0.tp.0 pfet_03v3 ad=1.248p pd=5.32u as=1.248p ps=5.32u w=4.8u l=0.4u
X916 lvds_lane_2.tp.0 lvds_lane_0.VREF.0 lvds_lane_2.fa.0 lvds_lane_2.tp.0 pfet_03v3 ad=1.248p pd=5.32u as=1.248p ps=5.32u w=4.8u l=0.4u
X917 VSS lvds_lane_0.VBN.0 lvds_lane_1.ts.0 VSS nfet_03v3 ad=0.65p pd=3.02u as=0.65p ps=3.02u w=2.5u l=1u
X918 VDD VDD lvds_lane_1.i2.0 VDD pfet_03v3 ad=1.65p pd=8.38u as=0.975p ps=4.27u w=3.75u l=0.28u
X919 lvds_lane_1.d3.0 lvds_lane_1.d2b.0 VDD VDD pfet_03v3 ad=0.52p pd=2.52u as=0.52p ps=2.52u w=2u l=0.28u
X920 lvds_lane_0.fb.0 lvds_lane_0.VREF.0 lvds_lane_0.tp.0 lvds_lane_0.tp.0 pfet_03v3 ad=1.248p pd=5.32u as=1.248p ps=5.32u w=4.8u l=0.4u
X921 lvds_lane_1.tp.0 lvds_lane_1.gn.0 lvds_lane_1.fb.0 lvds_lane_1.tp.0 pfet_03v3 ad=1.248p pd=5.32u as=1.248p ps=5.32u w=4.8u l=0.4u
X922 lvds_lane_1.fa.0 lvds_lane_0.VREF.0 lvds_lane_1.tp.0 lvds_lane_1.tp.0 pfet_03v3 ad=1.248p pd=5.32u as=1.248p ps=5.32u w=4.8u l=0.4u
X923 lvds_lane_0.nd.0 EN VDD VDD pfet_03v3 ad=0.78p pd=3.52u as=0.78p ps=3.52u w=3u l=0.28u
X924 lvds_lane_1.d2a.0 VDD VDD VDD pfet_03v3 ad=0.52p pd=2.52u as=0.88p ps=4.88u w=2u l=0.28u
X925 lvds_lane_0.d2a.0 lvds_lane_0.oa.0 lvds_lane_0.sa.0 VSS nfet_03v3 ad=1.1362p pd=4.89u as=1.1362p ps=4.89u w=4.37u l=0.5u
X926 lvds_lane_0.tp.0 lvds_lane_0.gp.0 lvds_lane_0.fa.0 lvds_lane_0.tp.0 pfet_03v3 ad=1.248p pd=5.32u as=1.248p ps=5.32u w=4.8u l=0.4u
X927 lvds_lane_2.fa.0 lvds_lane_2.gp.0 lvds_lane_2.tp.0 lvds_lane_2.tp.0 pfet_03v3 ad=1.248p pd=5.32u as=1.248p ps=5.32u w=4.8u l=0.4u
X928 lvds_lane_2.d3.0 lvds_lane_2.d2b.0 VDD VDD pfet_03v3 ad=0.52p pd=2.52u as=0.52p ps=2.52u w=2u l=0.28u
X929 lvds_lane_1.ts.0 lvds_lane_1.sa.0 VSS ppolyf_u_1k r_width=2u r_length=3.17u
X930 VSS lvds_lane_0.VBN.0 lvds_lane_0.tn.0 VSS nfet_03v3 ad=0.65p pd=3.02u as=0.65p ps=3.02u w=2.5u l=1u
X931 lvds_lane_0.VBN.0 lvds_lane_0.VBN.0 VSS VSS nfet_03v3 ad=0.65p pd=3.02u as=0.65p ps=3.02u w=2.5u l=1u
X932 lvds_lane_2.d2b.0 lvds_lane_2.d2a.0 VDD VDD pfet_03v3 ad=0.52p pd=2.52u as=0.52p ps=2.52u w=2u l=0.28u
X933 lvds_lane_0.d3.0 lvds_lane_0.d2b.0 VDD VDD pfet_03v3 ad=0.52p pd=2.52u as=0.52p ps=2.52u w=2u l=0.28u
X934 VDD lvds_lane_0.VBP.0 lvds_lane_0.tp.0 VDD pfet_03v3 ad=1.3p pd=5.52u as=1.3p ps=5.52u w=5u l=1u
X935 lvds_lane_1.tp.0 lvds_lane_0.VREF.0 lvds_lane_1.fb.0 lvds_lane_1.tp.0 pfet_03v3 ad=1.248p pd=5.32u as=1.248p ps=5.32u w=4.8u l=0.4u
X936 lvds_lane_2.tp.0 lvds_lane_2.gn.0 lvds_lane_2.fb.0 lvds_lane_2.tp.0 pfet_03v3 ad=1.248p pd=5.32u as=1.248p ps=5.32u w=4.8u l=0.4u
X937 VSS lvds_lane_0.VBN.0 lvds_lane_2.fa.0 VSS nfet_03v3 ad=0.65p pd=3.02u as=0.65p ps=3.02u w=2.5u l=1u
X938 lvds_lane_2.sa.0 lvds_lane_2.oa.0 lvds_lane_2.d2a.0 VSS nfet_03v3 ad=1.1362p pd=4.89u as=1.1362p ps=4.89u w=4.37u l=0.5u
X939 VSS VSS VSS ppolyf_u_1k r_width=2u r_length=9.11u
X940 VDD lvds_lane_0.VBP.0 lvds_lane_1.tp.0 VDD pfet_03v3 ad=1.3p pd=5.52u as=1.3p ps=5.52u w=5u l=1u
X941 lvds_lane_0.fa.0 lvds_lane_0.VBN.0 VSS VSS nfet_03v3 ad=0.65p pd=3.02u as=0.65p ps=3.02u w=2.5u l=1u
X942 lvds_lane_0.VBP.0 lvds_lane_0.VBP.0 VDD VDD pfet_03v3 ad=1.3p pd=5.52u as=1.3p ps=5.52u w=5u l=1u
X943 VSS VSS VSS VSS nfet_03v3 ad=0.6734p pd=3.11u as=0 ps=0 w=2.59u l=0.28u
X944 lvds_lane_0.tp.0 lvds_lane_0.VBP.0 VDD VDD pfet_03v3 ad=1.3p pd=5.52u as=1.3p ps=5.52u w=5u l=1u
X945 lvds_lane_0.fa.0 lvds_lane_0.VB2.0 lvds_lane_0.oa.0 VSS nfet_03v3 ad=1.1752p pd=5.04u as=1.1752p ps=5.04u w=4.52u l=0.5u
X946 lvds_lane_0.tp.0 lvds_lane_0.VREF.0 lvds_lane_0.fa.0 lvds_lane_0.tp.0 pfet_03v3 ad=1.248p pd=5.32u as=1.248p ps=5.32u w=4.8u l=0.4u
X947 lvds_lane_1.tp.0 lvds_lane_0.VREF.0 lvds_lane_1.fa.0 lvds_lane_1.tp.0 pfet_03v3 ad=1.248p pd=5.32u as=1.248p ps=5.32u w=4.8u l=0.4u
D11 VSS lvds_lane_0.gp.0 diode_nd2ps_03v3 pj=26u area=40p
X948 lvds_lane_1.fb.0 lvds_lane_1.gn.0 lvds_lane_1.tp.0 lvds_lane_1.tp.0 pfet_03v3 ad=1.248p pd=5.32u as=1.248p ps=5.32u w=4.8u l=0.4u
X949 lvds_lane_0.tn.0 lvds_lane_0.VBN.0 VSS VSS nfet_03v3 ad=0.65p pd=3.02u as=0.65p ps=3.02u w=2.5u l=1u
X950 VDD VDD VDD VDD pfet_03v3 ad=0.52p pd=2.52u as=0 ps=0 w=2u l=0.5u
X951 VDD lvds_lane_1.d2b.0 lvds_lane_1.d2b.0 VDD pfet_03v3 ad=0.52p pd=2.52u as=0.52p ps=2.52u w=2u l=0.28u
X952 VSS lvds_lane_0.VBN.0 lvds_lane_2.fb.0 VSS nfet_03v3 ad=0.65p pd=3.02u as=0.65p ps=3.02u w=2.5u l=1u
X953 lvds_lane_0.fa.0 lvds_lane_0.VB2.0 lvds_lane_0.oa.0 VSS nfet_03v3 ad=1.1752p pd=5.04u as=1.1752p ps=5.04u w=4.52u l=0.5u
X954 lvds_lane_2.oa.0 lvds_lane_0.VB2.0 lvds_lane_2.fa.0 VSS nfet_03v3 ad=1.1752p pd=5.04u as=1.1752p ps=5.04u w=4.52u l=0.5u
X955 lvds_lane_1.tn.0 VSS VSS VSS nfet_03v3 ad=0.65p pd=3.02u as=1.1p ps=5.88u w=2.5u l=1u
X956 VDD lvds_lane_0.VBP.0 lvds_lane_2.tp.0 VDD pfet_03v3 ad=1.3p pd=5.52u as=1.3p ps=5.52u w=5u l=1u
X957 lvds_lane_1.oa.0 lvds_lane_0.VREF.0 lvds_lane_1.tn.0 VSS nfet_03v3 ad=1.235p pd=5.27u as=1.235p ps=5.27u w=4.75u l=0.5u
X958 VDD lvds_lane_1.d2a.0 lvds_lane_1.n3a.0 VDD pfet_03v3 ad=0.52p pd=2.52u as=0.52p ps=2.52u w=2u l=0.28u
X959 lvds_lane_1.ts.0 lvds_lane_0.VBN.0 VSS VSS nfet_03v3 ad=0.65p pd=3.02u as=0.65p ps=3.02u w=2.5u l=1u
X960 lvds_lane_0.VBP.0 VDD VDD VDD pfet_03v3 ad=0.52p pd=2.52u as=0.88p ps=4.88u w=2u l=0.5u
X961 VDD lvds_lane_0.rla_m1.0 VSS ppolyf_u_1k r_width=2u r_length=9.11u
X962 VDD VDD lvds_lane_2.tp.0 VDD pfet_03v3 ad=2.2p pd=10.88u as=1.3p ps=5.52u w=5u l=1u
X963 lvds_lane_2.oa.0 VSS VSS VSS nfet_03v3 ad=1.1752p pd=5.04u as=1.9888p ps=9.92u w=4.52u l=0.5u
X964 VDD lvds_lane_1.d2a.0 lvds_lane_1.d2a.0 VDD pfet_03v3 ad=0.52p pd=2.52u as=0.52p ps=2.52u w=2u l=0.28u
X965 VDD lvds_lane_2.d2a.0 lvds_lane_2.n3a.0 VDD pfet_03v3 ad=0.52p pd=2.52u as=0.52p ps=2.52u w=2u l=0.28u
X966 lvds_lane_0.tn.0 lvds_lane_0.gp.0 lvds_lane_0.oa.0 VSS nfet_03v3 ad=1.235p pd=5.27u as=1.235p ps=5.27u w=4.75u l=0.5u
X967 lvds_lane_1.ob.0 lvds_lane_0.VREF.0 lvds_lane_1.tn.0 VSS nfet_03v3 ad=1.235p pd=5.27u as=1.235p ps=5.27u w=4.75u l=0.5u
X968 lvds_lane_2.n3a.0 lvds_lane_2.n3a.0 VSS VSS nfet_03v3 ad=0.6734p pd=3.11u as=0.6734p ps=3.11u w=2.59u l=0.28u
X969 lvds_lane_0.tp.0 lvds_lane_0.VREF.0 lvds_lane_0.fb.0 lvds_lane_0.tp.0 pfet_03v3 ad=1.248p pd=5.32u as=2.112p ps=10.48u w=4.8u l=0.4u
X970 lvds_lane_2.fb.0 lvds_lane_2.gn.0 lvds_lane_2.tp.0 lvds_lane_2.tp.0 pfet_03v3 ad=1.248p pd=5.32u as=1.248p ps=5.32u w=4.8u l=0.4u
X971 lvds_lane_0.fa.0 lvds_lane_0.gp.0 lvds_lane_0.tp.0 lvds_lane_0.tp.0 pfet_03v3 ad=1.248p pd=5.32u as=1.248p ps=5.32u w=4.8u l=0.4u
X972 lvds_lane_1.tp.0 lvds_lane_0.VREF.0 lvds_lane_1.fa.0 lvds_lane_1.tp.0 pfet_03v3 ad=1.248p pd=5.32u as=1.248p ps=5.32u w=4.8u l=0.4u
X973 lvds_lane_2.fb.0 lvds_lane_0.VBN.0 VSS VSS nfet_03v3 ad=0.65p pd=3.02u as=0.65p ps=3.02u w=2.5u l=1u
X974 VDD VDD VDD VDD pfet_03v3 ad=0.52p pd=2.52u as=0 ps=0 w=2u l=0.5u
X975 lvds_lane_2.oa.0 lvds_lane_2.gp.0 lvds_lane_2.tn.0 VSS nfet_03v3 ad=1.235p pd=5.27u as=1.235p ps=5.27u w=4.75u l=0.5u
X976 lvds_lane_2.tp.0 lvds_lane_2.gp.0 lvds_lane_2.fa.0 lvds_lane_2.tp.0 pfet_03v3 ad=1.248p pd=5.32u as=1.248p ps=5.32u w=4.8u l=0.4u
X977 lvds_lane_0.tn.0 lvds_lane_0.gn.0 lvds_lane_0.ob.0 VSS nfet_03v3 ad=1.235p pd=5.27u as=1.235p ps=5.27u w=4.75u l=0.5u
X978 lvds_lane_1.oa.0 lvds_lane_0.VREF.0 lvds_lane_1.tn.0 VSS nfet_03v3 ad=1.235p pd=5.27u as=1.235p ps=5.27u w=4.75u l=0.5u
X979 lvds_lane_1.tp.0 lvds_lane_0.VBP.0 VDD VDD pfet_03v3 ad=1.3p pd=5.52u as=1.3p ps=5.52u w=5u l=1u
X980 lvds_lane_1.fa.0 lvds_lane_1.gp.0 lvds_lane_1.tp.0 lvds_lane_1.tp.0 pfet_03v3 ad=1.248p pd=5.32u as=1.248p ps=5.32u w=4.8u l=0.4u
X981 lvds_lane_2.fa.0 lvds_lane_2.gp.0 lvds_lane_2.tp.0 lvds_lane_2.tp.0 pfet_03v3 ad=1.248p pd=5.32u as=1.248p ps=5.32u w=4.8u l=0.4u
X982 VDD EN lvds_lane_0.d2b.0 VDD pfet_03v3 ad=0.52p pd=2.52u as=0.52p ps=2.52u w=2u l=0.5u
X983 lvds_lane_0.VBP.0 lvds_lane_0.VBP.0 VDD VDD pfet_03v3 ad=1.3p pd=5.52u as=1.3p ps=5.52u w=5u l=1u
X984 lvds_lane_0.fb.0 lvds_lane_0.VBN.0 VSS VSS nfet_03v3 ad=0.65p pd=3.02u as=0.65p ps=3.02u w=2.5u l=1u
X985 VDD VDD VDD VDD pfet_03v3 ad=0.65p pd=3.02u as=0 ps=0 w=2.5u l=0.28u
X986 lvds_lane_2.tp.0 lvds_lane_0.VBP.0 VDD VDD pfet_03v3 ad=1.3p pd=5.52u as=1.3p ps=5.52u w=5u l=1u
X987 lvds_lane_2.ob.0 lvds_lane_2.gn.0 lvds_lane_2.tn.0 VSS nfet_03v3 ad=1.235p pd=5.27u as=1.235p ps=5.27u w=4.75u l=0.5u
X988 lvds_lane_0.tn.0 lvds_lane_0.VREF.0 lvds_lane_0.ob.0 VSS nfet_03v3 ad=1.235p pd=5.27u as=1.235p ps=5.27u w=4.75u l=0.5u
X989 lvds_lane_0.tp.0 lvds_lane_0.VBP.0 VDD VDD pfet_03v3 ad=1.3p pd=5.52u as=1.3p ps=5.52u w=5u l=1u
X990 lvds_lane_0.tp.0 lvds_lane_0.VREF.0 lvds_lane_0.fb.0 lvds_lane_0.tp.0 pfet_03v3 ad=1.248p pd=5.32u as=1.248p ps=5.32u w=4.8u l=0.4u
X991 lvds_lane_2.d2a.0 lvds_lane_2.d2a.0 VDD VDD pfet_03v3 ad=0.52p pd=2.52u as=0.52p ps=2.52u w=2u l=0.28u
X992 lvds_lane_0.n3a.0 VDD VDD VDD pfet_03v3 ad=0.52p pd=2.52u as=0.88p ps=4.88u w=2u l=0.28u
X993 VSS VSS lvds_lane_2.ts.0 VSS nfet_03v3 ad=1.1p pd=5.88u as=0.65p ps=3.02u w=2.5u l=1u
X994 lvds_lane_1.tp.0 lvds_lane_1.gp.0 lvds_lane_1.fa.0 lvds_lane_1.tp.0 pfet_03v3 ad=1.248p pd=5.32u as=1.248p ps=5.32u w=4.8u l=0.4u
X995 lvds_lane_2.ob.0 lvds_lane_0.VREF.0 lvds_lane_2.tn.0 VSS nfet_03v3 ad=1.235p pd=5.27u as=1.235p ps=5.27u w=4.75u l=0.5u
X996 lvds_lane_0.fb.0 lvds_lane_0.VREF.0 lvds_lane_0.tp.0 lvds_lane_0.tp.0 pfet_03v3 ad=1.248p pd=5.32u as=1.248p ps=5.32u w=4.8u l=0.4u
X997 VSS lvds_lane_0.VBN.0 lvds_lane_2.fa.0 VSS nfet_03v3 ad=0.65p pd=3.02u as=0.65p ps=3.02u w=2.5u l=1u
X998 VSS lvds_lane_0.VBN.0 lvds_lane_1.tn.0 VSS nfet_03v3 ad=0.65p pd=3.02u as=0.65p ps=3.02u w=2.5u l=1u
X999 VDD VDD lvds_lane_2.d2b.0 VDD pfet_03v3 ad=0.88p pd=4.88u as=0.52p ps=2.52u w=2u l=0.28u
X1000 VDD EN lvds_lane_1.d2a.0 VDD pfet_03v3 ad=0.52p pd=2.52u as=0.52p ps=2.52u w=2u l=0.5u
X1001 lvds_lane_0.tp.0 lvds_lane_0.VREF.0 lvds_lane_0.fb.0 lvds_lane_0.tp.0 pfet_03v3 ad=1.248p pd=5.32u as=1.248p ps=5.32u w=4.8u l=0.4u
X1002 lvds_lane_1.tp.0 lvds_lane_1.gn.0 lvds_lane_1.fb.0 lvds_lane_1.tp.0 pfet_03v3 ad=1.248p pd=5.32u as=1.248p ps=5.32u w=4.8u l=0.4u
X1003 lvds_lane_1.tp.0 lvds_lane_1.gn.0 lvds_lane_1.fb.0 lvds_lane_1.tp.0 pfet_03v3 ad=1.248p pd=5.32u as=1.248p ps=5.32u w=4.8u l=0.4u
X1004 lvds_lane_0.VBN.0 lvds_lane_0.VBN.0 VSS VSS nfet_03v3 ad=0.65p pd=3.02u as=0.65p ps=3.02u w=2.5u l=1u
X1005 lvds_lane_2.tn.0 lvds_lane_2.gn.0 lvds_lane_2.ob.0 VSS nfet_03v3 ad=1.235p pd=5.27u as=1.235p ps=5.27u w=4.75u l=0.5u
X1006 lvds_lane_0.VBP.0 lvds_lane_0.VBP.0 VDD VDD pfet_03v3 ad=1.3p pd=5.52u as=1.3p ps=5.52u w=5u l=1u
X1007 lvds_lane_2.fa.0 lvds_lane_0.VREF.0 lvds_lane_2.tp.0 lvds_lane_2.tp.0 pfet_03v3 ad=1.248p pd=5.32u as=1.248p ps=5.32u w=4.8u l=0.4u
X1008 VSS lvds_lane_0.VBN.0 lvds_lane_2.tn.0 VSS nfet_03v3 ad=0.65p pd=3.02u as=0.65p ps=3.02u w=2.5u l=1u
X1009 lvds_lane_1.nm.0 lvds_lane_1.d3.0 lvds_lane_1.nd.0 VSS nfet_03v3 ad=0.52p pd=2.52u as=0.52p ps=2.52u w=2u l=0.28u
X1010 lvds_lane_1.fa.0 lvds_lane_0.VBN.0 VSS VSS nfet_03v3 ad=0.65p pd=3.02u as=0.65p ps=3.02u w=2.5u l=1u
X1011 RX1_O lvds_lane_1.i2.0 VSS VSS nfet_03v3 ad=1.04p pd=4.52u as=1.04p ps=4.52u w=4u l=0.28u
X1012 lvds_lane_1.fb.0 lvds_lane_1.gn.0 lvds_lane_1.tp.0 lvds_lane_1.tp.0 pfet_03v3 ad=1.248p pd=5.32u as=1.248p ps=5.32u w=4.8u l=0.4u
X1013 lvds_lane_0.oa.0 lvds_lane_0.gp.0 lvds_lane_0.tn.0 VSS nfet_03v3 ad=1.235p pd=5.27u as=1.235p ps=5.27u w=4.75u l=0.5u
X1014 VSS VSS lvds_lane_1.d2a.0 VSS nfet_03v3 ad=1.9228p pd=9.62u as=1.1362p ps=4.89u w=4.37u l=0.5u
X1015 VDD lvds_lane_0.VBP.0 lvds_lane_2.tp.0 VDD pfet_03v3 ad=1.3p pd=5.52u as=1.3p ps=5.52u w=5u l=1u
X1016 lvds_lane_1.sb.0 lvds_lane_1.ob.0 lvds_lane_1.d2b.0 VSS nfet_03v3 ad=1.1362p pd=4.89u as=1.1362p ps=4.89u w=4.37u l=0.5u
X1017 VDD lvds_bias_0.enb.0 lvds_bias_0.nrb.0 VDD pfet_03v3 ad=1.3p pd=5.52u as=1.3p ps=5.52u w=5u l=0.5u
X1018 VDD lvds_lane_2.d2b.0 lvds_lane_2.d3.0 VDD pfet_03v3 ad=0.52p pd=2.52u as=0.52p ps=2.52u w=2u l=0.28u
X1019 lvds_lane_0.d3.0 lvds_lane_0.d2b.0 VDD VDD pfet_03v3 ad=0.52p pd=2.52u as=0.52p ps=2.52u w=2u l=0.28u
X1020 VDD lvds_lane_0.VBP.0 lvds_lane_0.VBP.0 VDD pfet_03v3 ad=1.3p pd=5.52u as=1.3p ps=5.52u w=5u l=1u
X1021 lvds_lane_1.fb.0 lvds_lane_1.gn.0 lvds_lane_1.tp.0 lvds_lane_1.tp.0 pfet_03v3 ad=1.248p pd=5.32u as=1.248p ps=5.32u w=4.8u l=0.4u
X1022 lvds_lane_2.fb.0 lvds_lane_2.gn.0 lvds_lane_2.tp.0 lvds_lane_2.tp.0 pfet_03v3 ad=1.248p pd=5.32u as=1.248p ps=5.32u w=4.8u l=0.4u
X1023 VSS lvds_lane_0.VBN.0 lvds_lane_0.fb.0 VSS nfet_03v3 ad=0.65p pd=3.02u as=0.65p ps=3.02u w=2.5u l=1u
X1024 VDD lvds_lane_1.i2.0 RX1_O VDD pfet_03v3 ad=1.3p pd=5.52u as=1.3p ps=5.52u w=5u l=0.28u
X1025 VDD lvds_lane_0.VBP.0 lvds_lane_2.tp.0 VDD pfet_03v3 ad=1.3p pd=5.52u as=1.3p ps=5.52u w=5u l=1u
X1026 lvds_lane_2.tp.0 lvds_lane_0.VREF.0 lvds_lane_2.fb.0 lvds_lane_2.tp.0 pfet_03v3 ad=1.248p pd=5.32u as=1.248p ps=5.32u w=4.8u l=0.4u
X1027 VSS lvds_lane_0.VBN.0 lvds_lane_1.fa.0 VSS nfet_03v3 ad=0.65p pd=3.02u as=0.65p ps=3.02u w=2.5u l=1u
X1028 lvds_lane_1.ob.0 lvds_lane_0.VB2.0 lvds_lane_1.fb.0 VSS nfet_03v3 ad=1.1752p pd=5.04u as=1.1752p ps=5.04u w=4.52u l=0.5u
X1029 VDD lvds_lane_0.VBP.0 lvds_lane_0.tp.0 VDD pfet_03v3 ad=1.3p pd=5.52u as=1.3p ps=5.52u w=5u l=1u
X1030 lvds_lane_1.oa.0 lvds_lane_0.VREF.0 lvds_lane_1.tn.0 VSS nfet_03v3 ad=1.235p pd=5.27u as=1.235p ps=5.27u w=4.75u l=0.5u
X1031 lvds_lane_1.tp.0 lvds_lane_1.gn.0 lvds_lane_1.fb.0 lvds_lane_1.tp.0 pfet_03v3 ad=1.248p pd=5.32u as=1.248p ps=5.32u w=4.8u l=0.4u
X1032 lvds_lane_1.ob.0 lvds_lane_0.VB2.0 lvds_lane_1.fb.0 VSS nfet_03v3 ad=1.1752p pd=5.04u as=1.1752p ps=5.04u w=4.52u l=0.5u
X1033 lvds_lane_2.fb.0 lvds_lane_0.VBN.0 VSS VSS nfet_03v3 ad=0.65p pd=3.02u as=0.65p ps=3.02u w=2.5u l=1u
X1034 lvds_bias_0.rf_m1.0 VSS VSS ppolyf_u_1k r_width=2u r_length=23.07u
X1035 lvds_lane_0.tp.0 lvds_lane_0.gp.0 lvds_lane_0.fa.0 lvds_lane_0.tp.0 pfet_03v3 ad=1.248p pd=5.32u as=1.248p ps=5.32u w=4.8u l=0.4u
X1036 lvds_lane_2.fb.0 lvds_lane_0.VREF.0 lvds_lane_2.tp.0 lvds_lane_2.tp.0 pfet_03v3 ad=1.248p pd=5.32u as=1.248p ps=5.32u w=4.8u l=0.4u
X1037 lvds_lane_2.tn.0 lvds_lane_0.VBN.0 VSS VSS nfet_03v3 ad=0.65p pd=3.02u as=0.65p ps=3.02u w=2.5u l=1u
X1038 lvds_lane_2.tp.0 lvds_lane_0.VBP.0 VDD VDD pfet_03v3 ad=1.3p pd=5.52u as=1.3p ps=5.52u w=5u l=1u
X1039 lvds_bias_0.rdb_m2.0 lvds_bias_0.rdb_m1.0 VSS ppolyf_u_1k r_width=2u r_length=19.26u
X1040 lvds_lane_1.fa.0 lvds_lane_1.gp.0 lvds_lane_1.tp.0 lvds_lane_1.tp.0 pfet_03v3 ad=1.248p pd=5.32u as=1.248p ps=5.32u w=4.8u l=0.4u
X1041 lvds_lane_1.ob.0 VSS VSS VSS nfet_03v3 ad=1.1752p pd=5.04u as=1.9888p ps=9.92u w=4.52u l=0.5u
X1042 lvds_lane_2.tp.0 lvds_lane_0.VBP.0 VDD VDD pfet_03v3 ad=1.3p pd=5.52u as=1.3p ps=5.52u w=5u l=1u
X1043 lvds_lane_1.tp.0 lvds_lane_0.VREF.0 lvds_lane_1.fa.0 lvds_lane_1.tp.0 pfet_03v3 ad=1.248p pd=5.32u as=1.248p ps=5.32u w=4.8u l=0.4u
X1044 lvds_lane_0.fb.0 lvds_lane_0.gn.0 lvds_lane_0.tp.0 lvds_lane_0.tp.0 pfet_03v3 ad=1.248p pd=5.32u as=1.248p ps=5.32u w=4.8u l=0.4u
X1045 lvds_lane_2.tp.0 lvds_lane_2.gp.0 lvds_lane_2.fa.0 lvds_lane_2.tp.0 pfet_03v3 ad=1.248p pd=5.32u as=1.248p ps=5.32u w=4.8u l=0.4u
X1046 VDD VDD VDD VDD pfet_03v3 ad=0.962p pd=4.22u as=0 ps=0 w=3.7u l=0.28u
C0 lvds_lane_0.VBN.0 EN 0.42114f
C1 lvds_lane_0.i2.0 lvds_lane_0.i1.0 0.28557f
C2 lvds_lane_0.VBN.0 lvds_bias_0.vf.0 1.54524f
C3 lvds_lane_0.d2b.0 lvds_lane_0.d2a.0 2.76659f
C4 lvds_lane_1.i2.0 EN 0.31277f
C5 lvds_lane_0.VBN.0 lvds_lane_0.gn.0 0.11482f
C6 EN lvds_lane_1.d2a.0 0.17357f
C7 lvds_lane_1.tn.0 lvds_lane_1.gp.0 1.20627f
C8 lvds_lane_0.VBN.0 lvds_lane_0.fa.0 2.39287f
C9 lvds_bias_0.enb.0 lvds_bias_0.nrb.0 0.83214f
C10 lvds_bias_0.rb_m2.0 lvds_bias_0.vf.0 0.08519f
C11 lvds_lane_0.ts.0 lvds_lane_0.sa.0 0.03853f
C12 lvds_lane_1.nm.0 lvds_lane_1.d3.0 0.01765f
C13 lvds_lane_0.VBN.0 lvds_lane_1.oa.0 0.33374f
C14 lvds_lane_0.VBN.0 lvds_lane_0.gp.0 0.14191f
C15 lvds_lane_0.VREF.0 lvds_lane_0.gn.0 2.33633f
C16 lvds_lane_2.ob.0 VDD 1.92789f
C17 lvds_bias_0.nrb.0 VDD 5.10108f
C18 lvds_lane_0.VBN.0 lvds_lane_0.oa.0 0.33374f
C19 lvds_lane_1.nm.0 lvds_lane_1.nd.0 0.2193f
C20 lvds_lane_0.d2b.0 lvds_lane_0.rla_m1.0 0.00423f
C21 lvds_lane_0.VREF.0 lvds_lane_0.fa.0 2.64932f
C22 lvds_lane_0.VBP.0 lvds_lane_1.tp.0 3.37779f
C23 lvds_lane_1.i2.0 lvds_lane_1.i1.0 0.28557f
C24 lvds_lane_2.tn.0 VDD 0.19528f
C25 lvds_lane_1.tn.0 lvds_lane_1.gn.0 0.99696f
C26 lvds_lane_0.VREF.0 lvds_lane_1.oa.0 2.14744f
C27 lvds_lane_1.gp.0 VDD 4.5498f
C28 lvds_lane_0.VREF.0 lvds_lane_0.gp.0 1.91483f
C29 lvds_lane_1.oa.0 lvds_lane_1.d2a.0 0.16422f
C30 lvds_lane_0.VREF.0 lvds_lane_0.oa.0 2.14744f
C31 RX0_O VDD 3.99882f
C32 lvds_lane_1.ts.0 lvds_lane_1.sa.0 0.03853f
C33 lvds_lane_2.d2b.0 lvds_lane_2.sa.0 0.20995f
C34 lvds_lane_0.rlb_m1.0 lvds_lane_0.rla_m1.0 0.39394f
C35 lvds_lane_2.ts.0 VDD 0.93712f
C36 lvds_bias_0.nrb.0 EN 0.24322f
C37 lvds_bias_0.vf.0 lvds_bias_0.nrb.0 0.76263f
C38 lvds_lane_1.i2.0 RX1_O 0.50509f
C39 lvds_lane_0.VB2.0 lvds_lane_1.tp.0 0.05309f
C40 lvds_lane_2.gp.0 lvds_lane_0.VBP.0 0.26446f
C41 lvds_lane_1.gn.0 VDD 4.52025f
C42 RX2_N VDD 2.56543f
C43 EN RX0_O 1.94682f
C44 lvds_lane_0.ts.0 VDD 0.93712f
C45 lvds_lane_1.ob.0 lvds_lane_0.VB2.0 0.57476f
C46 lvds_lane_0.VBP.0 lvds_lane_2.gn.0 0.26446f
C47 lvds_lane_2.d2b.0 lvds_lane_2.rla_m1.0 0.00423f
C48 lvds_lane_0.VBP.0 RX0_N 0.03712f
C49 lvds_bias_0.rdb_m2.0 lvds_bias_0.rdt_m2.0 0.37f
C50 lvds_lane_0.d2b.0 lvds_lane_0.ob.0 0.16374f
C51 lvds_lane_0.gn.0 lvds_lane_0.fb.0 2.59553f
C52 lvds_lane_0.sa.0 VDD 0.00366f
C53 lvds_lane_0.fa.0 lvds_lane_0.fb.0 0.80129f
C54 lvds_lane_0.VB2.0 lvds_lane_2.gp.0 0.05601f
C55 lvds_lane_2.i1.0 VDD 2.62232f
C56 lvds_lane_2.gp.0 lvds_lane_2.tp.0 12.8757f
C57 lvds_lane_0.VBP.0 RX0_P 0.03875f
C58 lvds_lane_1.oa.0 lvds_lane_1.gp.0 1.23135f
C59 lvds_lane_1.fa.0 lvds_lane_1.tp.0 25.3704f
C60 lvds_lane_0.gp.0 lvds_lane_0.fb.0 0.86843f
C61 lvds_bias_0.rdt_m2.0 lvds_bias_0.nmid.0 0.00432f
C62 lvds_lane_0.VB2.0 lvds_lane_2.gn.0 0.05558f
C63 lvds_lane_2.tp.0 lvds_lane_2.gn.0 13.4594f
C64 lvds_lane_1.ob.0 lvds_lane_1.fa.0 0
C65 lvds_lane_1.tn.0 VDD 0.19528f
C66 lvds_lane_0.ts.0 lvds_lane_0.gn.0 0.01921f
C67 lvds_lane_2.ob.0 lvds_lane_2.sb.0 0.20964f
C68 lvds_lane_0.d2b.0 lvds_lane_0.n3a.0 0.16863f
C69 lvds_lane_2.i1.0 EN 0.26447f
C70 lvds_lane_0.nd.0 lvds_lane_0.nm.0 0.2193f
C71 lvds_lane_1.oa.0 lvds_lane_1.gn.0 0.30476f
C72 lvds_lane_2.d2a.0 VDD 12.6668f
C73 lvds_lane_0.d3.0 lvds_lane_0.d2a.0 2.37176f
C74 lvds_lane_0.VBP.0 lvds_bias_0.nmid.0 0.03404f
C75 EN lvds_lane_0.nm.0 0.02238f
C76 lvds_bias_0.enb.0 VDD 6.1787f
C77 lvds_lane_2.gp.0 lvds_lane_2.fa.0 2.44274f
C78 lvds_lane_1.fb.0 lvds_lane_0.VB2.0 2.14447f
C79 lvds_lane_1.ts.0 lvds_lane_1.ob.0 0.21086f
C80 lvds_lane_2.ts.0 lvds_lane_2.sb.0 0.06367f
C81 lvds_lane_0.VB2.0 lvds_lane_0.ob.0 0.57476f
C82 lvds_lane_2.gn.0 lvds_lane_2.fa.0 0.67123f
C83 lvds_lane_1.ob.0 lvds_lane_1.sa.0 0.00738f
C84 lvds_lane_2.d2a.0 EN 0.17357f
C85 lvds_lane_2.gp.0 RX2_P 0.14621f
C86 lvds_lane_0.VREF.0 lvds_bias_0.rdt_m2.0 0.00234f
C87 lvds_bias_0.enb.0 EN 4.04436f
C88 lvds_lane_0.VBN.0 lvds_lane_0.VBP.0 7.61409f
C89 lvds_lane_0.oa.0 lvds_lane_0.sa.0 0.14911f
C90 lvds_lane_0.VB2.0 lvds_bias_0.nmid.0 0.91956f
C91 lvds_bias_0.enb.0 lvds_bias_0.vf.0 1.18587f
C92 RX1_P lvds_lane_0.VBP.0 0.03967f
C93 lvds_lane_0.nd.0 VDD 2.72485f
C94 lvds_lane_2.fb.0 lvds_lane_0.VB2.0 2.14447f
C95 lvds_bias_0.rdb_m3.0 lvds_bias_0.rdt_m1.0 0.41833f
C96 lvds_lane_2.fb.0 lvds_lane_2.tp.0 25.7437f
C97 EN VDD 63.4972f
C98 lvds_bias_0.rdt_m3.0 lvds_bias_0.rdt_m1.0 0.08167f
C99 lvds_lane_1.fb.0 lvds_lane_1.fa.0 0.80129f
C100 lvds_lane_0.VREF.0 lvds_lane_0.VBP.0 0.0747f
C101 lvds_bias_0.vf.0 VDD 0.00294f
C102 lvds_lane_1.oa.0 lvds_lane_1.tn.0 9.87797f
C103 lvds_lane_1.d2b.0 lvds_lane_1.sa.0 0.20995f
C104 lvds_bias_0.rdb_m1.0 lvds_bias_0.rdt_m3.0 0.22342f
C105 lvds_lane_0.sb.0 lvds_lane_0.ob.0 0.20964f
C106 lvds_lane_0.VBN.0 lvds_lane_0.VB2.0 0.63813f
C107 EN lvds_lane_0.nd.0 0.90578f
C108 lvds_lane_0.gn.0 VDD 4.52025f
C109 lvds_lane_2.sa.0 lvds_lane_2.oa.0 0.14911f
C110 lvds_bias_0.vf.0 EN 0.02265f
C111 lvds_lane_1.i1.0 VDD 2.62232f
C112 lvds_lane_2.fb.0 lvds_lane_2.fa.0 0.80129f
C113 lvds_lane_1.oa.0 VDD 1.56447f
C114 lvds_lane_0.VREF.0 lvds_lane_0.VB2.0 24.5935f
C115 lvds_lane_0.gp.0 VDD 4.5498f
C116 lvds_lane_0.VREF.0 lvds_lane_2.tp.0 14.925f
C117 lvds_lane_0.oa.0 VDD 1.56447f
C118 lvds_lane_0.VB2.0 lvds_lane_2.oa.0 0.57905f
C119 lvds_lane_2.d3.0 lvds_lane_2.nd.0 0.22426f
C120 lvds_bias_0.nrb.0 lvds_lane_0.VBP.0 0.36246f
C121 lvds_lane_1.i1.0 EN 0.26447f
C122 RX1_O VDD 4.00061f
C123 lvds_lane_0.VBN.0 lvds_lane_2.fa.0 2.39287f
C124 lvds_lane_2.i2.0 RX2_O 0.50509f
C125 lvds_lane_0.i2.0 RX0_O 0.50501f
C126 lvds_lane_0.VBN.0 lvds_lane_1.fa.0 2.39287f
C127 lvds_lane_2.ob.0 lvds_lane_2.sa.0 0.00738f
C128 lvds_lane_1.gp.0 lvds_lane_0.VBP.0 0.26446f
C129 lvds_lane_0.fa.0 lvds_lane_0.gn.0 0.67123f
C130 lvds_lane_0.rla_m1.0 lvds_lane_0.d2a.0 0
C131 lvds_lane_0.VREF.0 lvds_lane_1.fa.0 2.64932f
C132 lvds_lane_0.VREF.0 lvds_lane_2.fa.0 2.64932f
C133 lvds_lane_0.d3.0 lvds_lane_0.n3a.0 0.80741f
C134 lvds_lane_2.nm.0 lvds_lane_2.nd.0 0.2193f
C135 lvds_lane_2.d2b.0 lvds_lane_2.n3a.0 0.16863f
C136 EN RX1_O 0.00492f
C137 lvds_lane_2.oa.0 lvds_lane_2.fa.0 2.90441f
C138 lvds_lane_0.gn.0 lvds_lane_0.gp.0 2.07546f
C139 lvds_lane_1.ts.0 lvds_lane_0.VBN.0 0.99312f
C140 lvds_lane_2.ob.0 lvds_lane_0.VB2.0 0.57476f
C141 lvds_bias_0.nrb.0 lvds_lane_0.VB2.0 0.03936f
C142 lvds_lane_0.oa.0 lvds_lane_0.gn.0 0.30476f
C143 lvds_lane_2.ts.0 lvds_lane_2.sa.0 0.03853f
C144 lvds_lane_0.d2b.0 lvds_lane_0.sa.0 0.20995f
C145 lvds_lane_0.fa.0 lvds_lane_0.gp.0 2.44274f
C146 lvds_lane_0.VBP.0 lvds_lane_1.gn.0 0.26446f
C147 lvds_lane_0.fa.0 lvds_lane_0.oa.0 2.90441f
C148 RX2_N lvds_lane_0.VBP.0 0.03712f
C149 lvds_lane_0.VB2.0 lvds_lane_1.gp.0 0.05601f
C150 lvds_lane_1.ob.0 lvds_lane_1.d2b.0 0.16374f
C151 lvds_lane_0.VB2.0 lvds_lane_0.fb.0 2.14447f
C152 lvds_lane_0.VREF.0 lvds_lane_1.ts.0 0.07669f
C153 lvds_lane_0.VREF.0 lvds_lane_0.tp.0 14.925f
C154 lvds_lane_0.oa.0 lvds_lane_0.gp.0 1.23135f
C155 lvds_lane_0.rlb_m1.0 lvds_lane_0.sa.0 0
C156 lvds_lane_1.n3a.0 lvds_lane_1.d2b.0 0.16863f
C157 lvds_lane_1.i1.0 RX1_O 0
C158 lvds_lane_1.sa.0 lvds_lane_1.rla_m1.0 0.30587f
C159 lvds_lane_1.d2a.0 lvds_lane_1.sa.0 1.67001f
C160 lvds_lane_1.fb.0 lvds_lane_1.tp.0 25.7437f
C161 lvds_lane_2.gp.0 lvds_lane_2.gn.0 2.07546f
C162 lvds_lane_0.VB2.0 lvds_lane_1.gn.0 0.05558f
C163 lvds_lane_1.nm.0 EN 0.02238f
C164 lvds_lane_2.ob.0 lvds_lane_2.fa.0 0
C165 lvds_lane_1.fb.0 lvds_lane_1.ob.0 2.81909f
C166 lvds_lane_1.n3a.0 lvds_lane_1.d3.0 0.80741f
C167 RX1_N lvds_lane_1.gn.0 0.14621f
C168 lvds_lane_1.fa.0 lvds_lane_1.gp.0 2.44274f
C169 lvds_lane_0.d2b.0 VDD 11.7806f
C170 lvds_lane_2.d2b.0 lvds_lane_2.d3.0 0.34009f
C171 lvds_lane_1.d3.0 lvds_lane_1.d2b.0 0.34009f
C172 lvds_bias_0.rdt_m2.0 VDD 0.00209f
C173 lvds_lane_0.i2.0 VDD 4.2831f
C174 lvds_bias_0.enb.0 lvds_lane_0.VBP.0 1.1468f
C175 lvds_lane_2.d2a.0 lvds_lane_2.sa.0 1.67001f
C176 lvds_lane_1.fa.0 lvds_lane_1.gn.0 0.67123f
C177 lvds_bias_0.rf_m1.0 lvds_bias_0.rb_m3.0 0.04347f
C178 lvds_lane_0.n3a.0 lvds_lane_0.d2a.0 0.24692f
C179 lvds_lane_0.fb.0 lvds_lane_0.tp.0 25.7437f
C180 lvds_lane_2.n3a.0 lvds_lane_2.d3.0 0.80741f
C181 EN lvds_lane_0.d2b.0 0.44208f
C182 lvds_lane_0.VBP.0 VDD 0.11404p
C183 lvds_lane_0.ts.0 lvds_lane_0.sb.0 0.06367f
C184 lvds_lane_1.nd.0 lvds_lane_1.d3.0 0.22426f
C185 lvds_lane_2.fb.0 lvds_lane_2.gp.0 0.86843f
C186 lvds_lane_2.sa.0 VDD 0.00366f
C187 lvds_lane_0.i2.0 EN 0.31277f
C188 lvds_lane_0.VBN.0 lvds_lane_1.ob.0 0.19136f
C189 lvds_lane_0.tn.0 lvds_lane_0.ob.0 9.55392f
C190 lvds_lane_1.ts.0 lvds_lane_1.gn.0 0.01921f
C191 lvds_lane_2.d2a.0 lvds_lane_2.rla_m1.0 0
C192 lvds_bias_0.enb.0 lvds_lane_0.VB2.0 2.12636f
C193 lvds_lane_0.VREF.0 lvds_lane_1.tp.0 14.925f
C194 lvds_lane_2.rlb_m1.0 lvds_lane_2.sa.0 0
C195 lvds_lane_1.rlb_m1.0 lvds_lane_1.sa.0 0
C196 lvds_lane_0.sb.0 lvds_lane_0.sa.0 0.7765f
C197 lvds_lane_2.fb.0 lvds_lane_2.gn.0 2.59553f
C198 lvds_lane_0.VBP.0 EN 0.30684f
C199 lvds_lane_0.VREF.0 lvds_lane_1.ob.0 2.70252f
C200 lvds_bias_0.vf.0 lvds_lane_0.VBP.0 0.3587f
C201 lvds_lane_0.VB2.0 VDD 6.61063f
C202 lvds_lane_0.VBN.0 lvds_lane_2.gp.0 0.14191f
C203 lvds_lane_2.tp.0 VDD 11.3411f
C204 lvds_bias_0.rdb_m2.0 lvds_bias_0.nmid.0 0.04228f
C205 RX1_N VDD 2.56543f
C206 lvds_lane_1.n3a.0 lvds_lane_1.d2a.0 0.24692f
C207 lvds_lane_0.VBP.0 lvds_lane_0.gn.0 0.26446f
C208 lvds_lane_0.VBN.0 lvds_lane_2.gn.0 0.11482f
C209 lvds_lane_2.rlb_m1.0 lvds_lane_2.rla_m1.0 0.39394f
C210 lvds_lane_2.i1.0 lvds_lane_2.nd.0 0.21598f
C211 lvds_lane_2.i2.0 lvds_lane_2.i1.0 0.28557f
C212 lvds_lane_0.VREF.0 lvds_lane_2.gp.0 1.91483f
C213 lvds_lane_0.d3.0 lvds_lane_0.nm.0 0.01765f
C214 RX0_O lvds_lane_0.i1.0 0
C215 lvds_lane_0.VB2.0 EN 2.2084f
C216 lvds_lane_2.gp.0 lvds_lane_2.oa.0 1.23135f
C217 lvds_lane_0.VBN.0 lvds_lane_0.tn.0 0.82513f
C218 lvds_bias_0.enb.0 lvds_bias_0.rb_m1.0 0
C219 lvds_lane_1.d2b.0 lvds_lane_1.rla_m1.0 0.00423f
C220 lvds_bias_0.vf.0 lvds_lane_0.VB2.0 0.92899f
C221 lvds_lane_0.VREF.0 lvds_lane_2.gn.0 2.33633f
C222 lvds_lane_0.VBP.0 lvds_lane_0.gp.0 0.26446f
C223 lvds_lane_1.d2b.0 lvds_lane_1.d2a.0 2.76659f
C224 lvds_lane_1.ts.0 lvds_lane_1.tn.0 0
C225 lvds_lane_2.gn.0 lvds_lane_2.oa.0 0.30476f
C226 lvds_lane_2.ob.0 lvds_lane_2.d2b.0 0.16374f
C227 lvds_lane_0.VBN.0 lvds_lane_1.fb.0 1.48704f
C228 lvds_lane_0.VREF.0 lvds_lane_0.tn.0 1.62411f
C229 lvds_lane_0.VB2.0 lvds_lane_0.gn.0 0.05558f
C230 lvds_lane_1.gp.0 lvds_lane_1.tp.0 12.8757f
C231 lvds_lane_0.VBN.0 lvds_lane_0.ob.0 0.19136f
C232 lvds_lane_0.fa.0 lvds_lane_0.VB2.0 1.75715f
C233 lvds_lane_1.d3.0 lvds_lane_1.d2a.0 2.37176f
C234 lvds_lane_0.VREF.0 lvds_bias_0.rdb_m2.0 0.09091f
C235 RX2_P VDD 2.27847f
C236 lvds_lane_2.d3.0 lvds_lane_2.nm.0 0.01765f
C237 lvds_lane_0.VREF.0 lvds_lane_1.fb.0 2.88984f
C238 lvds_lane_1.ob.0 lvds_lane_1.gp.0 0.3633f
C239 lvds_lane_1.oa.0 lvds_lane_0.VB2.0 0.57905f
C240 lvds_lane_0.VB2.0 lvds_lane_0.gp.0 0.05601f
C241 lvds_lane_0.d3.0 VDD 4.47773f
C242 lvds_lane_0.VBN.0 lvds_bias_0.nmid.0 0.11617f
C243 lvds_lane_1.ts.0 VDD 0.93712f
C244 lvds_lane_0.tp.0 VDD 11.3411f
C245 lvds_lane_0.VB2.0 lvds_lane_0.oa.0 0.57905f
C246 lvds_lane_2.nd.0 VDD 2.72485f
C247 lvds_lane_2.ob.0 lvds_lane_2.gp.0 0.3633f
C248 lvds_lane_2.i2.0 VDD 4.2831f
C249 lvds_bias_0.rb_m1.0 EN 0.00476f
C250 lvds_lane_0.VREF.0 lvds_lane_0.ob.0 2.70252f
C251 lvds_lane_2.sa.0 lvds_lane_2.sb.0 0.7765f
C252 lvds_lane_1.tp.0 lvds_lane_1.gn.0 13.4594f
C253 lvds_lane_0.VBN.0 lvds_lane_2.fb.0 1.48704f
C254 lvds_lane_1.sa.0 VDD 0.00366f
C255 lvds_lane_2.tn.0 lvds_lane_2.gp.0 1.20627f
C256 lvds_lane_2.ob.0 lvds_lane_2.gn.0 1.03804f
C257 lvds_lane_0.VREF.0 lvds_bias_0.nmid.0 0
C258 lvds_lane_1.ob.0 lvds_lane_1.gn.0 1.03804f
C259 lvds_lane_0.d3.0 lvds_lane_0.nd.0 0.22426f
C260 lvds_lane_2.tn.0 lvds_lane_2.gn.0 0.99696f
C261 lvds_lane_0.d3.0 EN 0.46698f
C262 EN lvds_lane_2.nd.0 0.90578f
C263 lvds_lane_0.VREF.0 lvds_lane_2.fb.0 2.88984f
C264 lvds_lane_2.i2.0 EN 0.31277f
C265 lvds_lane_0.sa.0 lvds_lane_0.d2a.0 1.67001f
C266 lvds_lane_1.oa.0 lvds_lane_1.fa.0 2.90441f
C267 lvds_lane_2.ts.0 lvds_lane_2.gn.0 0.01921f
C268 lvds_lane_0.gn.0 lvds_lane_0.tp.0 13.4594f
C269 lvds_lane_0.VREF.0 lvds_lane_0.VBN.0 2.95645f
C270 lvds_lane_0.fa.0 lvds_lane_0.tp.0 25.3704f
C271 RX2_N lvds_lane_2.gn.0 0.14621f
C272 lvds_lane_0.VBN.0 lvds_lane_2.oa.0 0.33374f
C273 lvds_lane_1.fb.0 lvds_lane_1.gp.0 0.86843f
C274 lvds_lane_1.ts.0 lvds_lane_1.sb.0 0.06367f
C275 lvds_lane_0.VBN.0 lvds_bias_0.rb_m2.0 0.03954f
C276 VDD lvds_lane_0.i1.0 2.62232f
C277 lvds_lane_0.gp.0 lvds_lane_0.tp.0 12.8757f
C278 lvds_lane_0.sa.0 lvds_lane_0.rla_m1.0 0.30587f
C279 lvds_lane_1.sb.0 lvds_lane_1.sa.0 0.7765f
C280 lvds_lane_0.fb.0 lvds_lane_0.ob.0 2.81909f
C281 lvds_lane_1.oa.0 lvds_lane_1.sa.0 0.14911f
C282 lvds_lane_1.ob.0 lvds_lane_1.tn.0 9.55392f
C283 lvds_lane_1.d2a.0 lvds_lane_1.rla_m1.0 0
C284 lvds_lane_0.VREF.0 lvds_lane_2.oa.0 2.14744f
C285 lvds_lane_0.ts.0 lvds_lane_0.tn.0 0
C286 lvds_lane_2.ob.0 lvds_lane_2.fb.0 2.81909f
C287 lvds_lane_2.d2a.0 lvds_lane_2.d2b.0 2.76659f
C288 lvds_lane_0.nd.0 lvds_lane_0.i1.0 0.21598f
C289 lvds_lane_1.fb.0 lvds_lane_1.gn.0 2.59553f
C290 EN lvds_lane_0.i1.0 0.26447f
C291 lvds_lane_0.d2a.0 VDD 12.6668f
C292 lvds_lane_1.tp.0 VDD 11.3411f
C293 lvds_lane_2.d2a.0 lvds_lane_2.n3a.0 0.24692f
C294 lvds_lane_0.VBN.0 lvds_lane_2.ob.0 0.19136f
C295 lvds_lane_2.d2b.0 VDD 11.7806f
C296 lvds_lane_0.ts.0 lvds_lane_0.ob.0 0.21086f
C297 lvds_lane_0.VBN.0 lvds_bias_0.nrb.0 0.04436f
C298 lvds_lane_1.ob.0 VDD 1.92789f
C299 lvds_lane_0.VBN.0 lvds_lane_2.tn.0 0.82513f
C300 lvds_lane_0.VBN.0 lvds_lane_1.gp.0 0.14191f
C301 lvds_lane_0.VBN.0 lvds_lane_0.fb.0 1.48704f
C302 lvds_lane_1.n3a.0 VDD 4.08941f
C303 EN lvds_lane_0.d2a.0 0.17357f
C304 RX1_P lvds_lane_1.gp.0 0.14621f
C305 lvds_lane_0.VREF.0 lvds_lane_2.ob.0 2.70252f
C306 lvds_lane_0.sa.0 lvds_lane_0.ob.0 0.00738f
C307 lvds_lane_2.n3a.0 VDD 4.08941f
C308 lvds_lane_2.gp.0 VDD 4.5498f
C309 lvds_lane_2.ob.0 lvds_lane_2.oa.0 0.59251f
C310 lvds_lane_2.d2b.0 EN 0.44208f
C311 lvds_lane_0.VBN.0 lvds_lane_2.ts.0 0.99312f
C312 lvds_lane_0.VREF.0 lvds_lane_2.tn.0 1.62411f
C313 lvds_bias_0.rb_m2.0 lvds_bias_0.nrb.0 0.03837f
C314 lvds_lane_0.VREF.0 lvds_lane_1.gp.0 1.91483f
C315 lvds_lane_2.tn.0 lvds_lane_2.oa.0 9.87797f
C316 lvds_lane_0.VREF.0 lvds_lane_0.fb.0 2.88984f
C317 lvds_lane_1.d2b.0 VDD 11.7806f
C318 lvds_lane_0.VB2.0 lvds_lane_0.VBP.0 5.46578f
C319 lvds_lane_2.gn.0 VDD 4.52025f
C320 lvds_lane_0.VBN.0 lvds_lane_1.gn.0 0.11482f
C321 lvds_lane_0.VBP.0 lvds_lane_2.tp.0 3.37779f
C322 lvds_lane_1.n3a.0 EN 0.00585f
C323 RX0_N VDD 2.56543f
C324 lvds_lane_0.VREF.0 lvds_lane_2.ts.0 0.07669f
C325 lvds_lane_2.i1.0 RX2_O 0
C326 lvds_lane_0.VBN.0 lvds_lane_0.ts.0 0.99312f
C327 lvds_lane_0.VBP.0 RX1_N 0.03712f
C328 EN lvds_lane_2.n3a.0 0.00585f
C329 lvds_lane_0.sb.0 lvds_lane_0.d2b.0 0.68313f
C330 lvds_lane_0.tn.0 VDD 0.19528f
C331 lvds_bias_0.enb.0 lvds_bias_0.rdt_m1.0 0.0052f
C332 lvds_lane_2.sa.0 lvds_lane_2.rla_m1.0 0.30587f
C333 lvds_lane_1.rlb_m1.0 lvds_lane_1.rla_m1.0 0.39394f
C334 lvds_lane_1.d3.0 VDD 4.47773f
C335 lvds_lane_0.VREF.0 lvds_lane_1.gn.0 2.33633f
C336 lvds_lane_0.oa.0 lvds_lane_0.d2a.0 0.16422f
C337 lvds_lane_1.d2b.0 EN 0.44208f
C338 lvds_lane_1.ob.0 lvds_lane_1.sb.0 0.20964f
C339 RX0_P VDD 2.27023f
C340 lvds_bias_0.rdb_m2.0 VDD 0.00594f
C341 lvds_lane_2.d2a.0 lvds_lane_2.d3.0 2.37176f
C342 lvds_lane_1.nd.0 VDD 2.72485f
C343 lvds_lane_0.VREF.0 lvds_lane_0.ts.0 0.07669f
C344 lvds_lane_1.ob.0 lvds_lane_1.oa.0 0.59251f
C345 lvds_lane_0.d3.0 lvds_lane_0.d2b.0 0.34009f
C346 lvds_lane_0.VB2.0 lvds_lane_2.tp.0 0.05309f
C347 lvds_lane_2.ob.0 lvds_lane_2.tn.0 9.55392f
C348 lvds_lane_0.ob.0 VDD 1.92789f
C349 lvds_bias_0.enb.0 lvds_bias_0.nmid.0 0.71708f
C350 lvds_bias_0.rb_m1.0 lvds_lane_0.VBP.0 0.0038f
C351 lvds_lane_1.d3.0 EN 0.46698f
C352 lvds_lane_2.d3.0 VDD 4.47773f
C353 lvds_lane_0.gn.0 RX0_N 0.14621f
C354 lvds_bias_0.nmid.0 VDD 0.89656f
C355 lvds_lane_1.nd.0 EN 0.90578f
C356 lvds_lane_0.VBN.0 lvds_lane_1.tn.0 0.82513f
C357 lvds_lane_1.d2b.0 lvds_lane_1.sb.0 0.68313f
C358 lvds_lane_2.ob.0 lvds_lane_2.ts.0 0.21086f
C359 lvds_lane_2.d2b.0 lvds_lane_2.sb.0 0.68313f
C360 RX2_O VDD 4.00067f
C361 lvds_lane_0.VBP.0 RX2_P 0.03967f
C362 lvds_lane_0.gn.0 lvds_lane_0.tn.0 0.99696f
C363 lvds_lane_2.ts.0 lvds_lane_2.tn.0 0
C364 lvds_lane_0.VBP.0 lvds_lane_0.tp.0 3.37779f
C365 lvds_lane_0.VBN.0 lvds_bias_0.enb.0 0.2848f
C366 lvds_lane_1.fa.0 lvds_lane_0.VB2.0 1.75715f
C367 lvds_lane_0.VB2.0 lvds_lane_2.fa.0 1.75715f
C368 lvds_lane_0.VREF.0 lvds_lane_1.tn.0 1.62411f
C369 lvds_lane_2.tp.0 lvds_lane_2.fa.0 25.3704f
C370 EN lvds_lane_2.d3.0 0.46698f
C371 lvds_lane_0.n3a.0 VDD 4.08941f
C372 lvds_lane_0.gp.0 lvds_lane_0.tn.0 1.20627f
C373 lvds_bias_0.nmid.0 EN 0.59891f
C374 lvds_lane_1.gp.0 lvds_lane_1.gn.0 2.07546f
C375 lvds_lane_0.oa.0 lvds_lane_0.tn.0 9.87797f
C376 EN RX2_O 0.005f
C377 lvds_lane_0.VBN.0 VDD 3.79959f
C378 lvds_lane_0.gn.0 lvds_lane_0.ob.0 1.03804f
C379 lvds_lane_1.i1.0 lvds_lane_1.nd.0 0.21598f
C380 lvds_lane_2.d2a.0 lvds_lane_2.oa.0 0.16422f
C381 lvds_lane_0.VREF.0 lvds_bias_0.enb.0 0.14548f
C382 RX1_P VDD 2.27847f
C383 RX0_P lvds_lane_0.gp.0 0.14621f
C384 lvds_lane_0.fa.0 lvds_lane_0.ob.0 0
C385 lvds_bias_0.rb_m3.0 lvds_bias_0.rb_m1.0 0.06955f
C386 lvds_lane_0.VB2.0 lvds_lane_0.tp.0 0.05309f
C387 lvds_lane_0.gp.0 lvds_lane_0.ob.0 0.3633f
C388 lvds_lane_1.i2.0 VDD 4.2831f
C389 EN lvds_lane_0.n3a.0 0.00585f
C390 lvds_lane_0.VREF.0 VDD 2.13357f
C391 lvds_lane_0.oa.0 lvds_lane_0.ob.0 0.59251f
C392 lvds_lane_1.d2a.0 VDD 12.6668f
C393 EN lvds_lane_2.nm.0 0.02238f
C394 lvds_lane_2.oa.0 VDD 1.56447f
C395 RX2_O VSS 18.8961f
C396 RX1_O VSS 11.8271f
C397 RX0_O VSS 11.1616f
C398 EN VSS 37.6717f
C399 RX2_N VSS 3.34389f
C400 RX2_P VSS 3.63059f
C401 RX1_N VSS 3.34389f
C402 RX1_P VSS 3.63059f
C403 RX0_N VSS 3.34389f
C404 RX0_P VSS 3.63059f
C405 VDD VSS 0.73438p
C406 lvds_bias_0.rb_m3.0 VSS 1.32997f
C407 lvds_bias_0.rb_m2.0 VSS 1.18198f
C408 lvds_bias_0.rb_m1.0 VSS 1.29868f
C409 lvds_bias_0.rf_m1.0 VSS 1.40226f
C410 lvds_bias_0.vf.0 VSS 3.02831f
C411 lvds_bias_0.nrb.0 VSS 1.98311f
C412 lvds_lane_2.i2.0 VSS 4.2469f
C413 lvds_lane_2.i1.0 VSS 3.72118f
C414 lvds_lane_2.nm.0 VSS 0.31567f
C415 lvds_lane_2.nd.0 VSS 3.35161f
C416 lvds_lane_1.i2.0 VSS 4.2469f
C417 lvds_lane_1.i1.0 VSS 3.72118f
C418 lvds_lane_1.nm.0 VSS 0.31567f
C419 lvds_lane_1.nd.0 VSS 3.35161f
C420 lvds_lane_0.i2.0 VSS 4.2469f
C421 lvds_lane_0.i1.0 VSS 3.72118f
C422 lvds_lane_0.nm.0 VSS 0.31567f
C423 lvds_lane_0.nd.0 VSS 3.35161f
C424 lvds_lane_2.d3.0 VSS 4.9259f
C425 lvds_lane_2.n3a.0 VSS 3.56595f
C426 lvds_lane_1.d3.0 VSS 4.9259f
C427 lvds_lane_1.n3a.0 VSS 3.56595f
C428 lvds_lane_0.d3.0 VSS 4.9259f
C429 lvds_lane_0.n3a.0 VSS 3.56595f
C430 lvds_bias_0.rdb_m1.0 VSS 1.12023f
C431 lvds_bias_0.rdt_m3.0 VSS 1.81265f
C432 lvds_bias_0.rdb_m2.0 VSS 1.89154f
C433 lvds_bias_0.rdb_m3.0 VSS 1.13703f
C434 lvds_bias_0.rdt_m1.0 VSS 1.66241f
C435 lvds_bias_0.rdt_m2.0 VSS 1.18196f
C436 lvds_bias_0.nmid.0 VSS 4.29306f
C437 lvds_lane_2.sb.0 VSS 2.33901f
C438 lvds_lane_2.d2b.0 VSS 5.02018f
C439 lvds_lane_2.rlb_m1.0 VSS 1.11225f
C440 lvds_lane_2.rla_m1.0 VSS 1.48222f
C441 lvds_lane_2.sa.0 VSS 4.30772f
C442 lvds_lane_2.d2a.0 VSS 3.35523f
C443 lvds_lane_1.sb.0 VSS 2.33901f
C444 lvds_lane_1.d2b.0 VSS 5.02018f
C445 lvds_lane_1.rlb_m1.0 VSS 1.11225f
C446 lvds_lane_1.rla_m1.0 VSS 1.48222f
C447 lvds_lane_1.sa.0 VSS 4.30772f
C448 lvds_lane_1.d2a.0 VSS 3.35523f
C449 lvds_lane_0.sb.0 VSS 2.33901f
C450 lvds_lane_0.d2b.0 VSS 5.02018f
C451 lvds_lane_0.rlb_m1.0 VSS 1.11225f
C452 lvds_lane_0.rla_m1.0 VSS 1.48222f
C453 lvds_lane_0.sa.0 VSS 4.30772f
C454 lvds_lane_0.d2a.0 VSS 3.35523f
C455 lvds_lane_2.ts.0 VSS 7.37304f
C456 lvds_lane_2.tn.0 VSS 4.38031f
C457 lvds_lane_1.ts.0 VSS 7.37304f
C458 lvds_lane_1.tn.0 VSS 4.38031f
C459 lvds_lane_0.ts.0 VSS 7.37304f
C460 lvds_lane_0.tn.0 VSS 4.38031f
C461 lvds_bias_0.enb.0 VSS 8.34564f
C462 lvds_lane_2.ob.0 VSS 6.80006f
C463 lvds_lane_2.oa.0 VSS 7.22376f
C464 lvds_lane_1.ob.0 VSS 6.80006f
C465 lvds_lane_1.oa.0 VSS 7.22376f
C466 lvds_lane_0.ob.0 VSS 6.80006f
C467 lvds_lane_0.VBN.0 VSS 0.1762p
C468 lvds_lane_0.oa.0 VSS 7.22376f
C469 lvds_lane_2.fa.0 VSS 9.0556f
C470 lvds_lane_2.fb.0 VSS 7.93573f
C471 lvds_lane_1.fa.0 VSS 9.0556f
C472 lvds_lane_1.fb.0 VSS 7.93573f
C473 lvds_lane_0.fa.0 VSS 9.0556f
C474 lvds_lane_0.fb.0 VSS 7.93573f
C475 lvds_lane_0.VREF.0 VSS 59.6279f
C476 lvds_lane_0.VB2.0 VSS 40.2263f
C477 lvds_lane_2.gn.0 VSS 13.8994f
C478 lvds_lane_2.gp.0 VSS 14.1023f
C479 lvds_lane_1.gn.0 VSS 13.8994f
C480 lvds_lane_1.gp.0 VSS 14.1023f
C481 lvds_lane_0.gn.0 VSS 13.8994f
C482 lvds_lane_0.VBP.0 VSS 20.6887f
C483 lvds_lane_0.gp.0 VSS 14.1023f
C484 lvds_lane_2.tp.0 VSS 0.1029p
C485 lvds_lane_1.tp.0 VSS 0.1029p
C486 lvds_lane_0.tp.0 VSS 0.1029p
.ends lvds_rx_x3
