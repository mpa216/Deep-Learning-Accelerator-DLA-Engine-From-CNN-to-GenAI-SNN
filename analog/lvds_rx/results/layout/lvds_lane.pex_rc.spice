* lvds_lane: parasitic R (extresist, tolerance 10) on all nets; C from the C-coupled extraction (check.rc_repair, T11: Magic 8.3.636 extresist counts every coupling twice)
* GENERATED by layout/macro/run_macro.py (T10) from a GDS with sha256 f71aecad1ad41a1eaad0c62a96379acec1870f6dccee852c35586f9f4c3a63a2 -- do not edit by hand.
* Ports in the order of subckt lvds_lane of netlist/lvds_rx_lvs_ref.spice (Magic's own order was: INP INN OUT EN VBN VB2 VREF VBP VDD VSS).
* NGSPICE file created from lvds_lane.ext - technology: gf180mcuD

.subckt lvds_lane VDD VSS INP INN EN VBN VBP VB2 VREF OUT
X0 tp.0.t0 gn.0.t18 fb.0.t63 tp.0.t0 pfet_03v3 ad=1.248p pd=5.32u as=1.248p ps=5.32u w=4.8u l=0.4u
X1 ob.0.t17 VREF.t16 tn.0.t38 VSS.t229 nfet_03v3 ad=1.235p pd=5.27u as=1.235p ps=5.27u w=4.75u l=0.5u
X2 oa.0.t26 VREF.t2 tn.0.t47 VSS.t243 nfet_03v3 ad=1.235p pd=5.27u as=1.235p ps=5.27u w=4.75u l=0.5u
X3 tp.0.t0 VREF.t63 fb.0.t34 tp.0.t0 pfet_03v3 ad=1.248p pd=5.32u as=2.112p ps=10.48u w=4.8u l=0.4u
X4 fb.0.t32 gn.0.t11 tp.0.t0 tp.0.t0 pfet_03v3 ad=1.248p pd=5.32u as=1.248p ps=5.32u w=4.8u l=0.4u
X5 oa.0.t20 VREF.t14 tn.0.t45 VSS.t231 nfet_03v3 ad=1.235p pd=5.27u as=1.235p ps=5.27u w=4.75u l=0.5u
X6 ob.0.t23 VREF.t4 tn.0.t30 VSS.t241 nfet_03v3 ad=1.235p pd=5.27u as=1.235p ps=5.27u w=4.75u l=0.5u
X7 VSS.t93 VBN.t1 ts.0.t10 VSS.t92 nfet_03v3 ad=0.65p pd=3.02u as=0.65p ps=3.02u w=2.5u l=1u
X8 tn.0.t8 VBN.t14 VSS.t73 VSS.t72 nfet_03v3 ad=0.65p pd=3.02u as=0.65p ps=3.02u w=2.5u l=1u
X9 tp.0.t0 VREF.t49 fa.0.t48 tp.0.t0 pfet_03v3 ad=1.248p pd=5.32u as=1.248p ps=5.32u w=4.8u l=0.4u
X10 ts.0.t3 VBN.t8 VSS.t83 VSS.t82 nfet_03v3 ad=0.65p pd=3.02u as=0.65p ps=3.02u w=2.5u l=1u
X11 tp.0.t0 VREF.t33 fa.0.t56 tp.0.t0 pfet_03v3 ad=1.248p pd=5.32u as=1.248p ps=5.32u w=4.8u l=0.4u
X12 VDD.t122 d2a.0.t30 n3a.0.t7 VDD.t121 pfet_03v3 ad=0.52p pd=2.52u as=0.52p ps=2.52u w=2u l=0.28u
X13 fb.0.t35 VREF.t60 tp.0.t0 tp.0.t0 pfet_03v3 ad=1.248p pd=5.32u as=1.248p ps=5.32u w=4.8u l=0.4u
X14 VSS.t55 VBN.t23 fb.0.t14 VSS.t54 nfet_03v3 ad=0.65p pd=3.02u as=0.65p ps=3.02u w=2.5u l=1u
X15 VSS.t15 VBN.t11 ts.0.t0 VSS.t14 nfet_03v3 ad=0.65p pd=3.02u as=0.65p ps=3.02u w=2.5u l=1u
X16 tp.0.t0 gn.0.t12 fb.0.t33 tp.0.t0 pfet_03v3 ad=1.248p pd=5.32u as=1.248p ps=5.32u w=4.8u l=0.4u
X17 VSS.t59 VBN.t19 tn.0.t3 VSS.t58 nfet_03v3 ad=0.65p pd=3.02u as=0.65p ps=3.02u w=2.5u l=1u
X18 tn.0.t50 gp.0.t9 oa.0.t28 VSS.t255 nfet_03v3 ad=1.235p pd=5.27u as=1.235p ps=5.27u w=4.75u l=0.5u
X19 gp.0.t0 INP.t0 VDD.t55 ppolyf_u r_width=5u r_length=1.8u
X20 tp.0.t0 VREF.t47 fb.0.t42 tp.0.t0 pfet_03v3 ad=1.248p pd=5.32u as=1.248p ps=5.32u w=4.8u l=0.4u
X21 VSS.t11 VBN.t3 ts.0.t8 VSS.t10 nfet_03v3 ad=0.65p pd=3.02u as=0.65p ps=3.02u w=2.5u l=1u
X22 ob.0.t27 rlb_m1.0.t1 VSS.t257 ppolyf_u_1k r_width=2u r_length=9.11u
X23 fa.0.t34 VB2.t9 oa.0.t15 VSS.t199 nfet_03v3 ad=1.1752p pd=5.04u as=1.1752p ps=5.04u w=4.52u l=0.5u
X24 ob.0.t8 VB2.t3 fb.0.t28 VSS.t205 nfet_03v3 ad=1.1752p pd=5.04u as=1.1752p ps=5.04u w=4.52u l=0.5u
X25 VDD.t162 VBP.t7 tp.0.t0 VDD.t161 pfet_03v3 ad=1.3p pd=5.52u as=1.3p ps=5.52u w=5u l=1u
X26 fa.0.t36 VB2.t7 oa.0.t13 VSS.t201 nfet_03v3 ad=1.1752p pd=5.04u as=1.1752p ps=5.04u w=4.52u l=0.5u
X27 ob.0.t12 VB2.t5 fb.0.t26 VSS.t203 nfet_03v3 ad=1.1752p pd=5.04u as=1.1752p ps=5.04u w=4.52u l=0.5u
X28 tn.0.t19 gn.0.t8 ob.0.t1 VSS.t110 nfet_03v3 ad=1.235p pd=5.27u as=1.235p ps=5.27u w=4.75u l=0.5u
X29 VDD.t58 i1.0.t5 i2.0.t2 VDD.t57 pfet_03v3 ad=0.975p pd=4.27u as=0.975p ps=4.27u w=3.75u l=0.28u
X30 tp.0.t0 VREF.t29 fa.0.t58 tp.0.t0 pfet_03v3 ad=1.248p pd=5.32u as=1.248p ps=5.32u w=4.8u l=0.4u
X31 ob.0.t5 VSS.t132 VSS.t134 VSS.t133 nfet_03v3 ad=1.1752p pd=5.04u as=1.9888p ps=9.92u w=4.52u l=0.5u
X32 tn.0.t15 gp.0.t7 oa.0.t4 VSS.t106 nfet_03v3 ad=1.235p pd=5.27u as=1.235p ps=5.27u w=4.75u l=0.5u
X33 d2b.0.t7 d2a.0.t24 VDD.t92 VDD.t91 pfet_03v3 ad=0.52p pd=2.52u as=0.52p ps=2.52u w=2u l=0.28u
X34 VDD.t107 nd.0.t6 i1.0.t2 VDD.t106 pfet_03v3 ad=0.962p pd=4.22u as=0.962p ps=4.22u w=3.7u l=0.28u
X35 tp.0.t0 VBP.t10 VDD.t156 VDD.t155 pfet_03v3 ad=1.3p pd=5.52u as=1.3p ps=5.52u w=5u l=1u
X36 VDD.t177 rla_m1.0.t1 VSS.t256 ppolyf_u_1k r_width=2u r_length=9.11u
X37 fa.0.t5 VBN.t38 VSS.t27 VSS.t26 nfet_03v3 ad=0.65p pd=3.02u as=0.65p ps=3.02u w=2.5u l=1u
X38 fb.0.t11 VBN.t28 VSS.t49 VSS.t48 nfet_03v3 ad=0.65p pd=3.02u as=0.65p ps=3.02u w=2.5u l=1u
X39 tp.0.t0 gp.0.t19 fa.0.t24 tp.0.t0 pfet_03v3 ad=1.248p pd=5.32u as=1.248p ps=5.32u w=4.8u l=0.4u
X40 i2.0.t0 VDD.t42 VDD.t44 VDD.t43 pfet_03v3 ad=0.975p pd=4.27u as=1.65p ps=8.38u w=3.75u l=0.28u
X41 oa.0.t24 VREF.t6 tn.0.t41 VSS.t239 nfet_03v3 ad=1.235p pd=5.27u as=1.235p ps=5.27u w=4.75u l=0.5u
X42 VSS.t115 i2.0.t11 OUT.t0 VSS.t114 nfet_03v3 ad=1.04p pd=4.52u as=1.04p ps=4.52u w=4u l=0.28u
X43 VDD.t41 VDD.t39 VDD.t41 VDD.t40 pfet_03v3 ad=0.962p pd=4.22u as=0 ps=0 w=3.7u l=0.28u
X44 VDD.t90 d2a.0.t23 d2b.0.t6 VDD.t89 pfet_03v3 ad=0.52p pd=2.52u as=0.52p ps=2.52u w=2u l=0.28u
X45 fb.0.t49 VREF.t32 tp.0.t0 tp.0.t0 pfet_03v3 ad=1.248p pd=5.32u as=1.248p ps=5.32u w=4.8u l=0.4u
X46 VSS.t19 VBN.t43 fb.0.t4 VSS.t18 nfet_03v3 ad=0.65p pd=3.02u as=0.65p ps=3.02u w=2.5u l=1u
X47 OUT.t5 i2.0.t8 VDD.t191 VDD.t190 pfet_03v3 ad=1.3p pd=5.52u as=1.3p ps=5.52u w=5u l=0.28u
X48 VDD.t14 VDD.t12 tp.0.t0 VDD.t13 pfet_03v3 ad=2.2p pd=10.88u as=1.3p ps=5.52u w=5u l=1u
X49 tp.0.t0 VREF.t61 fa.0.t42 tp.0.t0 pfet_03v3 ad=1.248p pd=5.32u as=1.248p ps=5.32u w=4.8u l=0.4u
X50 VSS.t217 VSS.t218 VSS.t216 ppolyf_u_1k r_width=2u r_length=9.11u
X51 tp.0.t0 VREF.t21 fa.0.t62 tp.0.t0 pfet_03v3 ad=1.248p pd=5.32u as=1.248p ps=5.32u w=4.8u l=0.4u
X52 tn.0.t35 VREF.t11 ob.0.t20 VSS.t234 nfet_03v3 ad=1.235p pd=5.27u as=1.235p ps=5.27u w=4.75u l=0.5u
X53 tp.0.t0 VBP.t14 VDD.t148 VDD.t147 pfet_03v3 ad=1.3p pd=5.52u as=1.3p ps=5.52u w=5u l=1u
X54 tp.0.t0 gp.0.t27 fa.0.t23 tp.0.t0 pfet_03v3 ad=1.248p pd=5.32u as=1.248p ps=5.32u w=4.8u l=0.4u
X55 fa.0.t55 VREF.t34 tp.0.t0 tp.0.t0 pfet_03v3 ad=1.248p pd=5.32u as=1.248p ps=5.32u w=4.8u l=0.4u
X56 OUT.t8 VSS.t186 VSS.t188 VSS.t187 nfet_03v3 ad=1.04p pd=4.52u as=1.76p ps=8.88u w=4u l=0.28u
X57 tn.0.t0 gp.0.t1 oa.0.t0 VSS.t3 nfet_03v3 ad=1.235p pd=5.27u as=1.235p ps=5.27u w=4.75u l=0.5u
X58 VSS.t185 VSS.t183 VSS.t185 VSS.t184 nfet_03v3 ad=0.78p pd=3.52u as=0 ps=0 w=3u l=0.28u
X59 VDD.t193 i2.0.t9 OUT.t6 VDD.t192 pfet_03v3 ad=1.3p pd=5.52u as=1.3p ps=5.52u w=5u l=0.28u
X60 d2b.0.t9 d2b.0.t8 VDD.t109 VDD.t108 pfet_03v3 ad=0.52p pd=2.52u as=0.52p ps=2.52u w=2u l=0.28u
X61 VSS.t149 VSS.t147 fa.0.t29 VSS.t148 nfet_03v3 ad=1.1p pd=5.88u as=0.65p ps=3.02u w=2.5u l=1u
X62 VSS.t137 VSS.t135 fb.0.t24 VSS.t136 nfet_03v3 ad=1.9888p pd=9.92u as=1.1752p ps=5.04u w=4.52u l=0.5u
X63 nm.0.t1 d3.0.t11 nd.0.t5 VSS.t225 nfet_03v3 ad=0.52p pd=2.52u as=0.52p ps=2.52u w=2u l=0.28u
X64 VDD.t115 d2a.0.t14 d2a.0.t15 VDD.t114 pfet_03v3 ad=0.52p pd=2.52u as=0.52p ps=2.52u w=2u l=0.28u
X65 d3.0.t1 d2b.0.t26 VDD.t64 VDD.t63 pfet_03v3 ad=0.52p pd=2.52u as=0.52p ps=2.52u w=2u l=0.28u
X66 VDD.t138 VBP.t19 tp.0.t0 VDD.t137 pfet_03v3 ad=1.3p pd=5.52u as=1.3p ps=5.52u w=5u l=1u
X67 tp.0.t0 gn.0.t26 fb.0.t0 tp.0.t0 pfet_03v3 ad=1.248p pd=5.32u as=1.248p ps=5.32u w=4.8u l=0.4u
X68 fa.0.t21 gp.0.t26 tp.0.t0 tp.0.t0 pfet_03v3 ad=1.248p pd=5.32u as=1.248p ps=5.32u w=4.8u l=0.4u
X69 tp.0.t0 gn.0.t14 fb.0.t19 tp.0.t0 pfet_03v3 ad=1.248p pd=5.32u as=1.248p ps=5.32u w=4.8u l=0.4u
X70 tp.0.t0 VBP.t4 VDD.t168 VDD.t167 pfet_03v3 ad=1.3p pd=5.52u as=1.3p ps=5.52u w=5u l=1u
X71 fb.0.t22 gn.0.t19 tp.0.t0 tp.0.t0 pfet_03v3 ad=1.248p pd=5.32u as=1.248p ps=5.32u w=4.8u l=0.4u
X72 VSS.t67 VBN.t17 tn.0.t5 VSS.t66 nfet_03v3 ad=0.65p pd=3.02u as=0.65p ps=3.02u w=2.5u l=1u
X73 ob.0.t25 VREF.t0 tn.0.t32 VSS.t245 nfet_03v3 ad=2.09p pd=10.38u as=1.235p ps=5.27u w=4.75u l=0.5u
X74 VDD.t62 d2b.0.t25 d3.0.t0 VDD.t61 pfet_03v3 ad=0.52p pd=2.52u as=0.52p ps=2.52u w=2u l=0.28u
X75 VSS.t91 VBN.t5 ts.0.t6 VSS.t90 nfet_03v3 ad=0.65p pd=3.02u as=0.65p ps=3.02u w=2.5u l=1u
X76 VDD.t29 VDD.t27 VDD.t29 VDD.t28 pfet_03v3 ad=0.52p pd=2.52u as=0 ps=0 w=2u l=0.5u
X77 VDD.t97 d2a.0.t26 n3a.0.t3 VDD.t96 pfet_03v3 ad=0.52p pd=2.52u as=0.52p ps=2.52u w=2u l=0.28u
X78 d2a.0.t0 VDD.t15 VDD.t17 VDD.t16 pfet_03v3 ad=0.52p pd=2.52u as=0.88p ps=4.88u w=2u l=0.5u
X79 VDD.t56 rlb_m1.0.t0 VSS.t111 ppolyf_u_1k r_width=2u r_length=9.11u
X80 fa.0.t41 VREF.t62 tp.0.t0 tp.0.t0 pfet_03v3 ad=1.248p pd=5.32u as=1.248p ps=5.32u w=4.8u l=0.4u
X81 fa.0.t18 gp.0.t20 tp.0.t0 tp.0.t0 pfet_03v3 ad=1.248p pd=5.32u as=1.248p ps=5.32u w=4.8u l=0.4u
X82 fb.0.t55 VREF.t20 tp.0.t0 tp.0.t0 pfet_03v3 ad=2.112p pd=10.48u as=1.248p ps=5.32u w=4.8u l=0.4u
X83 fa.0.t7 VBN.t34 VSS.t37 VSS.t36 nfet_03v3 ad=0.65p pd=3.02u as=0.65p ps=3.02u w=2.5u l=1u
X84 tn.0.t27 gp.0.t5 oa.0.t17 VSS.t214 nfet_03v3 ad=1.235p pd=5.27u as=1.235p ps=5.27u w=4.75u l=0.5u
X85 VDD.t158 VBP.t9 tp.0.t0 VDD.t157 pfet_03v3 ad=1.3p pd=5.52u as=1.3p ps=5.52u w=5u l=1u
X86 nd.0.t0 VDD.t30 VDD.t32 VDD.t31 pfet_03v3 ad=0.78p pd=3.52u as=1.32p ps=6.88u w=3u l=0.28u
X87 fa.0.t17 gp.0.t28 tp.0.t0 tp.0.t0 pfet_03v3 ad=1.248p pd=5.32u as=1.248p ps=5.32u w=4.8u l=0.4u
X88 fb.0.t62 gn.0.t13 tp.0.t0 tp.0.t0 pfet_03v3 ad=1.248p pd=5.32u as=1.248p ps=5.32u w=4.8u l=0.4u
X89 tn.0.t23 VSS.t150 VSS.t152 VSS.t151 nfet_03v3 ad=0.65p pd=3.02u as=1.1p ps=5.88u w=2.5u l=1u
X90 d2b.0.t17 ob.0.t29 sb.0.t2 VSS.t222 nfet_03v3 ad=1.1362p pd=4.89u as=1.1362p ps=4.89u w=4.37u l=0.5u
X91 tn.0.t40 VREF.t9 oa.0.t23 VSS.t236 nfet_03v3 ad=1.235p pd=5.27u as=1.235p ps=5.27u w=4.75u l=0.5u
X92 ts.0.t11 VBN.t0 VSS.t95 VSS.t94 nfet_03v3 ad=0.65p pd=3.02u as=0.65p ps=3.02u w=2.5u l=1u
X93 sa.0.t1 oa.0.t30 d2a.0.t10 VSS.t253 nfet_03v3 ad=1.1362p pd=4.89u as=1.1362p ps=4.89u w=4.37u l=0.5u
X94 fb.0.t47 VREF.t36 tp.0.t0 tp.0.t0 pfet_03v3 ad=1.248p pd=5.32u as=1.248p ps=5.32u w=4.8u l=0.4u
X95 tn.0.t20 gn.0.t10 ob.0.t2 VSS.t112 nfet_03v3 ad=1.235p pd=5.27u as=1.235p ps=5.27u w=4.75u l=0.5u
X96 tn.0.t49 gn.0.t2 ob.0.t26 VSS.t246 nfet_03v3 ad=1.235p pd=5.27u as=1.235p ps=5.27u w=4.75u l=0.5u
X97 tp.0.t0 VREF.t45 fa.0.t50 tp.0.t0 pfet_03v3 ad=1.248p pd=5.32u as=1.248p ps=5.32u w=4.8u l=0.4u
X98 fa.0.t61 VREF.t22 tp.0.t0 tp.0.t0 pfet_03v3 ad=1.248p pd=5.32u as=1.248p ps=5.32u w=4.8u l=0.4u
X99 VDD.t78 d2b.0.t14 d2b.0.t15 VDD.t77 pfet_03v3 ad=0.52p pd=2.52u as=0.52p ps=2.52u w=2u l=0.28u
X100 n3a.0.t6 d2a.0.t29 VDD.t103 VDD.t102 pfet_03v3 ad=0.52p pd=2.52u as=0.52p ps=2.52u w=2u l=0.28u
D0 gn.0.t33 VDD.t54 diode_pd2nw_03v3 pj=26u area=40p
X101 fb.0.t1 gn.0.t27 tp.0.t0 tp.0.t0 pfet_03v3 ad=1.248p pd=5.32u as=1.248p ps=5.32u w=4.8u l=0.4u
X102 tn.0.t13 gp.0.t3 oa.0.t3 VSS.t101 nfet_03v3 ad=1.235p pd=5.27u as=1.235p ps=5.27u w=4.75u l=0.5u
X103 fa.0.t14 gp.0.t14 tp.0.t0 tp.0.t0 pfet_03v3 ad=1.248p pd=5.32u as=1.248p ps=5.32u w=4.8u l=0.4u
X104 fb.0.t3 VBN.t44 VSS.t17 VSS.t16 nfet_03v3 ad=0.65p pd=3.02u as=0.65p ps=3.02u w=2.5u l=1u
X105 tn.0.t10 VBN.t12 VSS.t77 VSS.t76 nfet_03v3 ad=0.65p pd=3.02u as=0.65p ps=3.02u w=2.5u l=1u
X106 d3.0.t8 d2b.0.t30 VDD.t183 VDD.t182 pfet_03v3 ad=0.52p pd=2.52u as=0.52p ps=2.52u w=2u l=0.28u
X107 fb.0.t7 VBN.t36 VSS.t33 VSS.t32 nfet_03v3 ad=0.65p pd=3.02u as=0.65p ps=3.02u w=2.5u l=1u
X108 ts.0.t1 VBN.t10 VSS.t79 VSS.t78 nfet_03v3 ad=0.65p pd=3.02u as=0.65p ps=3.02u w=2.5u l=1u
D1 VSS.t97 gn.0.t34 diode_nd2ps_03v3 pj=26u area=40p
X109 tp.0.t0 gn.0.t32 fb.0.t15 tp.0.t0 pfet_03v3 ad=1.248p pd=5.32u as=1.248p ps=5.32u w=4.8u l=0.4u
X110 oa.0.t14 VB2.t10 fa.0.t33 VSS.t198 nfet_03v3 ad=1.1752p pd=5.04u as=1.1752p ps=5.04u w=4.52u l=0.5u
X111 VSS.t9 VBN.t41 fa.0.t4 VSS.t8 nfet_03v3 ad=0.65p pd=3.02u as=0.65p ps=3.02u w=2.5u l=1u
X112 VSS.t25 VBN.t25 fa.0.t12 VSS.t24 nfet_03v3 ad=0.65p pd=3.02u as=0.65p ps=3.02u w=2.5u l=1u
X113 tp.0.t0 gp.0.t25 fa.0.t65 tp.0.t0 pfet_03v3 ad=1.248p pd=5.32u as=1.248p ps=5.32u w=4.8u l=0.4u
X114 tp.0.t0 gp.0.t15 fa.0.t19 tp.0.t0 pfet_03v3 ad=1.248p pd=5.32u as=1.248p ps=5.32u w=4.8u l=0.4u
X115 fb.0.t23 gn.0.t15 tp.0.t0 tp.0.t0 pfet_03v3 ad=1.248p pd=5.32u as=1.248p ps=5.32u w=4.8u l=0.4u
X116 VDD.t181 d2b.0.t29 d3.0.t7 VDD.t180 pfet_03v3 ad=0.52p pd=2.52u as=0.52p ps=2.52u w=2u l=0.28u
X117 oa.0.t8 rla_m1.0.t0 VSS.t118 ppolyf_u_1k r_width=2u r_length=9.11u
X118 VSS.t248 n3a.0.t12 n3a.0.t13 VSS.t247 nfet_03v3 ad=0.6734p pd=3.11u as=0.6734p ps=3.11u w=2.59u l=0.28u
X119 fa.0.t28 VSS.t144 VSS.t146 VSS.t145 nfet_03v3 ad=0.65p pd=3.02u as=1.1p ps=5.88u w=2.5u l=1u
X120 tn.0.t33 VREF.t15 ob.0.t18 VSS.t230 nfet_03v3 ad=1.235p pd=5.27u as=1.235p ps=5.27u w=4.75u l=0.5u
X121 VSS.t122 VSS.t120 VSS.t122 VSS.t121 nfet_03v3 ad=1.1396p pd=6.06u as=0 ps=0 w=2.59u l=0.28u
X122 tp.0.t0 VBP.t12 VDD.t152 VDD.t151 pfet_03v3 ad=1.3p pd=5.52u as=1.3p ps=5.52u w=5u l=1u
X123 VSS.t23 VBN.t39 fb.0.t6 VSS.t22 nfet_03v3 ad=0.65p pd=3.02u as=0.65p ps=3.02u w=2.5u l=1u
X124 VDD.t142 VBP.t17 tp.0.t0 VDD.t141 pfet_03v3 ad=1.3p pd=5.52u as=1.3p ps=5.52u w=5u l=1u
X125 VDD.t170 VBP.t3 tp.0.t0 VDD.t169 pfet_03v3 ad=1.3p pd=5.52u as=1.3p ps=5.52u w=5u l=1u
X126 fa.0.t49 VREF.t46 tp.0.t0 tp.0.t0 pfet_03v3 ad=1.248p pd=5.32u as=1.248p ps=5.32u w=4.8u l=0.4u
X127 tp.0.t0 VREF.t35 fb.0.t48 tp.0.t0 pfet_03v3 ad=1.248p pd=5.32u as=1.248p ps=5.32u w=4.8u l=0.4u
X128 gn.0.t0 INN.t0 VDD.t95 ppolyf_u r_width=5u r_length=1.8u
X129 d3.0.t3 d2b.0.t32 VDD.t105 VDD.t104 pfet_03v3 ad=0.52p pd=2.52u as=0.52p ps=2.52u w=2u l=0.28u
X130 fa.0.t43 VREF.t58 tp.0.t0 tp.0.t0 pfet_03v3 ad=1.248p pd=5.32u as=1.248p ps=5.32u w=4.8u l=0.4u
X131 VDD.t84 EN.t2 d2b.0.t4 VDD.t83 pfet_03v3 ad=0.52p pd=2.52u as=0.52p ps=2.52u w=2u l=0.5u
X132 n3a.0.t0 VDD.t6 VDD.t8 VDD.t7 pfet_03v3 ad=0.52p pd=2.52u as=0.88p ps=4.88u w=2u l=0.28u
X133 tp.0.t0 VBP.t6 VDD.t164 VDD.t163 pfet_03v3 ad=1.3p pd=5.52u as=1.3p ps=5.52u w=5u l=1u
X134 tp.0.t0 gp.0.t13 fa.0.t0 tp.0.t0 pfet_03v3 ad=1.248p pd=5.32u as=1.248p ps=5.32u w=4.8u l=0.4u
X135 tp.0.t0 VDD.t9 VDD.t11 VDD.t10 pfet_03v3 ad=1.3p pd=5.52u as=2.2p ps=10.88u w=5u l=1u
X136 fb.0.t43 VREF.t44 tp.0.t0 tp.0.t0 pfet_03v3 ad=1.248p pd=5.32u as=1.248p ps=5.32u w=4.8u l=0.4u
X137 fa.0.t53 VREF.t38 tp.0.t0 tp.0.t0 pfet_03v3 ad=1.248p pd=5.32u as=1.248p ps=5.32u w=4.8u l=0.4u
X138 oa.0.t16 VB2.t8 fa.0.t35 VSS.t200 nfet_03v3 ad=1.1752p pd=5.04u as=1.1752p ps=5.04u w=4.52u l=0.5u
X139 sb.0.t1 ob.0.t30 d2b.0.t16 VSS.t221 nfet_03v3 ad=1.1362p pd=4.89u as=1.1362p ps=4.89u w=4.37u l=0.5u
X140 VDD.t174 VBP.t1 tp.0.t0 VDD.t173 pfet_03v3 ad=1.3p pd=5.52u as=1.3p ps=5.52u w=5u l=1u
X141 VSS.t143 VSS.t141 fa.0.t27 VSS.t142 nfet_03v3 ad=1.9888p pd=9.92u as=1.1752p ps=5.04u w=4.52u l=0.5u
X142 tp.0.t0 VREF.t55 fb.0.t38 tp.0.t0 pfet_03v3 ad=1.248p pd=5.32u as=1.248p ps=5.32u w=4.8u l=0.4u
X143 fb.0.t25 VB2.t6 ob.0.t11 VSS.t202 nfet_03v3 ad=1.1752p pd=5.04u as=1.1752p ps=5.04u w=4.52u l=0.5u
X144 tn.0.t2 VBN.t20 VSS.t63 VSS.t62 nfet_03v3 ad=0.65p pd=3.02u as=0.65p ps=3.02u w=2.5u l=1u
X145 ob.0.t28 gn.0.t7 tn.0.t51 VSS.t260 nfet_03v3 ad=1.235p pd=5.27u as=1.235p ps=5.27u w=4.75u l=0.5u
D2 VSS.t100 gp.0.t33 diode_nd2ps_03v3 pj=26u area=40p
X146 ts.0.t9 VBN.t2 VSS.t13 VSS.t12 nfet_03v3 ad=0.65p pd=3.02u as=0.65p ps=3.02u w=2.5u l=1u
X147 OUT.t2 VDD.t48 VDD.t50 VDD.t49 pfet_03v3 ad=1.3p pd=5.52u as=2.2p ps=10.88u w=5u l=0.28u
X148 VDD.t111 d2b.0.t10 d2b.0.t11 VDD.t110 pfet_03v3 ad=0.52p pd=2.52u as=0.52p ps=2.52u w=2u l=0.28u
X149 fa.0.t20 gp.0.t32 tp.0.t0 tp.0.t0 pfet_03v3 ad=1.248p pd=5.32u as=1.248p ps=5.32u w=4.8u l=0.4u
X150 tp.0.t0 gp.0.t31 fa.0.t39 tp.0.t0 pfet_03v3 ad=1.248p pd=5.32u as=1.248p ps=5.32u w=4.8u l=0.4u
X151 fb.0.t45 VREF.t40 tp.0.t0 tp.0.t0 pfet_03v3 ad=1.248p pd=5.32u as=1.248p ps=5.32u w=4.8u l=0.4u
X152 VSS.t75 VBN.t13 tn.0.t9 VSS.t74 nfet_03v3 ad=0.65p pd=3.02u as=0.65p ps=3.02u w=2.5u l=1u
X153 VSS.t117 i1.0.t6 i2.0.t3 VSS.t116 nfet_03v3 ad=0.78p pd=3.52u as=0.78p ps=3.52u w=3u l=0.28u
X154 VSS.t220 nd.0.t7 i1.0.t3 VSS.t219 nfet_03v3 ad=0.39p pd=2.02u as=0.39p ps=2.02u w=1.5u l=0.28u
X155 VSS.t194 EN.t1 nm.0.t0 VSS.t193 nfet_03v3 ad=0.52p pd=2.52u as=0.52p ps=2.52u w=2u l=0.28u
X156 VSS.t211 VSS.t212 VSS.t210 ppolyf_u_1k r_width=2u r_length=3.17u
D3 gp.0.t34 VDD.t118 diode_pd2nw_03v3 pj=26u area=40p
X157 fa.0.t9 VBN.t30 VSS.t31 VSS.t30 nfet_03v3 ad=0.65p pd=3.02u as=0.65p ps=3.02u w=2.5u l=1u
X158 tn.0.t37 VREF.t19 ob.0.t16 VSS.t226 nfet_03v3 ad=1.235p pd=5.27u as=2.09p ps=10.38u w=4.75u l=0.5u
X159 tn.0.t46 VREF.t13 oa.0.t21 VSS.t232 nfet_03v3 ad=1.235p pd=5.27u as=1.235p ps=5.27u w=4.75u l=0.5u
X160 nd.0.t2 VSS.t171 VSS.t173 VSS.t172 nfet_03v3 ad=0.52p pd=2.52u as=0.88p ps=4.88u w=2u l=0.28u
X161 tn.0.t28 gn.0.t4 ob.0.t15 VSS.t215 nfet_03v3 ad=1.235p pd=5.27u as=1.235p ps=5.27u w=4.75u l=0.5u
X162 tn.0.t29 VREF.t7 ob.0.t22 VSS.t238 nfet_03v3 ad=1.235p pd=5.27u as=1.235p ps=5.27u w=4.75u l=0.5u
X163 tp.0.t0 gp.0.t23 fa.0.t63 tp.0.t0 pfet_03v3 ad=1.248p pd=5.32u as=1.248p ps=5.32u w=4.8u l=0.4u
X164 ts.0.t13 VSS.t129 VSS.t131 VSS.t130 nfet_03v3 ad=0.65p pd=3.02u as=1.1p ps=5.88u w=2.5u l=1u
X165 tp.0.t0 gn.0.t20 fb.0.t56 tp.0.t0 pfet_03v3 ad=1.248p pd=5.32u as=1.248p ps=5.32u w=4.8u l=0.4u
X166 VSS.t39 VBN.t33 fa.0.t8 VSS.t38 nfet_03v3 ad=0.65p pd=3.02u as=0.65p ps=3.02u w=2.5u l=1u
X167 tn.0.t4 VBN.t18 VSS.t65 VSS.t64 nfet_03v3 ad=0.65p pd=3.02u as=0.65p ps=3.02u w=2.5u l=1u
X168 tp.0.t0 VREF.t59 fb.0.t36 tp.0.t0 pfet_03v3 ad=1.248p pd=5.32u as=1.248p ps=5.32u w=4.8u l=0.4u
X169 VDD.t53 VDD.t51 OUT.t1 VDD.t52 pfet_03v3 ad=2.2p pd=10.88u as=1.3p ps=5.52u w=5u l=0.28u
X170 i2.0.t4 VSS.t180 VSS.t182 VSS.t181 nfet_03v3 ad=0.78p pd=3.52u as=1.32p ps=6.88u w=3u l=0.28u
X171 VSS.t125 VSS.t123 VSS.t125 VSS.t124 nfet_03v3 ad=0.52p pd=2.52u as=0 ps=0 w=2u l=0.28u
X172 n3a.0.t2 d2a.0.t25 VDD.t94 VDD.t93 pfet_03v3 ad=0.52p pd=2.52u as=0.52p ps=2.52u w=2u l=0.28u
X173 tp.0.t0 VREF.t23 fb.0.t54 tp.0.t0 pfet_03v3 ad=1.248p pd=5.32u as=1.248p ps=5.32u w=4.8u l=0.4u
X174 i1.0.t1 VSS.t174 VSS.t176 VSS.t175 nfet_03v3 ad=0.39p pd=2.02u as=0.66p ps=3.88u w=1.5u l=0.28u
X175 VSS.t71 VBN.t15 tn.0.t7 VSS.t70 nfet_03v3 ad=0.65p pd=3.02u as=0.65p ps=3.02u w=2.5u l=1u
X176 oa.0.t22 VREF.t10 tn.0.t39 VSS.t235 nfet_03v3 ad=1.235p pd=5.27u as=1.235p ps=5.27u w=4.75u l=0.5u
X177 tp.0.t0 VBP.t8 VDD.t160 VDD.t159 pfet_03v3 ad=1.3p pd=5.52u as=1.3p ps=5.52u w=5u l=1u
X178 tp.0.t0 VREF.t37 fa.0.t54 tp.0.t0 pfet_03v3 ad=1.248p pd=5.32u as=1.248p ps=5.32u w=4.8u l=0.4u
X179 VSS.t87 VBN.t7 ts.0.t4 VSS.t86 nfet_03v3 ad=0.65p pd=3.02u as=0.65p ps=3.02u w=2.5u l=1u
X180 oa.0.t9 VSS.t138 VSS.t140 VSS.t139 nfet_03v3 ad=1.1752p pd=5.04u as=1.9888p ps=9.92u w=4.52u l=0.5u
X181 VDD.t113 d3.0.t10 nd.0.t4 VDD.t112 pfet_03v3 ad=0.78p pd=3.52u as=0.78p ps=3.52u w=3u l=0.28u
X182 fb.0.t37 VREF.t56 tp.0.t0 tp.0.t0 pfet_03v3 ad=1.248p pd=5.32u as=1.248p ps=5.32u w=4.8u l=0.4u
X183 tp.0.t0 VREF.t25 fa.0.t60 tp.0.t0 pfet_03v3 ad=1.248p pd=5.32u as=1.248p ps=5.32u w=4.8u l=0.4u
X184 fa.0.t13 VBN.t22 VSS.t57 VSS.t56 nfet_03v3 ad=0.65p pd=3.02u as=0.65p ps=3.02u w=2.5u l=1u
X185 OUT.t3 i2.0.t6 VDD.t120 VDD.t119 pfet_03v3 ad=1.3p pd=5.52u as=1.3p ps=5.52u w=5u l=0.28u
X186 VDD.t5 VDD.t3 n3a.0.t1 VDD.t4 pfet_03v3 ad=0.88p pd=4.88u as=0.52p ps=2.52u w=2u l=0.28u
X187 tp.0.t0 gn.0.t22 fb.0.t58 tp.0.t0 pfet_03v3 ad=1.248p pd=5.32u as=1.248p ps=5.32u w=4.8u l=0.4u
X188 fa.0.t59 VREF.t26 tp.0.t0 tp.0.t0 pfet_03v3 ad=1.248p pd=5.32u as=1.248p ps=5.32u w=4.8u l=0.4u
X189 oa.0.t11 VB2.t12 fa.0.t31 VSS.t196 nfet_03v3 ad=1.1752p pd=5.04u as=1.1752p ps=5.04u w=4.52u l=0.5u
X190 fb.0.t31 VB2.t0 ob.0.t7 VSS.t208 nfet_03v3 ad=1.1752p pd=5.04u as=1.1752p ps=5.04u w=4.52u l=0.5u
X191 fb.0.t18 gn.0.t25 tp.0.t0 tp.0.t0 pfet_03v3 ad=1.248p pd=5.32u as=1.248p ps=5.32u w=4.8u l=0.4u
X192 VSS.t29 VBN.t37 fa.0.t6 VSS.t28 nfet_03v3 ad=0.65p pd=3.02u as=0.65p ps=3.02u w=2.5u l=1u
X193 fb.0.t29 VB2.t2 ob.0.t9 VSS.t206 nfet_03v3 ad=1.1752p pd=5.04u as=1.1752p ps=5.04u w=4.52u l=0.5u
X194 d2a.0.t1 VDD.t18 VDD.t20 VDD.t19 pfet_03v3 ad=0.52p pd=2.52u as=0.88p ps=4.88u w=2u l=0.28u
X195 tp.0.t0 VREF.t39 fb.0.t46 tp.0.t0 pfet_03v3 ad=1.248p pd=5.32u as=1.248p ps=5.32u w=4.8u l=0.4u
X196 d2b.0.t13 d2b.0.t12 VDD.t76 VDD.t75 pfet_03v3 ad=0.52p pd=2.52u as=0.52p ps=2.52u w=2u l=0.28u
X197 VDD.t101 d2a.0.t28 n3a.0.t5 VDD.t100 pfet_03v3 ad=0.52p pd=2.52u as=0.52p ps=2.52u w=2u l=0.28u
X198 nd.0.t3 EN.t0 VDD.t82 VDD.t81 pfet_03v3 ad=0.78p pd=3.52u as=0.78p ps=3.52u w=3u l=0.28u
X199 fa.0.t45 VREF.t54 tp.0.t0 tp.0.t0 pfet_03v3 ad=1.248p pd=5.32u as=1.248p ps=5.32u w=4.8u l=0.4u
X200 fb.0.t51 VREF.t28 tp.0.t0 tp.0.t0 pfet_03v3 ad=1.248p pd=5.32u as=1.248p ps=5.32u w=4.8u l=0.4u
X201 tn.0.t44 VREF.t17 oa.0.t19 VSS.t228 nfet_03v3 ad=1.235p pd=5.27u as=1.235p ps=5.27u w=4.75u l=0.5u
X202 fa.0.t40 gp.0.t24 tp.0.t0 tp.0.t0 pfet_03v3 ad=1.248p pd=5.32u as=1.248p ps=5.32u w=4.8u l=0.4u
X203 fa.0.t3 VBN.t42 VSS.t7 VSS.t6 nfet_03v3 ad=0.65p pd=3.02u as=0.65p ps=3.02u w=2.5u l=1u
X204 tn.0.t48 VREF.t1 oa.0.t27 VSS.t244 nfet_03v3 ad=1.235p pd=5.27u as=1.235p ps=5.27u w=4.75u l=0.5u
X205 VDD.t23 VDD.t21 d2b.0.t0 VDD.t22 pfet_03v3 ad=0.88p pd=4.88u as=0.52p ps=2.52u w=2u l=0.28u
X206 ts.0.t15 sa.0.t0 VSS.t213 ppolyf_u_1k r_width=2u r_length=3.17u
X207 tp.0.t0 VBP.t0 VDD.t176 VDD.t175 pfet_03v3 ad=1.3p pd=5.52u as=1.3p ps=5.52u w=5u l=1u
X208 fb.0.t21 gn.0.t17 tp.0.t0 tp.0.t0 pfet_03v3 ad=1.248p pd=5.32u as=1.248p ps=5.32u w=4.8u l=0.4u
X209 tn.0.t31 VREF.t3 ob.0.t24 VSS.t242 nfet_03v3 ad=1.235p pd=5.27u as=1.235p ps=5.27u w=4.75u l=0.5u
X210 VDD.t68 d2b.0.t20 d2a.0.t9 VDD.t67 pfet_03v3 ad=0.52p pd=2.52u as=0.52p ps=2.52u w=2u l=0.28u
X211 d3.0.t6 d2b.0.t28 VDD.t179 VDD.t178 pfet_03v3 ad=0.52p pd=2.52u as=0.52p ps=2.52u w=2u l=0.28u
X212 tn.0.t14 gn.0.t6 ob.0.t0 VSS.t105 nfet_03v3 ad=1.235p pd=5.27u as=1.235p ps=5.27u w=4.75u l=0.5u
X213 VSS.t51 VBN.t27 fb.0.t12 VSS.t50 nfet_03v3 ad=0.65p pd=3.02u as=0.65p ps=3.02u w=2.5u l=1u
X214 d3.0.t5 n3a.0.t15 VSS.t252 VSS.t251 nfet_03v3 ad=0.6734p pd=3.11u as=0.6734p ps=3.11u w=2.59u l=0.28u
X215 ob.0.t21 VREF.t8 tn.0.t36 VSS.t237 nfet_03v3 ad=1.235p pd=5.27u as=1.235p ps=5.27u w=4.75u l=0.5u
X216 d2b.0.t18 d2a.0.t20 VDD.t130 VDD.t129 pfet_03v3 ad=0.52p pd=2.52u as=0.52p ps=2.52u w=2u l=0.28u
X217 n3a.0.t11 n3a.0.t10 VSS.t224 VSS.t223 nfet_03v3 ad=0.6734p pd=3.11u as=0.6734p ps=3.11u w=2.59u l=0.28u
X218 oa.0.t1 gp.0.t10 tn.0.t11 VSS.t98 nfet_03v3 ad=1.235p pd=5.27u as=1.235p ps=5.27u w=4.75u l=0.5u
X219 d2b.0.t1 VDD.t24 VDD.t26 VDD.t25 pfet_03v3 ad=0.52p pd=2.52u as=0.88p ps=4.88u w=2u l=0.5u
X220 ts.0.t12 sb.0.t0 VSS.t96 ppolyf_u_1k r_width=2u r_length=3.17u
X221 tp.0.t0 VREF.t57 fa.0.t44 tp.0.t0 pfet_03v3 ad=1.248p pd=5.32u as=1.248p ps=5.32u w=4.8u l=0.4u
X222 fb.0.t53 VREF.t24 tp.0.t0 tp.0.t0 pfet_03v3 ad=1.248p pd=5.32u as=1.248p ps=5.32u w=4.8u l=0.4u
X223 ob.0.t3 gn.0.t3 tn.0.t21 VSS.t113 nfet_03v3 ad=1.235p pd=5.27u as=1.235p ps=5.27u w=4.75u l=0.5u
X224 VDD.t2 VDD.t0 VDD.t2 VDD.t1 pfet_03v3 ad=0.52p pd=2.52u as=0 ps=0 w=2u l=0.5u
X225 fb.0.t16 gn.0.t23 tp.0.t0 tp.0.t0 pfet_03v3 ad=1.248p pd=5.32u as=1.248p ps=5.32u w=4.8u l=0.4u
X226 fb.0.t9 VBN.t32 VSS.t41 VSS.t40 nfet_03v3 ad=0.65p pd=3.02u as=0.65p ps=3.02u w=2.5u l=1u
X227 oa.0.t6 gp.0.t4 tn.0.t17 VSS.t108 nfet_03v3 ad=1.235p pd=5.27u as=1.235p ps=5.27u w=4.75u l=0.5u
X228 VDD.t146 VBP.t15 tp.0.t0 VDD.t145 pfet_03v3 ad=1.3p pd=5.52u as=1.3p ps=5.52u w=5u l=1u
X229 VDD.t166 VBP.t5 tp.0.t0 VDD.t165 pfet_03v3 ad=1.3p pd=5.52u as=1.3p ps=5.52u w=5u l=1u
X230 ob.0.t4 gn.0.t9 tn.0.t22 VSS.t119 nfet_03v3 ad=1.235p pd=5.27u as=1.235p ps=5.27u w=4.75u l=0.5u
X231 VDD.t185 d2b.0.t31 d3.0.t9 VDD.t184 pfet_03v3 ad=0.52p pd=2.52u as=0.52p ps=2.52u w=2u l=0.28u
X232 d2b.0.t2 VSS.t162 VSS.t164 VSS.t163 nfet_03v3 ad=1.1362p pd=4.89u as=1.9228p ps=9.62u w=4.37u l=0.5u
X233 fb.0.t27 VB2.t4 ob.0.t13 VSS.t204 nfet_03v3 ad=1.1752p pd=5.04u as=1.1752p ps=5.04u w=4.52u l=0.5u
X234 oa.0.t5 gp.0.t8 tn.0.t16 VSS.t107 nfet_03v3 ad=1.235p pd=5.27u as=1.235p ps=5.27u w=4.75u l=0.5u
X235 VDD.t126 d2a.0.t32 n3a.0.t9 VDD.t125 pfet_03v3 ad=0.52p pd=2.52u as=0.52p ps=2.52u w=2u l=0.28u
X236 VSS.t161 VSS.t159 d2a.0.t3 VSS.t160 nfet_03v3 ad=1.9228p pd=9.62u as=1.1362p ps=4.89u w=4.37u l=0.5u
X237 fb.0.t61 gn.0.t31 tp.0.t0 tp.0.t0 pfet_03v3 ad=1.248p pd=5.32u as=1.248p ps=5.32u w=4.8u l=0.4u
X238 fa.0.t64 gp.0.t22 tp.0.t0 tp.0.t0 pfet_03v3 ad=1.248p pd=5.32u as=1.248p ps=5.32u w=4.8u l=0.4u
X239 tp.0.t0 VREF.t41 fa.0.t52 tp.0.t0 pfet_03v3 ad=1.248p pd=5.32u as=1.248p ps=5.32u w=4.8u l=0.4u
X240 tp.0.t0 VREF.t27 fb.0.t52 tp.0.t0 pfet_03v3 ad=1.248p pd=5.32u as=1.248p ps=5.32u w=4.8u l=0.4u
X241 tp.0.t0 VBP.t20 VDD.t136 VDD.t135 pfet_03v3 ad=1.3p pd=5.52u as=1.3p ps=5.52u w=5u l=1u
X242 tp.0.t0 gn.0.t24 fb.0.t17 tp.0.t0 pfet_03v3 ad=1.248p pd=5.32u as=1.248p ps=5.32u w=4.8u l=0.4u
X243 tp.0.t0 gn.0.t16 fb.0.t20 tp.0.t0 pfet_03v3 ad=1.248p pd=5.32u as=1.248p ps=5.32u w=4.8u l=0.4u
X244 VSS.t81 VBN.t9 ts.0.t2 VSS.t80 nfet_03v3 ad=0.65p pd=3.02u as=0.65p ps=3.02u w=2.5u l=1u
X245 VSS.t61 VBN.t21 tn.0.t1 VSS.t60 nfet_03v3 ad=0.65p pd=3.02u as=0.65p ps=3.02u w=2.5u l=1u
X246 tn.0.t42 VREF.t5 oa.0.t25 VSS.t240 nfet_03v3 ad=1.235p pd=5.27u as=1.235p ps=5.27u w=4.75u l=0.5u
X247 fa.0.t38 gp.0.t30 tp.0.t0 tp.0.t0 pfet_03v3 ad=1.248p pd=5.32u as=1.248p ps=5.32u w=4.8u l=0.4u
X248 VDD.t47 VDD.t45 i2.0.t1 VDD.t46 pfet_03v3 ad=1.65p pd=8.38u as=0.975p ps=4.27u w=3.75u l=0.28u
X249 d2a.0.t6 d2b.0.t23 VDD.t74 VDD.t73 pfet_03v3 ad=0.52p pd=2.52u as=0.52p ps=2.52u w=2u l=0.28u
X250 VDD.t80 EN.t3 d2a.0.t4 VDD.t79 pfet_03v3 ad=0.52p pd=2.52u as=0.52p ps=2.52u w=2u l=0.5u
X251 tp.0.t0 gp.0.t17 fa.0.t1 tp.0.t0 pfet_03v3 ad=1.248p pd=5.32u as=1.248p ps=5.32u w=4.8u l=0.4u
X252 ts.0.t7 VBN.t4 VSS.t85 VSS.t84 nfet_03v3 ad=0.65p pd=3.02u as=0.65p ps=3.02u w=2.5u l=1u
X253 VSS.t179 VSS.t177 VSS.t179 VSS.t178 nfet_03v3 ad=0.39p pd=2.02u as=0 ps=0 w=1.5u l=0.28u
X254 VSS.t167 VSS.t165 d2b.0.t3 VSS.t166 nfet_03v3 ad=1.9228p pd=9.62u as=1.1362p ps=4.89u w=4.37u l=0.5u
X255 fb.0.t59 gn.0.t29 tp.0.t0 tp.0.t0 pfet_03v3 ad=1.248p pd=5.32u as=1.248p ps=5.32u w=4.8u l=0.4u
X256 VSS.t128 VSS.t126 tn.0.t24 VSS.t127 nfet_03v3 ad=1.1p pd=5.88u as=0.65p ps=3.02u w=2.5u l=1u
X257 ob.0.t19 VREF.t12 tn.0.t34 VSS.t233 nfet_03v3 ad=1.235p pd=5.27u as=1.235p ps=5.27u w=4.75u l=0.5u
X258 d2a.0.t2 VSS.t156 VSS.t158 VSS.t157 nfet_03v3 ad=1.1362p pd=4.89u as=1.9228p ps=9.62u w=4.37u l=0.5u
X259 tp.0.t0 gn.0.t28 fb.0.t2 tp.0.t0 pfet_03v3 ad=1.248p pd=5.32u as=1.248p ps=5.32u w=4.8u l=0.4u
X260 fa.0.t25 gp.0.t12 tp.0.t0 tp.0.t0 pfet_03v3 ad=1.248p pd=5.32u as=1.248p ps=5.32u w=4.8u l=0.4u
X261 VSS.t35 VBN.t35 fb.0.t8 VSS.t34 nfet_03v3 ad=0.65p pd=3.02u as=0.65p ps=3.02u w=2.5u l=1u
X262 ob.0.t6 gn.0.t1 tn.0.t25 VSS.t192 nfet_03v3 ad=1.235p pd=5.27u as=1.235p ps=5.27u w=4.75u l=0.5u
X263 d2a.0.t11 oa.0.t29 sa.0.t2 VSS.t254 nfet_03v3 ad=1.1362p pd=4.89u as=1.1362p ps=4.89u w=4.37u l=0.5u
X264 i2.0.t5 i1.0.t4 VDD.t187 VDD.t186 pfet_03v3 ad=0.975p pd=4.27u as=0.975p ps=4.27u w=3.75u l=0.28u
X265 VDD.t72 d2b.0.t22 d2a.0.t7 VDD.t71 pfet_03v3 ad=0.52p pd=2.52u as=0.52p ps=2.52u w=2u l=0.28u
X266 VSS.t1 VSS.t2 VSS.t0 ppolyf_u_1k r_width=2u r_length=3.17u
X267 fb.0.t5 VBN.t40 VSS.t21 VSS.t20 nfet_03v3 ad=0.65p pd=3.02u as=0.65p ps=3.02u w=2.5u l=1u
X268 fa.0.t11 VBN.t26 VSS.t47 VSS.t46 nfet_03v3 ad=0.65p pd=3.02u as=0.65p ps=3.02u w=2.5u l=1u
X269 i1.0.t0 VDD.t36 VDD.t38 VDD.t37 pfet_03v3 ad=0.962p pd=4.22u as=1.628p ps=8.28u w=3.7u l=0.28u
X270 tn.0.t6 VBN.t16 VSS.t69 VSS.t68 nfet_03v3 ad=0.65p pd=3.02u as=0.65p ps=3.02u w=2.5u l=1u
X271 VSS.t45 VBN.t29 fa.0.t10 VSS.t44 nfet_03v3 ad=0.65p pd=3.02u as=0.65p ps=3.02u w=2.5u l=1u
X272 tp.0.t0 VREF.t53 fa.0.t46 tp.0.t0 pfet_03v3 ad=1.248p pd=5.32u as=1.248p ps=5.32u w=4.8u l=0.4u
X273 fb.0.t57 gn.0.t21 tp.0.t0 tp.0.t0 pfet_03v3 ad=1.248p pd=5.32u as=1.248p ps=5.32u w=4.8u l=0.4u
X274 fa.0.t16 gp.0.t16 tp.0.t0 tp.0.t0 pfet_03v3 ad=1.248p pd=5.32u as=1.248p ps=5.32u w=4.8u l=0.4u
X275 OUT.t7 i2.0.t10 VSS.t259 VSS.t258 nfet_03v3 ad=1.04p pd=4.52u as=1.04p ps=4.52u w=4u l=0.28u
X276 VDD.t154 VBP.t11 tp.0.t0 VDD.t153 pfet_03v3 ad=1.3p pd=5.52u as=1.3p ps=5.52u w=5u l=1u
X277 VSS.t5 VBN.t45 fa.0.t2 VSS.t4 nfet_03v3 ad=0.65p pd=3.02u as=0.65p ps=3.02u w=2.5u l=1u
X278 tp.0.t0 gn.0.t30 fb.0.t60 tp.0.t0 pfet_03v3 ad=1.248p pd=5.32u as=1.248p ps=5.32u w=4.8u l=0.4u
X279 fa.0.t26 gp.0.t18 tp.0.t0 tp.0.t0 pfet_03v3 ad=1.248p pd=5.32u as=1.248p ps=5.32u w=4.8u l=0.4u
X280 VDD.t189 i2.0.t7 OUT.t4 VDD.t188 pfet_03v3 ad=1.3p pd=5.52u as=1.3p ps=5.52u w=5u l=0.28u
X281 tp.0.t0 VREF.t43 fb.0.t44 tp.0.t0 pfet_03v3 ad=1.248p pd=5.32u as=1.248p ps=5.32u w=4.8u l=0.4u
X282 fb.0.t13 VBN.t24 VSS.t53 VSS.t52 nfet_03v3 ad=0.65p pd=3.02u as=0.65p ps=3.02u w=2.5u l=1u
X283 VDD.t60 d2b.0.t24 d2a.0.t5 VDD.t59 pfet_03v3 ad=0.52p pd=2.52u as=0.52p ps=2.52u w=2u l=0.28u
X284 VSS.t103 VSS.t104 VSS.t102 ppolyf_u_1k r_width=2u r_length=9.11u
X285 fa.0.t47 VREF.t50 tp.0.t0 tp.0.t0 pfet_03v3 ad=1.248p pd=5.32u as=1.248p ps=5.32u w=4.8u l=0.4u
X286 ob.0.t14 gn.0.t5 tn.0.t26 VSS.t209 nfet_03v3 ad=1.235p pd=5.27u as=1.235p ps=5.27u w=4.75u l=0.5u
X287 oa.0.t7 gp.0.t6 tn.0.t18 VSS.t109 nfet_03v3 ad=1.235p pd=5.27u as=1.235p ps=5.27u w=4.75u l=0.5u
X288 VSS.t191 VSS.t189 OUT.t9 VSS.t190 nfet_03v3 ad=1.76p pd=8.88u as=1.04p ps=4.52u w=4u l=0.28u
X289 VDD.t35 VDD.t33 nd.0.t1 VDD.t34 pfet_03v3 ad=1.32p pd=6.88u as=0.78p ps=3.52u w=3u l=0.28u
X290 tp.0.t0 gp.0.t29 fa.0.t22 tp.0.t0 pfet_03v3 ad=1.248p pd=5.32u as=1.248p ps=5.32u w=4.8u l=0.4u
X291 VSS.t155 VSS.t153 ts.0.t14 VSS.t154 nfet_03v3 ad=1.1p pd=5.88u as=0.65p ps=3.02u w=2.5u l=1u
X292 VDD.t134 VBP.t21 tp.0.t0 VDD.t133 pfet_03v3 ad=1.3p pd=5.52u as=1.3p ps=5.52u w=5u l=1u
X293 tp.0.t0 gp.0.t11 fa.0.t15 tp.0.t0 pfet_03v3 ad=1.248p pd=5.32u as=1.248p ps=5.32u w=4.8u l=0.4u
X294 VDD.t150 VBP.t13 tp.0.t0 VDD.t149 pfet_03v3 ad=1.3p pd=5.52u as=1.3p ps=5.52u w=5u l=1u
X295 d2b.0.t5 d2a.0.t22 VDD.t88 VDD.t87 pfet_03v3 ad=0.52p pd=2.52u as=0.52p ps=2.52u w=2u l=0.28u
X296 d2a.0.t13 d2a.0.t12 VDD.t86 VDD.t85 pfet_03v3 ad=0.52p pd=2.52u as=0.52p ps=2.52u w=2u l=0.28u
X297 fb.0.t41 VREF.t48 tp.0.t0 tp.0.t0 pfet_03v3 ad=1.248p pd=5.32u as=1.248p ps=5.32u w=4.8u l=0.4u
X298 oa.0.t2 gp.0.t2 tn.0.t12 VSS.t99 nfet_03v3 ad=1.235p pd=5.27u as=1.235p ps=5.27u w=4.75u l=0.5u
X299 d2a.0.t8 d2b.0.t21 VDD.t70 VDD.t69 pfet_03v3 ad=0.52p pd=2.52u as=0.52p ps=2.52u w=2u l=0.28u
X300 VDD.t66 d2b.0.t27 d3.0.t2 VDD.t65 pfet_03v3 ad=0.52p pd=2.52u as=0.52p ps=2.52u w=2u l=0.28u
X301 tp.0.t0 VBP.t18 VDD.t140 VDD.t139 pfet_03v3 ad=1.3p pd=5.52u as=1.3p ps=5.52u w=5u l=1u
X302 tp.0.t0 VBP.t2 VDD.t172 VDD.t171 pfet_03v3 ad=1.3p pd=5.52u as=1.3p ps=5.52u w=5u l=1u
X303 fa.0.t30 VB2.t13 oa.0.t10 VSS.t195 nfet_03v3 ad=1.1752p pd=5.04u as=1.1752p ps=5.04u w=4.52u l=0.5u
X304 VSS.t250 n3a.0.t14 d3.0.t4 VSS.t249 nfet_03v3 ad=0.6734p pd=3.11u as=0.6734p ps=3.11u w=2.59u l=0.28u
X305 tp.0.t0 gp.0.t21 fa.0.t37 tp.0.t0 pfet_03v3 ad=1.248p pd=5.32u as=1.248p ps=5.32u w=4.8u l=0.4u
X306 fa.0.t32 VB2.t11 oa.0.t12 VSS.t197 nfet_03v3 ad=1.1752p pd=5.04u as=1.1752p ps=5.04u w=4.52u l=0.5u
X307 VDD.t128 d2a.0.t18 d2a.0.t19 VDD.t127 pfet_03v3 ad=0.52p pd=2.52u as=0.52p ps=2.52u w=2u l=0.28u
X308 ob.0.t10 VB2.t1 fb.0.t30 VSS.t207 nfet_03v3 ad=1.1752p pd=5.04u as=1.1752p ps=5.04u w=4.52u l=0.5u
X309 VDD.t132 d2a.0.t21 d2b.0.t19 VDD.t131 pfet_03v3 ad=0.52p pd=2.52u as=0.52p ps=2.52u w=2u l=0.28u
X310 n3a.0.t4 d2a.0.t27 VDD.t99 VDD.t98 pfet_03v3 ad=0.52p pd=2.52u as=0.52p ps=2.52u w=2u l=0.28u
X311 VSS.t43 VBN.t31 fb.0.t10 VSS.t42 nfet_03v3 ad=0.65p pd=3.02u as=0.65p ps=3.02u w=2.5u l=1u
X312 ts.0.t5 VBN.t6 VSS.t89 VSS.t88 nfet_03v3 ad=0.65p pd=3.02u as=0.65p ps=3.02u w=2.5u l=1u
X313 tp.0.t0 VBP.t16 VDD.t144 VDD.t143 pfet_03v3 ad=1.3p pd=5.52u as=1.3p ps=5.52u w=5u l=1u
X314 fa.0.t51 VREF.t42 tp.0.t0 tp.0.t0 pfet_03v3 ad=1.248p pd=5.32u as=1.248p ps=5.32u w=4.8u l=0.4u
X315 fb.0.t39 VREF.t52 tp.0.t0 tp.0.t0 pfet_03v3 ad=1.248p pd=5.32u as=1.248p ps=5.32u w=4.8u l=0.4u
X316 VSS.t170 VSS.t168 VSS.t170 VSS.t169 nfet_03v3 ad=0.6734p pd=3.11u as=0 ps=0 w=2.59u l=0.28u
X317 tp.0.t0 VREF.t51 fb.0.t40 tp.0.t0 pfet_03v3 ad=1.248p pd=5.32u as=1.248p ps=5.32u w=4.8u l=0.4u
X318 tp.0.t0 VREF.t31 fb.0.t50 tp.0.t0 pfet_03v3 ad=1.248p pd=5.32u as=1.248p ps=5.32u w=4.8u l=0.4u
X319 fa.0.t57 VREF.t30 tp.0.t0 tp.0.t0 pfet_03v3 ad=1.248p pd=5.32u as=1.248p ps=5.32u w=4.8u l=0.4u
X320 oa.0.t18 VREF.t18 tn.0.t43 VSS.t227 nfet_03v3 ad=1.235p pd=5.27u as=1.235p ps=5.27u w=4.75u l=0.5u
X321 d2a.0.t17 d2a.0.t16 VDD.t117 VDD.t116 pfet_03v3 ad=0.52p pd=2.52u as=0.52p ps=2.52u w=2u l=0.28u
X322 n3a.0.t8 d2a.0.t31 VDD.t124 VDD.t123 pfet_03v3 ad=0.52p pd=2.52u as=0.52p ps=2.52u w=2u l=0.28u
R0 OUT.n6 OUT 9.0005
R1 OUT.n2 OUT 9.0005
R2 OUT.n7 OUT 5.04371
R3 OUT OUT.n7 2.23121
R4 OUT.n7 OUT 1.78121
R5 OUT OUT.n6 0.93425
R6 OUT OUT.n1 0.879957
R7 OUT OUT.n0 0.879957
R8 OUT OUT.n2 0.698
R9 OUT OUT.n5 0.612457
R10 OUT OUT.n4 0.612457
R11 OUT OUT.n3 0.612457
R12 OUT.n6 OUT 0.476214
R13 OUT.n1 OUT.t0 0.41
R14 OUT.n1 OUT.t8 0.41
R15 OUT.n0 OUT.t9 0.41
R16 OUT.n0 OUT.t7 0.41
R17 OUT.n5 OUT.t6 0.3645
R18 OUT.n5 OUT.t2 0.3645
R19 OUT.n4 OUT.t4 0.3645
R20 OUT.n4 OUT.t5 0.3645
R21 OUT.n3 OUT.t1 0.3645
R22 OUT.n3 OUT.t3 0.3645
R23 OUT.n2 OUT 0.238357
R24 EN EN.t0 54.0878
R25 EN EN.t1 40.9915
R26 EN EN.t3 27.4653
R27 EN EN.t2 27.4653
R28 EN.n0 EN 10.1384
R29 EN EN.n2 8.30621
R30 EN.n0 EN 6.05621
R31 EN.n2 EN.n1 4.5005
R32 EN.n2 EN.n0 4.23693
R33 EN.n1 EN 1.44371
R34 EN.n1 EN 1.21871
R35 VBN.n33 VBN.t22 17.1092
R36 VBN.n23 VBN.t12 15.9196
R37 VBN.n11 VBN.t44 15.9196
R38 VBN.n0 VBN.t11 15.9196
R39 VBN.n22 VBN 15.3551
R40 VBN.n31 VBN.t21 15.3248
R41 VBN.n30 VBN.t20 15.3248
R42 VBN.n29 VBN.t19 15.3248
R43 VBN.n28 VBN.t18 15.3248
R44 VBN.n27 VBN.t17 15.3248
R45 VBN.n26 VBN.t16 15.3248
R46 VBN.n25 VBN.t15 15.3248
R47 VBN.n24 VBN.t14 15.3248
R48 VBN.n23 VBN.t13 15.3248
R49 VBN.n43 VBN.t45 15.3248
R50 VBN.n42 VBN.t42 15.3248
R51 VBN.n41 VBN.t41 15.3248
R52 VBN.n40 VBN.t38 15.3248
R53 VBN.n39 VBN.t37 15.3248
R54 VBN.n38 VBN.t34 15.3248
R55 VBN.n37 VBN.t33 15.3248
R56 VBN.n36 VBN.t30 15.3248
R57 VBN.n35 VBN.t29 15.3248
R58 VBN.n34 VBN.t26 15.3248
R59 VBN.n33 VBN.t25 15.3248
R60 VBN.n21 VBN.t23 15.3248
R61 VBN.n20 VBN.t24 15.3248
R62 VBN.n19 VBN.t27 15.3248
R63 VBN.n18 VBN.t28 15.3248
R64 VBN.n17 VBN.t31 15.3248
R65 VBN.n16 VBN.t32 15.3248
R66 VBN.n15 VBN.t35 15.3248
R67 VBN.n14 VBN.t36 15.3248
R68 VBN.n13 VBN.t39 15.3248
R69 VBN.n12 VBN.t40 15.3248
R70 VBN.n11 VBN.t43 15.3248
R71 VBN.n0 VBN.t10 15.3248
R72 VBN.n1 VBN.t9 15.3248
R73 VBN.n2 VBN.t8 15.3248
R74 VBN.n3 VBN.t7 15.3248
R75 VBN.n4 VBN.t6 15.3248
R76 VBN.n5 VBN.t5 15.3248
R77 VBN.n6 VBN.t4 15.3248
R78 VBN.n7 VBN.t3 15.3248
R79 VBN.n8 VBN.t2 15.3248
R80 VBN.n9 VBN.t1 15.3248
R81 VBN.n10 VBN.t0 15.3248
R82 VBN VBN.n21 10.9238
R83 VBN VBN.n31 10.329
R84 VBN VBN.n43 10.329
R85 VBN VBN.n10 10.329
R86 VBN.n44 VBN.n32 8.96193
R87 VBN VBN.n22 8.08121
R88 VBN VBN.n44 8.08121
R89 VBN.n32 VBN 5.63836
R90 VBN.n32 VBN 5.49371
R91 VBN.n44 VBN 5.49371
R92 VBN.n22 VBN 4.81871
R93 VBN.n35 VBN.n34 1.78485
R94 VBN.n37 VBN.n36 1.78485
R95 VBN.n41 VBN.n40 1.78485
R96 VBN.n43 VBN.n42 1.78485
R97 VBN.n20 VBN.n19 1.78485
R98 VBN.n18 VBN.n17 1.78485
R99 VBN.n16 VBN.n15 1.78485
R100 VBN.n14 VBN.n13 1.78485
R101 VBN.n12 VBN.n11 1.78485
R102 VBN.n39 VBN 1.38376
R103 VBN.n24 VBN.n23 0.595283
R104 VBN.n25 VBN.n24 0.595283
R105 VBN.n26 VBN.n25 0.595283
R106 VBN.n27 VBN.n26 0.595283
R107 VBN.n29 VBN.n28 0.595283
R108 VBN.n30 VBN.n29 0.595283
R109 VBN.n31 VBN.n30 0.595283
R110 VBN.n34 VBN.n33 0.595283
R111 VBN.n36 VBN.n35 0.595283
R112 VBN.n38 VBN.n37 0.595283
R113 VBN.n40 VBN.n39 0.595283
R114 VBN.n42 VBN.n41 0.595283
R115 VBN.n21 VBN.n20 0.595283
R116 VBN.n19 VBN.n18 0.595283
R117 VBN.n15 VBN.n14 0.595283
R118 VBN.n13 VBN.n12 0.595283
R119 VBN.n10 VBN.n9 0.595283
R120 VBN.n9 VBN.n8 0.595283
R121 VBN.n8 VBN.n7 0.595283
R122 VBN.n7 VBN.n6 0.595283
R123 VBN.n5 VBN.n4 0.595283
R124 VBN.n4 VBN.n3 0.595283
R125 VBN.n3 VBN.n2 0.595283
R126 VBN.n2 VBN.n1 0.595283
R127 VBN.n1 VBN.n0 0.595283
R128 VBN.n17 VBN 0.491587
R129 VBN VBN.n38 0.401587
R130 VBN VBN.n27 0.39963
R131 VBN VBN.n5 0.39963
R132 VBN.n28 VBN 0.196152
R133 VBN.n6 VBN 0.196152
R134 VBN VBN.n16 0.104196
R135 VB2.n6 VB2.t7 45.65
R136 VB2.n0 VB2.t6 45.65
R137 VB2.n11 VB2.t13 45.2508
R138 VB2.n10 VB2.t12 45.2508
R139 VB2.n9 VB2.t11 45.2508
R140 VB2.n8 VB2.t10 45.2508
R141 VB2.n7 VB2.t9 45.2508
R142 VB2.n6 VB2.t8 45.2508
R143 VB2.n0 VB2.t5 45.2508
R144 VB2.n1 VB2.t4 45.2508
R145 VB2.n2 VB2.t3 45.2508
R146 VB2.n3 VB2.t2 45.2508
R147 VB2.n4 VB2.t1 45.2508
R148 VB2.n5 VB2.t0 45.2508
R149 VB2 VB2.n12 13.7062
R150 VB2 VB2.n11 10.0355
R151 VB2 VB2.n5 10.0355
R152 VB2.n12 VB2 9.01336
R153 VB2.n12 VB2 4.81871
R154 VB2.n7 VB2.n6 0.39963
R155 VB2.n8 VB2.n7 0.39963
R156 VB2.n9 VB2.n8 0.39963
R157 VB2.n11 VB2.n10 0.39963
R158 VB2.n5 VB2.n4 0.39963
R159 VB2.n3 VB2.n2 0.39963
R160 VB2.n2 VB2.n1 0.39963
R161 VB2.n1 VB2.n0 0.39963
R162 VB2.n10 VB2 0.248978
R163 VB2.n4 VB2 0.248978
R164 VB2 VB2.n9 0.151152
R165 VB2 VB2.n3 0.151152
R166 VREF.n31 VREF.t44 57.4425
R167 VREF.n0 VREF.t43 57.4425
R168 VREF.n49 VREF.t63 57.0825
R169 VREF.n48 VREF.t62 57.0825
R170 VREF.n47 VREF.t61 57.0825
R171 VREF.n46 VREF.t60 57.0825
R172 VREF.n45 VREF.t59 57.0825
R173 VREF.n44 VREF.t58 57.0825
R174 VREF.n43 VREF.t57 57.0825
R175 VREF.n42 VREF.t56 57.0825
R176 VREF.n41 VREF.t55 57.0825
R177 VREF.n40 VREF.t54 57.0825
R178 VREF.n39 VREF.t53 57.0825
R179 VREF.n38 VREF.t52 57.0825
R180 VREF.n37 VREF.t51 57.0825
R181 VREF.n36 VREF.t50 57.0825
R182 VREF.n35 VREF.t49 57.0825
R183 VREF.n34 VREF.t48 57.0825
R184 VREF.n33 VREF.t47 57.0825
R185 VREF.n32 VREF.t46 57.0825
R186 VREF.n31 VREF.t45 57.0825
R187 VREF.n22 VREF.t20 57.0825
R188 VREF.n21 VREF.t21 57.0825
R189 VREF.n20 VREF.t22 57.0825
R190 VREF.n19 VREF.t23 57.0825
R191 VREF.n18 VREF.t24 57.0825
R192 VREF.n17 VREF.t25 57.0825
R193 VREF.n16 VREF.t26 57.0825
R194 VREF.n15 VREF.t27 57.0825
R195 VREF.n14 VREF.t28 57.0825
R196 VREF.n13 VREF.t29 57.0825
R197 VREF.n12 VREF.t30 57.0825
R198 VREF.n11 VREF.t31 57.0825
R199 VREF.n10 VREF.t32 57.0825
R200 VREF.n9 VREF.t33 57.0825
R201 VREF.n8 VREF.t34 57.0825
R202 VREF.n7 VREF.t35 57.0825
R203 VREF.n6 VREF.t36 57.0825
R204 VREF.n5 VREF.t37 57.0825
R205 VREF.n4 VREF.t38 57.0825
R206 VREF.n3 VREF.t39 57.0825
R207 VREF.n2 VREF.t40 57.0825
R208 VREF.n1 VREF.t41 57.0825
R209 VREF.n0 VREF.t42 57.0825
R210 VREF.n51 VREF.t8 47.329
R211 VREF.n23 VREF.t7 47.329
R212 VREF.n61 VREF.t19 46.9298
R213 VREF.n60 VREF.t18 46.9298
R214 VREF.n59 VREF.t17 46.9298
R215 VREF.n58 VREF.t16 46.9298
R216 VREF.n57 VREF.t15 46.9298
R217 VREF.n56 VREF.t14 46.9298
R218 VREF.n55 VREF.t13 46.9298
R219 VREF.n54 VREF.t12 46.9298
R220 VREF.n53 VREF.t11 46.9298
R221 VREF.n52 VREF.t10 46.9298
R222 VREF.n51 VREF.t9 46.9298
R223 VREF.n29 VREF.t0 46.9298
R224 VREF.n28 VREF.t1 46.9298
R225 VREF.n27 VREF.t2 46.9298
R226 VREF.n26 VREF.t3 46.9298
R227 VREF.n25 VREF.t4 46.9298
R228 VREF.n24 VREF.t5 46.9298
R229 VREF.n23 VREF.t6 46.9298
R230 VREF.n30 VREF 11.0801
R231 VREF VREF.n49 9.73811
R232 VREF VREF.n22 9.73811
R233 VREF VREF.n61 9.63637
R234 VREF VREF.n29 9.63637
R235 VREF.n30 VREF 8.86871
R236 VREF.n50 VREF 7.88836
R237 VREF.n62 VREF 7.85621
R238 VREF VREF.n30 7.85621
R239 VREF VREF.n62 7.85621
R240 VREF.n62 VREF.n50 6.93693
R241 VREF.n50 VREF 5.83121
R242 VREF.n52 VREF.n51 0.39963
R243 VREF.n53 VREF.n52 0.39963
R244 VREF.n54 VREF.n53 0.39963
R245 VREF.n55 VREF.n54 0.39963
R246 VREF.n56 VREF.n55 0.39963
R247 VREF.n58 VREF.n57 0.39963
R248 VREF.n59 VREF.n58 0.39963
R249 VREF.n60 VREF.n59 0.39963
R250 VREF.n61 VREF.n60 0.39963
R251 VREF.n29 VREF.n28 0.39963
R252 VREF.n28 VREF.n27 0.39963
R253 VREF.n26 VREF.n25 0.39963
R254 VREF.n25 VREF.n24 0.39963
R255 VREF.n24 VREF.n23 0.39963
R256 VREF.n32 VREF.n31 0.3605
R257 VREF.n33 VREF.n32 0.3605
R258 VREF.n34 VREF.n33 0.3605
R259 VREF.n35 VREF.n34 0.3605
R260 VREF.n36 VREF.n35 0.3605
R261 VREF.n37 VREF.n36 0.3605
R262 VREF.n38 VREF.n37 0.3605
R263 VREF.n39 VREF.n38 0.3605
R264 VREF.n40 VREF.n39 0.3605
R265 VREF.n42 VREF.n41 0.3605
R266 VREF.n43 VREF.n42 0.3605
R267 VREF.n44 VREF.n43 0.3605
R268 VREF.n45 VREF.n44 0.3605
R269 VREF.n46 VREF.n45 0.3605
R270 VREF.n47 VREF.n46 0.3605
R271 VREF.n48 VREF.n47 0.3605
R272 VREF.n49 VREF.n48 0.3605
R273 VREF.n22 VREF.n21 0.3605
R274 VREF.n21 VREF.n20 0.3605
R275 VREF.n20 VREF.n19 0.3605
R276 VREF.n19 VREF.n18 0.3605
R277 VREF.n18 VREF.n17 0.3605
R278 VREF.n17 VREF.n16 0.3605
R279 VREF.n16 VREF.n15 0.3605
R280 VREF.n15 VREF.n14 0.3605
R281 VREF.n14 VREF.n13 0.3605
R282 VREF.n13 VREF.n12 0.3605
R283 VREF.n11 VREF.n10 0.3605
R284 VREF.n10 VREF.n9 0.3605
R285 VREF.n9 VREF.n8 0.3605
R286 VREF.n8 VREF.n7 0.3605
R287 VREF.n7 VREF.n6 0.3605
R288 VREF.n6 VREF.n5 0.3605
R289 VREF.n5 VREF.n4 0.3605
R290 VREF.n4 VREF.n3 0.3605
R291 VREF.n3 VREF.n2 0.3605
R292 VREF.n2 VREF.n1 0.3605
R293 VREF.n1 VREF.n0 0.3605
R294 VREF.n57 VREF 0.247022
R295 VREF.n27 VREF 0.247022
R296 VREF VREF.n11 0.223543
R297 VREF VREF.n40 0.221587
R298 VREF VREF.n56 0.153109
R299 VREF VREF.n26 0.153109
R300 VREF.n41 VREF 0.139413
R301 VREF.n12 VREF 0.137457
R302 INN INN.t0 1.2823
R303 VBP.n0 VBP.t0 25.0446
R304 VBP.n20 VBP.t21 24.4498
R305 VBP.n19 VBP.t20 24.4498
R306 VBP.n18 VBP.t19 24.4498
R307 VBP.n17 VBP.t18 24.4498
R308 VBP.n16 VBP.t17 24.4498
R309 VBP.n15 VBP.t16 24.4498
R310 VBP.n14 VBP.t15 24.4498
R311 VBP.n13 VBP.t14 24.4498
R312 VBP.n12 VBP.t13 24.4498
R313 VBP.n11 VBP.t12 24.4498
R314 VBP.n10 VBP.t11 24.4498
R315 VBP.n9 VBP.t10 24.4498
R316 VBP.n8 VBP.t9 24.4498
R317 VBP.n7 VBP.t8 24.4498
R318 VBP.n6 VBP.t7 24.4498
R319 VBP.n5 VBP.t6 24.4498
R320 VBP.n4 VBP.t5 24.4498
R321 VBP.n3 VBP.t4 24.4498
R322 VBP.n2 VBP.t3 24.4498
R323 VBP.n1 VBP.t2 24.4498
R324 VBP.n0 VBP.t1 24.4498
R325 VBP.n21 VBP 15.5384
R326 VBP VBP.n20 10.4503
R327 VBP VBP.n21 7.18121
R328 VBP.n21 VBP 4.70621
R329 VBP.n1 VBP.n0 0.595283
R330 VBP.n2 VBP.n1 0.595283
R331 VBP.n3 VBP.n2 0.595283
R332 VBP.n4 VBP.n3 0.595283
R333 VBP.n5 VBP.n4 0.595283
R334 VBP.n6 VBP.n5 0.595283
R335 VBP.n7 VBP.n6 0.595283
R336 VBP.n8 VBP.n7 0.595283
R337 VBP.n9 VBP.n8 0.595283
R338 VBP.n10 VBP.n9 0.595283
R339 VBP.n12 VBP.n11 0.595283
R340 VBP.n13 VBP.n12 0.595283
R341 VBP.n14 VBP.n13 0.595283
R342 VBP.n15 VBP.n14 0.595283
R343 VBP.n16 VBP.n15 0.595283
R344 VBP.n17 VBP.n16 0.595283
R345 VBP.n18 VBP.n17 0.595283
R346 VBP.n19 VBP.n18 0.595283
R347 VBP.n20 VBP.n19 0.595283
R348 VBP VBP.n10 0.462239
R349 VBP.n11 VBP 0.133543
R350 INP INP.t0 1.2823
R351 VDD.n95 VDD.t1 490.897
R352 VDD.t16 VDD.n94 490.897
R353 VDD.t28 VDD.n33 490.897
R354 VDD.t25 VDD.n34 490.897
R355 VDD.n60 VDD.t4 472.923
R356 VDD.t7 VDD.n54 472.923
R357 VDD.t22 VDD.n117 472.923
R358 VDD.t19 VDD.n118 472.923
R359 VDD.n245 VDD.n4 434.175
R360 VDD.n243 VDD.n4 434.175
R361 VDD.n245 VDD.n5 434.175
R362 VDD.n243 VDD.n5 434.175
R363 VDD.n87 VDD.t34 406.473
R364 VDD.t31 VDD.n85 406.473
R365 VDD.n108 VDD.t40 370.091
R366 VDD.t37 VDD.n107 370.091
R367 VDD.n151 VDD.t46 367.702
R368 VDD.t43 VDD.n149 367.702
R369 VDD.t13 VDD.n4 356.781
R370 VDD.t10 VDD.n5 356.781
R371 VDD.t52 VDD.n23 317.307
R372 VDD.t49 VDD.n24 317.307
R373 VDD.n138 VDD.n118 228.726
R374 VDD.n140 VDD.n118 228.726
R375 VDD.n140 VDD.n117 228.726
R376 VDD.n138 VDD.n117 228.726
R377 VDD.n57 VDD.n54 214.726
R378 VDD.n58 VDD.n54 214.726
R379 VDD.n60 VDD.n58 214.726
R380 VDD.n60 VDD.n57 214.726
R381 VDD.t1 VDD.t79 166.667
R382 VDD.t79 VDD.t16 166.667
R383 VDD.t83 VDD.t28 166.667
R384 VDD.t83 VDD.t25 166.667
R385 VDD.t175 VDD.t13 166.667
R386 VDD.t173 VDD.t175 166.667
R387 VDD.t171 VDD.t173 166.667
R388 VDD.t169 VDD.t171 166.667
R389 VDD.t167 VDD.t169 166.667
R390 VDD.t165 VDD.t167 166.667
R391 VDD.t163 VDD.t165 166.667
R392 VDD.t161 VDD.t163 166.667
R393 VDD.t159 VDD.t161 166.667
R394 VDD.t157 VDD.t159 166.667
R395 VDD.t155 VDD.t157 166.667
R396 VDD.t153 VDD.t151 166.667
R397 VDD.t151 VDD.t149 166.667
R398 VDD.t149 VDD.t147 166.667
R399 VDD.t147 VDD.t145 166.667
R400 VDD.t145 VDD.t143 166.667
R401 VDD.t143 VDD.t141 166.667
R402 VDD.t141 VDD.t139 166.667
R403 VDD.t139 VDD.t137 166.667
R404 VDD.t137 VDD.t135 166.667
R405 VDD.t135 VDD.t133 166.667
R406 VDD.t133 VDD.t10 166.667
R407 VDD.n172 VDD.n24 156.976
R408 VDD.n170 VDD.n24 156.976
R409 VDD.n170 VDD.n23 156.976
R410 VDD.n172 VDD.n23 156.976
R411 VDD.n151 VDD.n146 132.038
R412 VDD.n151 VDD.n148 132.038
R413 VDD.n149 VDD.n146 132.038
R414 VDD.n149 VDD.n148 132.038
R415 VDD.t4 VDD.t93 130.72
R416 VDD.t93 VDD.t61 130.72
R417 VDD.t61 VDD.t63 130.72
R418 VDD.t63 VDD.t96 130.72
R419 VDD.t96 VDD.t98 130.72
R420 VDD.t98 VDD.t65 130.72
R421 VDD.t65 VDD.t178 130.72
R422 VDD.t178 VDD.t100 130.72
R423 VDD.t102 VDD.t180 130.72
R424 VDD.t180 VDD.t182 130.72
R425 VDD.t182 VDD.t121 130.72
R426 VDD.t121 VDD.t123 130.72
R427 VDD.t123 VDD.t184 130.72
R428 VDD.t184 VDD.t104 130.72
R429 VDD.t104 VDD.t125 130.72
R430 VDD.t125 VDD.t7 130.72
R431 VDD.t129 VDD.t22 130.72
R432 VDD.t127 VDD.t129 130.72
R433 VDD.t116 VDD.t127 130.72
R434 VDD.t77 VDD.t116 130.72
R435 VDD.t75 VDD.t77 130.72
R436 VDD.t67 VDD.t75 130.72
R437 VDD.t69 VDD.t67 130.72
R438 VDD.t131 VDD.t69 130.72
R439 VDD.t87 VDD.t131 130.72
R440 VDD.t89 VDD.t91 130.72
R441 VDD.t91 VDD.t71 130.72
R442 VDD.t71 VDD.t73 130.72
R443 VDD.t73 VDD.t110 130.72
R444 VDD.t110 VDD.t108 130.72
R445 VDD.t108 VDD.t114 130.72
R446 VDD.t114 VDD.t85 130.72
R447 VDD.t85 VDD.t59 130.72
R448 VDD.t59 VDD.t19 130.72
R449 VDD.n87 VDD.n50 125.475
R450 VDD.n87 VDD.n51 125.475
R451 VDD.n85 VDD.n50 125.475
R452 VDD.n85 VDD.n51 125.475
R453 VDD.n108 VDD.n104 124.6
R454 VDD.n108 VDD.n106 124.6
R455 VDD.n107 VDD.n104 124.6
R456 VDD.n107 VDD.n106 124.6
R457 VDD.n227 VDD.n221 120.862
R458 VDD.n225 VDD.n224 120.862
R459 VDD.n190 VDD.n184 120.862
R460 VDD.n187 VDD.n185 120.862
R461 VDD.n95 VDD.n43 115.501
R462 VDD.n95 VDD.n44 115.501
R463 VDD.n94 VDD.n43 115.501
R464 VDD.n94 VDD.n44 115.501
R465 VDD.n162 VDD.n33 115.501
R466 VDD.n163 VDD.n33 115.501
R467 VDD.n162 VDD.n34 115.501
R468 VDD.n163 VDD.n34 115.501
R469 VDD.t34 VDD.t81 112.361
R470 VDD.t112 VDD.t31 112.361
R471 VDD.n234 VDD.n229 106.576
R472 VDD.n232 VDD.n231 106.576
R473 VDD.n13 VDD.n8 106.576
R474 VDD.n10 VDD.n9 106.576
R475 VDD.n224 VDD.n223 102.594
R476 VDD.n227 VDD.n226 102.594
R477 VDD.n188 VDD.n184 102.594
R478 VDD.n189 VDD.n185 102.594
R479 VDD.t40 VDD.t106 102.302
R480 VDD.t106 VDD.t37 102.302
R481 VDD.t46 VDD.t186 101.653
R482 VDD.t57 VDD.t43 101.653
R483 VDD.n231 VDD.n230 91.2621
R484 VDD.n234 VDD.n233 91.2621
R485 VDD.n11 VDD.n8 91.2621
R486 VDD.n12 VDD.n9 91.2621
R487 VDD.t119 VDD.t52 87.7198
R488 VDD.t188 VDD.t119 87.7198
R489 VDD.t190 VDD.t192 87.7198
R490 VDD.t192 VDD.t49 87.7198
R491 VDD.n244 VDD.t155 83.3338
R492 VDD.n244 VDD.t153 83.3338
R493 VDD.n25 VDD.t51 80.6719
R494 VDD.n169 VDD.t48 80.6719
R495 VDD.t100 VDD.n59 65.36
R496 VDD.n59 VDD.t102 65.36
R497 VDD.n139 VDD.t87 65.36
R498 VDD.n139 VDD.t89 65.36
R499 VDD.n147 VDD.t42 64.3772
R500 VDD.n145 VDD.t45 64.3772
R501 VDD.n105 VDD.t36 63.7254
R502 VDD.n103 VDD.t39 63.7254
R503 VDD.t81 VDD.n86 56.1803
R504 VDD.n86 VDD.t112 56.1803
R505 VDD.n84 VDD.t30 54.6004
R506 VDD.n49 VDD.t33 54.6004
R507 VDD.t186 VDD.n150 50.8264
R508 VDD.n150 VDD.t57 50.8264
R509 VDD.n171 VDD.t188 43.8601
R510 VDD.n171 VDD.t190 43.8601
R511 VDD.n55 VDD.t3 41.5647
R512 VDD.n78 VDD.t6 41.5647
R513 VDD.n119 VDD.t21 41.5647
R514 VDD.n120 VDD.t18 41.5647
R515 VDD.n42 VDD.t0 27.9583
R516 VDD.n93 VDD.t15 27.9583
R517 VDD.n31 VDD.t27 27.9583
R518 VDD.n160 VDD.t24 27.9583
R519 VDD.n242 VDD.t9 25.6511
R520 VDD.n6 VDD.t12 25.6511
R521 VDD.n236 VDD 11.093
R522 VDD.n181 VDD 11.093
R523 VDD.n237 VDD 10.5659
R524 VDD.n192 VDD 10.5659
R525 VDD.n62 VDD 9.47621
R526 VDD VDD.n137 9.47621
R527 VDD.n122 VDD 9.47621
R528 VDD.n27 VDD 9.47621
R529 VDD.n37 VDD 9.28978
R530 VDD.n62 VDD 9.0005
R531 VDD.n64 VDD 9.0005
R532 VDD.n66 VDD 9.0005
R533 VDD.n68 VDD 9.0005
R534 VDD.n70 VDD 9.0005
R535 VDD.n72 VDD 9.0005
R536 VDD.n74 VDD 9.0005
R537 VDD.n76 VDD 9.0005
R538 VDD VDD.n77 9.0005
R539 VDD VDD.n41 9.0005
R540 VDD.n98 VDD 9.0005
R541 VDD.n122 VDD 9.0005
R542 VDD.n124 VDD 9.0005
R543 VDD.n126 VDD 9.0005
R544 VDD.n128 VDD 9.0005
R545 VDD.n131 VDD 9.0005
R546 VDD.n133 VDD 9.0005
R547 VDD.n135 VDD 9.0005
R548 VDD.n137 VDD 9.0005
R549 VDD.n37 VDD 9.0005
R550 VDD VDD.n159 9.0005
R551 VDD.n89 VDD 9.0005
R552 VDD.n111 VDD 9.0005
R553 VDD VDD.n101 9.0005
R554 VDD.n153 VDD 9.0005
R555 VDD.n29 VDD 9.0005
R556 VDD.n27 VDD 9.0005
R557 VDD VDD.n167 9.0005
R558 VDD.n198 VDD 9.0005
R559 VDD.n200 VDD 9.0005
R560 VDD.n202 VDD 9.0005
R561 VDD.n204 VDD 9.0005
R562 VDD.n206 VDD 9.0005
R563 VDD.n209 VDD 9.0005
R564 VDD.n211 VDD 9.0005
R565 VDD.n213 VDD 9.0005
R566 VDD.n215 VDD 9.0005
R567 VDD.n217 VDD 9.0005
R568 VDD VDD.n240 9.0005
R569 VDD.n196 VDD 9.0005
R570 VDD VDD.n14 5.76371
R571 VDD.n15 VDD 5.76371
R572 VDD VDD.n166 5.60621
R573 VDD.n90 VDD 5.49371
R574 VDD VDD.n100 5.49371
R575 VDD VDD.n30 5.49371
R576 VDD VDD.n6 5.358
R577 VDD VDD.n242 5.358
R578 VDD.n16 VDD 5.3105
R579 VDD.n99 VDD 5.26871
R580 VDD VDD.n158 5.26871
R581 VDD VDD.n239 5.26871
R582 VDD VDD.n194 5.26871
R583 VDD.n80 VDD 5.25017
R584 VDD VDD.n81 5.13693
R585 VDD VDD.n47 5.13693
R586 VDD.n114 VDD 5.13693
R587 VDD VDD.n39 5.13693
R588 VDD.n157 VDD 5.13693
R589 VDD VDD.n143 5.13693
R590 VDD VDD.n20 5.13693
R591 VDD.n174 VDD 5.13693
R592 VDD.n80 VDD 4.93121
R593 VDD VDD.n53 4.93121
R594 VDD VDD.n91 4.93121
R595 VDD VDD.n40 4.93121
R596 VDD VDD.n115 4.93121
R597 VDD.n142 VDD 4.93121
R598 VDD.n38 VDD 4.93121
R599 VDD.n165 VDD 4.93121
R600 VDD VDD.n218 4.85086
R601 VDD VDD.n235 4.85086
R602 VDD.n236 VDD 4.85086
R603 VDD VDD.n237 4.85086
R604 VDD.n238 VDD 4.85086
R605 VDD VDD.n1 4.85086
R606 VDD VDD.n0 4.85086
R607 VDD VDD.n7 4.85086
R608 VDD.n193 VDD 4.85086
R609 VDD VDD.n192 4.85086
R610 VDD.n181 VDD 4.85086
R611 VDD VDD.n180 4.85086
R612 VDD.n246 VDD.n2 4.718
R613 VDD.n246 VDD.n3 4.718
R614 VDD.n180 VDD 4.62653
R615 VDD VDD.n79 4.5005
R616 VDD.n56 VDD 4.5005
R617 VDD.n92 VDD 4.5005
R618 VDD.n46 VDD 4.5005
R619 VDD.n116 VDD 4.5005
R620 VDD VDD.n141 4.5005
R621 VDD VDD.n32 4.5005
R622 VDD VDD.n164 4.5005
R623 VDD.n52 VDD 4.5005
R624 VDD.n82 VDD 4.5005
R625 VDD.n102 VDD 4.5005
R626 VDD VDD.n113 4.5005
R627 VDD.n144 VDD 4.5005
R628 VDD VDD.n156 4.5005
R629 VDD.n22 VDD 4.5005
R630 VDD VDD.n173 4.5005
R631 VDD.n14 VDD 4.5005
R632 VDD.n15 VDD 4.5005
R633 VDD.n179 VDD.n17 4.5005
R634 VDD.n177 VDD.n19 4.5005
R635 VDD.n2 VDD 4.5005
R636 VDD VDD.n246 4.5005
R637 VDD.n3 VDD 4.5005
R638 VDD.n175 VDD.n174 4.09883
R639 VDD VDD.t177 3.57
R640 VDD VDD.t56 3.57
R641 VDD VDD.n119 2.798
R642 VDD.n228 VDD.n220 2.6483
R643 VDD.n222 VDD.n220 2.6483
R644 VDD.n222 VDD.n219 2.6483
R645 VDD.n191 VDD.n183 2.6483
R646 VDD.n186 VDD.n183 2.6483
R647 VDD.n186 VDD.n182 2.6483
R648 VDD VDD.n55 2.598
R649 VDD VDD.n228 2.4449
R650 VDD VDD.n182 2.4449
R651 VDD.n17 VDD.n16 2.3396
R652 VDD VDD.t2 2.30246
R653 VDD VDD.t17 2.30246
R654 VDD.t29 VDD 2.30246
R655 VDD VDD.t26 2.30246
R656 VDD.n176 VDD.n175 2.24472
R657 VDD.n178 VDD.n177 2.23795
R658 VDD.n18 VDD.n17 2.23795
R659 VDD VDD.t5 2.2105
R660 VDD VDD.t8 2.2105
R661 VDD VDD.t23 2.2105
R662 VDD VDD.t20 2.2105
R663 VDD VDD.n116 2.163
R664 VDD.n141 VDD 2.163
R665 VDD.n79 VDD 1.963
R666 VDD.n56 VDD 1.963
R667 VDD.n96 VDD 1.5705
R668 VDD VDD.n35 1.5705
R669 VDD VDD.t32 1.56579
R670 VDD VDD.t35 1.56579
R671 VDD VDD.n169 1.398
R672 VDD VDD.n25 1.398
R673 VDD.n97 VDD 1.39246
R674 VDD VDD.n36 1.39246
R675 VDD.n173 VDD.n21 1.3905
R676 VDD.n195 VDD.n2 1.3905
R677 VDD VDD.t38 1.32721
R678 VDD.t41 VDD 1.32721
R679 VDD VDD.n61 1.3005
R680 VDD VDD.n63 1.3005
R681 VDD VDD.n65 1.3005
R682 VDD VDD.n67 1.3005
R683 VDD VDD.n69 1.3005
R684 VDD VDD.n71 1.3005
R685 VDD VDD.n73 1.3005
R686 VDD VDD.n75 1.3005
R687 VDD VDD.n121 1.3005
R688 VDD VDD.n123 1.3005
R689 VDD VDD.n125 1.3005
R690 VDD VDD.n127 1.3005
R691 VDD VDD.n129 1.3005
R692 VDD VDD.n130 1.3005
R693 VDD VDD.n132 1.3005
R694 VDD VDD.n134 1.3005
R695 VDD VDD.n136 1.3005
R696 VDD.n152 VDD.n144 1.23425
R697 VDD.n109 VDD.n102 1.228
R698 VDD VDD.t44 1.22779
R699 VDD VDD.t47 1.22779
R700 VDD.n194 VDD.n193 1.21514
R701 VDD.n239 VDD.n238 1.21514
R702 VDD.n84 VDD 1.198
R703 VDD VDD.n145 1.198
R704 VDD VDD.n147 1.198
R705 VDD VDD.n236 1.13836
R706 VDD.n237 VDD 1.13836
R707 VDD.n192 VDD 1.13836
R708 VDD VDD.n181 1.13836
R709 VDD VDD.n103 1.098
R710 VDD VDD.n105 1.098
R711 VDD VDD.n56 1.0955
R712 VDD.n141 VDD 1.0955
R713 VDD.n168 VDD 1.0905
R714 VDD.n241 VDD 1.0905
R715 VDD VDD.t53 0.976457
R716 VDD VDD.t50 0.976457
R717 VDD VDD.t11 0.976457
R718 VDD VDD.t14 0.976457
R719 VDD VDD.n179 0.97175
R720 VDD VDD.n48 0.959123
R721 VDD.n240 VDD.n217 0.939071
R722 VDD.n217 VDD.n215 0.939071
R723 VDD.n215 VDD.n213 0.939071
R724 VDD.n213 VDD.n211 0.939071
R725 VDD.n211 VDD.n209 0.939071
R726 VDD.n209 VDD 0.939071
R727 VDD VDD.n206 0.939071
R728 VDD.n206 VDD.n204 0.939071
R729 VDD.n204 VDD.n202 0.939071
R730 VDD.n202 VDD.n200 0.939071
R731 VDD.n200 VDD.n198 0.939071
R732 VDD.n198 VDD.n196 0.939071
R733 VDD VDD.n155 0.93425
R734 VDD VDD.n112 0.928
R735 VDD.n61 VDD.t94 0.9105
R736 VDD.n61 VDD.t62 0.9105
R737 VDD.n63 VDD.t64 0.9105
R738 VDD.n63 VDD.t97 0.9105
R739 VDD.n65 VDD.t99 0.9105
R740 VDD.n65 VDD.t66 0.9105
R741 VDD.n67 VDD.t179 0.9105
R742 VDD.n67 VDD.t101 0.9105
R743 VDD.n69 VDD.t103 0.9105
R744 VDD.n69 VDD.t181 0.9105
R745 VDD.n71 VDD.t183 0.9105
R746 VDD.n71 VDD.t122 0.9105
R747 VDD.n73 VDD.t124 0.9105
R748 VDD.n73 VDD.t185 0.9105
R749 VDD.n75 VDD.t105 0.9105
R750 VDD.n75 VDD.t126 0.9105
R751 VDD.t2 VDD.n97 0.9105
R752 VDD.n97 VDD.t80 0.9105
R753 VDD.n121 VDD.t130 0.9105
R754 VDD.n121 VDD.t128 0.9105
R755 VDD.n123 VDD.t117 0.9105
R756 VDD.n123 VDD.t78 0.9105
R757 VDD.n125 VDD.t76 0.9105
R758 VDD.n125 VDD.t68 0.9105
R759 VDD.n127 VDD.t70 0.9105
R760 VDD.n127 VDD.t132 0.9105
R761 VDD.n129 VDD.t88 0.9105
R762 VDD.n129 VDD.t90 0.9105
R763 VDD.n130 VDD.t92 0.9105
R764 VDD.n130 VDD.t72 0.9105
R765 VDD.n132 VDD.t74 0.9105
R766 VDD.n132 VDD.t111 0.9105
R767 VDD.n134 VDD.t109 0.9105
R768 VDD.n134 VDD.t115 0.9105
R769 VDD.n136 VDD.t86 0.9105
R770 VDD.n136 VDD.t60 0.9105
R771 VDD.n36 VDD.t29 0.9105
R772 VDD.n36 VDD.t84 0.9105
R773 VDD.n169 VDD 0.8455
R774 VDD.n25 VDD 0.8455
R775 VDD VDD.n6 0.8455
R776 VDD.n242 VDD 0.8455
R777 VDD.n83 VDD 0.8405
R778 VDD VDD.n110 0.835314
R779 VDD VDD.n96 0.826152
R780 VDD.n45 VDD 0.826152
R781 VDD VDD.n35 0.826152
R782 VDD.n161 VDD 0.826152
R783 VDD VDD.n88 0.826152
R784 VDD.n83 VDD 0.826152
R785 VDD VDD.n109 0.826152
R786 VDD.n112 VDD 0.826152
R787 VDD VDD.n152 0.826152
R788 VDD.n155 VDD 0.826152
R789 VDD VDD.n21 0.826152
R790 VDD.n168 VDD 0.826152
R791 VDD VDD.n195 0.826152
R792 VDD.n241 VDD 0.826152
R793 VDD.n14 VDD 0.8105
R794 VDD VDD.n15 0.8105
R795 VDD VDD.n234 0.788
R796 VDD.n231 VDD 0.788
R797 VDD.n8 VDD 0.788
R798 VDD.n9 VDD 0.788
R799 VDD.n173 VDD 0.763
R800 VDD VDD.n22 0.763
R801 VDD VDD.n154 0.742457
R802 VDD.n45 VDD 0.7155
R803 VDD VDD.n161 0.7155
R804 VDD VDD.n54 0.7005
R805 VDD VDD.n60 0.7005
R806 VDD.n94 VDD 0.7005
R807 VDD VDD.n95 0.7005
R808 VDD VDD.n118 0.7005
R809 VDD.n117 VDD 0.7005
R810 VDD VDD.n34 0.7005
R811 VDD VDD.n33 0.7005
R812 VDD VDD.n145 0.68925
R813 VDD.n147 VDD 0.68925
R814 VDD VDD.n103 0.683
R815 VDD.n105 VDD 0.683
R816 VDD VDD.n0 0.68126
R817 VDD VDD.n1 0.68126
R818 VDD.n79 VDD.n78 0.6255
R819 VDD.n93 VDD.n92 0.6255
R820 VDD.n46 VDD.n42 0.6255
R821 VDD.n120 VDD.n116 0.6255
R822 VDD.n160 VDD.n32 0.6255
R823 VDD.n164 VDD.n31 0.6255
R824 VDD.n52 VDD.n49 0.6255
R825 VDD VDD.n28 0.612457
R826 VDD VDD.n26 0.612457
R827 VDD VDD.n197 0.612457
R828 VDD VDD.n199 0.612457
R829 VDD VDD.n201 0.612457
R830 VDD VDD.n203 0.612457
R831 VDD VDD.n205 0.612457
R832 VDD VDD.n207 0.612457
R833 VDD VDD.n208 0.612457
R834 VDD VDD.n210 0.612457
R835 VDD VDD.n212 0.612457
R836 VDD VDD.n214 0.612457
R837 VDD VDD.n216 0.612457
R838 VDD.n48 VDD.t82 0.607167
R839 VDD.n48 VDD.t113 0.607167
R840 VDD VDD.n84 0.5955
R841 VDD.n167 VDD 0.580679
R842 VDD.n240 VDD 0.575857
R843 VDD.n196 VDD 0.575857
R844 VDD VDD.n87 0.573227
R845 VDD.n85 VDD 0.573227
R846 VDD.n228 VDD.n227 0.573227
R847 VDD.n224 VDD.n222 0.573227
R848 VDD.n184 VDD.n183 0.573227
R849 VDD.n185 VDD.n182 0.573227
R850 VDD VDD.n52 0.563
R851 VDD.n82 VDD 0.563
R852 VDD.n144 VDD 0.563
R853 VDD.n156 VDD 0.563
R854 VDD.n101 VDD 0.548536
R855 VDD.n77 VDD 0.546929
R856 VDD VDD.n46 0.5455
R857 VDD.n92 VDD 0.5455
R858 VDD.n164 VDD 0.5455
R859 VDD VDD.n32 0.5455
R860 VDD.n153 VDD 0.542107
R861 VDD VDD.n89 0.538893
R862 VDD.n166 VDD.n165 0.53654
R863 VDD VDD.n108 0.5255
R864 VDD.n107 VDD 0.5255
R865 VDD.n88 VDD.n49 0.5155
R866 VDD VDD.n98 0.514786
R867 VDD.n159 VDD 0.514786
R868 VDD.n110 VDD.t41 0.492392
R869 VDD.n110 VDD.t107 0.492392
R870 VDD.n154 VDD.t187 0.485833
R871 VDD.n154 VDD.t58 0.485833
R872 VDD VDD.n151 0.485115
R873 VDD.n149 VDD 0.485115
R874 VDD.n81 VDD.n80 0.48254
R875 VDD.n77 VDD.n76 0.476214
R876 VDD.n76 VDD.n74 0.476214
R877 VDD.n74 VDD.n72 0.476214
R878 VDD.n72 VDD.n70 0.476214
R879 VDD.n68 VDD.n66 0.476214
R880 VDD.n66 VDD.n64 0.476214
R881 VDD.n64 VDD.n62 0.476214
R882 VDD.n137 VDD.n135 0.476214
R883 VDD.n135 VDD.n133 0.476214
R884 VDD.n133 VDD.n131 0.476214
R885 VDD.n131 VDD 0.476214
R886 VDD VDD.n128 0.476214
R887 VDD.n128 VDD.n126 0.476214
R888 VDD.n126 VDD.n124 0.476214
R889 VDD.n124 VDD.n122 0.476214
R890 VDD.n89 VDD 0.476214
R891 VDD VDD.n153 0.476214
R892 VDD.n167 VDD.n29 0.476214
R893 VDD.n159 VDD 0.473
R894 VDD.n78 VDD 0.4705
R895 VDD VDD.n55 0.4705
R896 VDD VDD.n93 0.4705
R897 VDD VDD.n42 0.4705
R898 VDD VDD.n120 0.4705
R899 VDD.n119 VDD 0.4705
R900 VDD VDD.n160 0.4705
R901 VDD VDD.n31 0.4705
R902 VDD.n102 VDD 0.463
R903 VDD.n113 VDD 0.463
R904 VDD VDD.n24 0.4205
R905 VDD VDD.n23 0.4205
R906 VDD VDD.n4 0.4205
R907 VDD VDD.n5 0.4205
R908 VDD.n106 VDD 0.39425
R909 VDD.t106 VDD.n106 0.39425
R910 VDD.n104 VDD 0.39425
R911 VDD.t106 VDD.n104 0.39425
R912 VDD.n232 VDD 0.39425
R913 VDD.n229 VDD 0.39425
R914 VDD VDD.n13 0.39425
R915 VDD.n10 VDD 0.39425
R916 VDD.n225 VDD.n220 0.371088
R917 VDD.n221 VDD.n219 0.371088
R918 VDD.n191 VDD.n190 0.371088
R919 VDD.n187 VDD.n186 0.371088
R920 VDD.n28 VDD.t191 0.3645
R921 VDD.n28 VDD.t193 0.3645
R922 VDD.n26 VDD.t120 0.3645
R923 VDD.n26 VDD.t189 0.3645
R924 VDD.n197 VDD.t176 0.3645
R925 VDD.n197 VDD.t174 0.3645
R926 VDD.n199 VDD.t172 0.3645
R927 VDD.n199 VDD.t170 0.3645
R928 VDD.n201 VDD.t168 0.3645
R929 VDD.n201 VDD.t166 0.3645
R930 VDD.n203 VDD.t164 0.3645
R931 VDD.n203 VDD.t162 0.3645
R932 VDD.n205 VDD.t160 0.3645
R933 VDD.n205 VDD.t158 0.3645
R934 VDD.n207 VDD.t156 0.3645
R935 VDD.n207 VDD.t154 0.3645
R936 VDD.n208 VDD.t152 0.3645
R937 VDD.n208 VDD.t150 0.3645
R938 VDD.n210 VDD.t148 0.3645
R939 VDD.n210 VDD.t146 0.3645
R940 VDD.n212 VDD.t144 0.3645
R941 VDD.n212 VDD.t142 0.3645
R942 VDD.n214 VDD.t140 0.3645
R943 VDD.n214 VDD.t138 0.3645
R944 VDD.n216 VDD.t136 0.3645
R945 VDD.n216 VDD.t134 0.3645
R946 VDD VDD.n44 0.3505
R947 VDD.t79 VDD.n44 0.3505
R948 VDD.n43 VDD 0.3505
R949 VDD.t79 VDD.n43 0.3505
R950 VDD VDD.n163 0.3505
R951 VDD.n163 VDD.t83 0.3505
R952 VDD.n162 VDD 0.3505
R953 VDD.t83 VDD.n162 0.3505
R954 VDD.n51 VDD 0.3505
R955 VDD.n86 VDD.n51 0.3505
R956 VDD VDD.n50 0.3505
R957 VDD.n86 VDD.n50 0.3505
R958 VDD.n148 VDD 0.3505
R959 VDD.n150 VDD.n148 0.3505
R960 VDD.n146 VDD 0.3505
R961 VDD.n150 VDD.n146 0.3505
R962 VDD.n233 VDD.t55 0.338172
R963 VDD.n230 VDD.t55 0.338172
R964 VDD.n12 VDD.t95 0.338172
R965 VDD.t95 VDD.n11 0.338172
R966 VDD.n226 VDD.t118 0.315577
R967 VDD.n223 VDD.t118 0.315577
R968 VDD.n189 VDD.t54 0.315577
R969 VDD.t54 VDD.n188 0.315577
R970 VDD.n142 VDD 0.31262
R971 VDD VDD.n172 0.3005
R972 VDD.n172 VDD.n171 0.3005
R973 VDD.n170 VDD 0.3005
R974 VDD.n171 VDD.n170 0.3005
R975 VDD VDD.n82 0.2905
R976 VDD.n113 VDD 0.2905
R977 VDD.n156 VDD 0.2905
R978 VDD VDD.n22 0.2905
R979 VDD VDD.n3 0.2905
R980 VDD.n98 VDD.n41 0.289786
R981 VDD.n70 VDD 0.238357
R982 VDD VDD.n68 0.238357
R983 VDD VDD.n27 0.238357
R984 VDD.n29 VDD 0.238357
R985 VDD.n114 VDD.n99 0.22514
R986 VDD.n174 VDD.n20 0.22154
R987 VDD.n111 VDD.n101 0.219071
R988 VDD.n157 VDD.n142 0.21326
R989 VDD.n235 VDD 0.20354
R990 VDD.n16 VDD 0.176
R991 VDD.n91 VDD.n40 0.1589
R992 VDD.n91 VDD.n90 0.15854
R993 VDD.n58 VDD 0.1505
R994 VDD.n59 VDD.n58 0.1505
R995 VDD.n57 VDD 0.1505
R996 VDD.n59 VDD.n57 0.1505
R997 VDD VDD.n219 0.1499
R998 VDD VDD.n191 0.1499
R999 VDD VDD.n41 0.145143
R1000 VDD VDD.n37 0.145143
R1001 VDD VDD.n140 0.1405
R1002 VDD.n140 VDD.n139 0.1405
R1003 VDD.n138 VDD 0.1405
R1004 VDD.n139 VDD.n138 0.1405
R1005 VDD.n180 VDD.n7 0.13226
R1006 VDD.n193 VDD.n7 0.13226
R1007 VDD.n238 VDD.n218 0.13226
R1008 VDD.n235 VDD.n218 0.13226
R1009 VDD.n115 VDD.n39 0.1175
R1010 VDD VDD.n111 0.109786
R1011 VDD.n166 VDD.n20 0.10202
R1012 VDD.n100 VDD 0.1013
R1013 VDD.n194 VDD.n0 0.10094
R1014 VDD.n239 VDD.n1 0.10094
R1015 VDD.n100 VDD.n39 0.09482
R1016 VDD.n143 VDD.n30 0.09338
R1017 VDD.n90 VDD.n47 0.09266
R1018 VDD.n158 VDD.n38 0.08726
R1019 VDD.n99 VDD.n40 0.08726
R1020 VDD.n81 VDD.n53 0.0851
R1021 VDD VDD.n45 0.0805
R1022 VDD.n96 VDD 0.0805
R1023 VDD.n161 VDD 0.0805
R1024 VDD.n35 VDD 0.0805
R1025 VDD.n88 VDD 0.0805
R1026 VDD VDD.n83 0.0805
R1027 VDD.n109 VDD 0.0805
R1028 VDD.n112 VDD 0.0805
R1029 VDD.n152 VDD 0.0805
R1030 VDD.n155 VDD 0.0805
R1031 VDD VDD.n168 0.0805
R1032 VDD VDD.n21 0.0805
R1033 VDD.n195 VDD 0.0805
R1034 VDD VDD.n241 0.0805
R1035 VDD.n53 VDD.n47 0.07934
R1036 VDD.n243 VDD 0.0712865
R1037 VDD.n244 VDD.n243 0.0712865
R1038 VDD.n246 VDD.n245 0.0712865
R1039 VDD.n245 VDD.n244 0.0712865
R1040 VDD.n230 VDD.n229 0.0573702
R1041 VDD.n233 VDD.n232 0.0573702
R1042 VDD.n13 VDD.n12 0.0573702
R1043 VDD.n11 VDD.n10 0.0573702
R1044 VDD.n223 VDD.n221 0.0568398
R1045 VDD.n226 VDD.n225 0.0568398
R1046 VDD.n190 VDD.n189 0.0568398
R1047 VDD.n188 VDD.n187 0.0568398
R1048 VDD.n178 VDD.n18 0.0536955
R1049 VDD.n175 VDD.n19 0.053
R1050 VDD.n143 VDD.n38 0.04766
R1051 VDD.n158 VDD.n157 0.03002
R1052 VDD.n179 VDD.n178 0.0270978
R1053 VDD.n19 VDD.n18 0.0270978
R1054 VDD.n165 VDD.n30 0.01886
R1055 VDD.n115 VDD.n114 0.01814
R1056 VDD.n176 VDD.n17 0.0135648
R1057 VDD.n177 VDD.n176 0.0135648
R1058 VSS.n216 VSS.n44 29246
R1059 VSS.n309 VSS.n303 29246
R1060 VSS.n309 VSS.n308 24989.3
R1061 VSS.n311 VSS.n47 13337
R1062 VSS.n110 VSS.n81 12095.5
R1063 VSS.n218 VSS.n217 10836.2
R1064 VSS.n304 VSS.n302 10836.2
R1065 VSS.n111 VSS.n110 9366.5
R1066 VSS.n217 VSS.n46 8018.86
R1067 VSS.t116 VSS.n6 6911.1
R1068 VSS.n120 VSS.n84 5814.65
R1069 VSS.n307 VSS.n304 4933.79
R1070 VSS.n356 VSS.n355 4805.01
R1071 VSS.n243 VSS.n6 4059.18
R1072 VSS.n233 VSS.n7 4059.18
R1073 VSS.n252 VSS.n121 4059.18
R1074 VSS.n355 VSS.n7 3505.97
R1075 VSS.n121 VSS.t116 3358.59
R1076 VSS.n121 VSS.n81 3102.63
R1077 VSS.t219 VSS.n7 2955.25
R1078 VSS.n101 VSS.n100 2745.21
R1079 VSS.t219 VSS.n6 2295.94
R1080 VSS.n217 VSS.n44 1792.36
R1081 VSS.n304 VSS.n303 1792.36
R1082 VSS.n346 VSS.n345 1755.71
R1083 VSS.n98 VSS.n81 1509.57
R1084 VSS.n310 VSS.n309 1444.14
R1085 VSS.n339 VSS.t169 1370.62
R1086 VSS.t121 VSS.n344 1370.62
R1087 VSS.n216 VSS.n46 1359.35
R1088 VSS.n218 VSS.n216 1099.61
R1089 VSS.n309 VSS.n302 1099.61
R1090 VSS.n355 VSS.n354 635.87
R1091 VSS.t100 VSS.n47 613.646
R1092 VSS.t97 VSS.n311 613.646
R1093 VSS.n84 VSS.t178 573.529
R1094 VSS.t175 VSS.n356 573.529
R1095 VSS.n111 VSS.t184 573.529
R1096 VSS.t181 VSS.n120 573.529
R1097 VSS.n109 VSS.t187 573.529
R1098 VSS.n184 VSS.n143 515.958
R1099 VSS.n184 VSS.n183 515.958
R1100 VSS.n183 VSS.n144 515.958
R1101 VSS.n144 VSS.n143 515.958
R1102 VSS.n181 VSS.n140 481.639
R1103 VSS.n145 VSS.n140 481.639
R1104 VSS.n148 VSS.n145 481.639
R1105 VSS.n181 VSS.n148 481.639
R1106 VSS.t169 VSS.t249 424.837
R1107 VSS.t249 VSS.t251 424.837
R1108 VSS.t247 VSS.t223 424.837
R1109 VSS.n354 VSS.t124 364.565
R1110 VSS.n346 VSS.t172 364.565
R1111 VSS.n345 VSS.t121 363.767
R1112 VSS.n102 VSS.n101 362.615
R1113 VSS.t100 VSS.n46 346.967
R1114 VSS.n245 VSS.n122 346.598
R1115 VSS.n245 VSS.n123 346.598
R1116 VSS.n250 VSS.n123 346.598
R1117 VSS.n250 VSS.n122 346.598
R1118 VSS.n110 VSS.n109 313.44
R1119 VSS.n310 VSS.n58 313.308
R1120 VSS.n219 VSS.n218 309.76
R1121 VSS.n297 VSS.n59 304.307
R1122 VSS.n297 VSS.n60 304.307
R1123 VSS.n300 VSS.n60 304.307
R1124 VSS.n300 VSS.n59 304.307
R1125 VSS.n225 VSS.n198 274.75
R1126 VSS.n215 VSS.n198 274.75
R1127 VSS.n215 VSS.n197 274.75
R1128 VSS.n225 VSS.n197 274.75
R1129 VSS.n308 VSS.n307 273.365
R1130 VSS.t97 VSS.n310 264.726
R1131 VSS.t251 VSS.n338 212.418
R1132 VSS.n338 VSS.t247 212.418
R1133 VSS.n263 VSS.n71 212.042
R1134 VSS.n263 VSS.n69 212.042
R1135 VSS.n71 VSS.n68 211.945
R1136 VSS.n69 VSS.n68 211.945
R1137 VSS.n222 VSS.n133 206.306
R1138 VSS.n222 VSS.n134 206.306
R1139 VSS.n231 VSS.n134 206.306
R1140 VSS.n231 VSS.n133 206.306
R1141 VSS.n294 VSS.n64 206.306
R1142 VSS.n294 VSS.n65 206.306
R1143 VSS.n267 VSS.n65 206.306
R1144 VSS.n267 VSS.n64 206.306
R1145 VSS.t219 VSS.t178 177.839
R1146 VSS.t219 VSS.t175 177.839
R1147 VSS.t116 VSS.t184 177.839
R1148 VSS.t116 VSS.t181 177.839
R1149 VSS.t190 VSS.t258 177.839
R1150 VSS.t114 VSS.t187 177.839
R1151 VSS.n295 VSS.n63 166.194
R1152 VSS.n235 VSS.n129 155.264
R1153 VSS.n235 VSS.n130 155.264
R1154 VSS.n241 VSS.n130 155.264
R1155 VSS.n241 VSS.n129 155.264
R1156 VSS.n255 VSS.n80 155.264
R1157 VSS.n257 VSS.n80 155.264
R1158 VSS.n257 VSS.n79 155.264
R1159 VSS.n255 VSS.n79 155.264
R1160 VSS.n301 VSS.t154 152.929
R1161 VSS.t151 VSS.n219 152.929
R1162 VSS.n302 VSS.n301 151.63
R1163 VSS.n339 VSS.n27 144.958
R1164 VSS.n344 VSS.n27 144.958
R1165 VSS.n344 VSS.n28 144.958
R1166 VSS.n339 VSS.n28 144.958
R1167 VSS.n102 VSS.n91 143.112
R1168 VSS.n102 VSS.n92 143.112
R1169 VSS.n108 VSS.n91 143.112
R1170 VSS.n108 VSS.n92 143.112
R1171 VSS.n313 VSS.n57 134.29
R1172 VSS.n314 VSS.n57 134.29
R1173 VSS.n314 VSS.n56 134.29
R1174 VSS.n313 VSS.n56 134.29
R1175 VSS.n322 VSS.n48 134.29
R1176 VSS.n322 VSS.n49 134.29
R1177 VSS.n51 VSS.n48 134.29
R1178 VSS.n119 VSS.n82 125.612
R1179 VSS.n119 VSS.n83 125.612
R1180 VSS.n112 VSS.n83 125.612
R1181 VSS.n112 VSS.n82 125.612
R1182 VSS.n347 VSS.n9 123.668
R1183 VSS.n347 VSS.n10 123.668
R1184 VSS.n353 VSS.n10 123.668
R1185 VSS.n353 VSS.n9 123.668
R1186 VSS.n146 VSS.n63 123.019
R1187 VSS.n234 VSS.n131 123.019
R1188 VSS.n101 VSS.n98 118.931
R1189 VSS.t193 VSS.t124 113.043
R1190 VSS.t172 VSS.t225 113.043
R1191 VSS.n8 VSS.n5 111.028
R1192 VSS.n357 VSS.n5 111.028
R1193 VSS.n357 VSS.n4 111.028
R1194 VSS.n8 VSS.n4 111.028
R1195 VSS.n296 VSS.t133 106.635
R1196 VSS.t142 VSS.n132 106.635
R1197 VSS.n234 VSS.n233 95.451
R1198 VSS.t258 VSS.n97 88.9198
R1199 VSS.n97 VSS.t114 88.9198
R1200 VSS.n218 VSS.n26 86.088
R1201 VSS.t94 VSS.t154 79.0658
R1202 VSS.t92 VSS.t94 79.0658
R1203 VSS.t12 VSS.t10 79.0658
R1204 VSS.t64 VSS.t58 79.0658
R1205 VSS.t58 VSS.t62 79.0658
R1206 VSS.t62 VSS.t60 79.0658
R1207 VSS.t60 VSS.t151 79.0658
R1208 VSS.n98 VSS.t190 76.6934
R1209 VSS.n99 VSS.t84 71.5234
R1210 VSS.n233 VSS.n232 70.7431
R1211 VSS.n345 VSS.n26 68.4024
R1212 VSS.n103 VSS.t189 67.5149
R1213 VSS.n107 VSS.t186 67.5149
R1214 VSS.n345 VSS.t223 61.0708
R1215 VSS.n308 VSS.n58 57.3669
R1216 VSS.n25 VSS.t193 56.5222
R1217 VSS.t225 VSS.n25 56.5222
R1218 VSS.n113 VSS.t183 54.4791
R1219 VSS.n118 VSS.t180 54.4791
R1220 VSS.t205 VSS.t206 53.0575
R1221 VSS.t202 VSS.t203 53.0575
R1222 VSS.t244 VSS.t243 53.0575
R1223 VSS.t241 VSS.t240 53.0575
R1224 VSS.t238 VSS.t192 53.0575
R1225 VSS.t246 VSS.t99 53.0575
R1226 VSS.t108 VSS.t101 53.0575
R1227 VSS.t214 VSS.t209 53.0575
R1228 VSS.t107 VSS.t110 53.0575
R1229 VSS.t255 VSS.t98 53.0575
R1230 VSS.t237 VSS.t236 53.0575
R1231 VSS.t234 VSS.t233 53.0575
R1232 VSS.t231 VSS.t230 53.0575
R1233 VSS.t227 VSS.t228 53.0575
R1234 VSS.t200 VSS.t201 53.0575
R1235 VSS.t197 VSS.t198 53.0575
R1236 VSS.t139 VSS.t195 53.0575
R1237 VSS.t88 VSS.t96 52.7974
R1238 VSS.n100 VSS.t12 49.1562
R1239 VSS.n341 VSS.t168 49.1345
R1240 VSS.n342 VSS.t120 49.1345
R1241 VSS.t127 VSS.t142 46.2953
R1242 VSS.n230 VSS.t141 46.233
R1243 VSS.n221 VSS.t138 46.233
R1244 VSS.n268 VSS.t135 46.233
R1245 VSS.n293 VSS.t132 46.233
R1246 VSS.t204 VSS.t78 45.255
R1247 VSS.t74 VSS.t199 45.255
R1248 VSS.n240 VSS.t159 45.138
R1249 VSS.n236 VSS.t156 45.138
R1250 VSS.n77 VSS.t165 45.138
R1251 VSS.n254 VSS.t162 45.138
R1252 VSS.t207 VSS.t82 44.2146
R1253 VSS.t70 VSS.t196 44.2146
R1254 VSS.t66 VSS.n223 43.6945
R1255 VSS.t44 VSS.t113 42.134
R1256 VSS.t26 VSS.t112 42.134
R1257 VSS.t84 VSS.t0 41.8739
R1258 VSS.n23 VSS.t123 41.4434
R1259 VSS.n348 VSS.t171 41.4434
R1260 VSS.t136 VSS.n264 41.0936
R1261 VSS.t42 VSS.t215 41.0936
R1262 VSS.t32 VSS.t119 41.0936
R1263 VSS.t38 VSS.t109 40.0533
R1264 VSS.t36 VSS.t106 40.0533
R1265 VSS.n265 VSS.t88 39.5332
R1266 VSS.n224 VSS.t68 39.5332
R1267 VSS.n224 VSS.t66 39.5332
R1268 VSS.t0 VSS.t90 37.1924
R1269 VSS.n147 VSS.t222 36.6722
R1270 VSS.n139 VSS.t253 36.6722
R1271 VSS.t245 VSS.t163 36.1521
R1272 VSS.t226 VSS.t160 36.1521
R1273 VSS.t46 VSS.t3 35.892
R1274 VSS.t235 VSS.t8 35.892
R1275 VSS.n266 VSS.t90 35.3718
R1276 VSS.n223 VSS.t64 35.3718
R1277 VSS.n2 VSS.t177 34.9256
R1278 VSS.n15 VSS.t174 34.9256
R1279 VSS.t52 VSS.t239 34.8517
R1280 VSS.t232 VSS.t18 34.8517
R1281 VSS.t196 VSS.t72 34.8517
R1282 VSS.t257 VSS.t40 34.0714
R1283 VSS.t111 VSS.t34 34.0714
R1284 VSS.t56 VSS.t242 33.8113
R1285 VSS.t4 VSS.t229 33.8113
R1286 VSS.t199 VSS.t76 33.8113
R1287 VSS.n296 VSS.n295 33.2912
R1288 VSS.n232 VSS.n132 33.2912
R1289 VSS.n100 VSS.t92 29.9101
R1290 VSS.n70 VSS.t130 29.9101
R1291 VSS.t210 VSS.t204 29.3899
R1292 VSS.n253 VSS.t54 28.3496
R1293 VSS.t16 VSS.n242 28.3496
R1294 VSS.t239 VSS.n252 27.5693
R1295 VSS.n243 VSS.t232 27.5693
R1296 VSS.n256 VSS.t222 26.529
R1297 VSS.n256 VSS.t221 26.529
R1298 VSS.n182 VSS.t105 26.529
R1299 VSS.n182 VSS.t260 26.529
R1300 VSS.n138 VSS.t254 26.529
R1301 VSS.t253 VSS.n138 26.529
R1302 VSS.t96 VSS.t86 26.2689
R1303 VSS.t113 VSS.t102 24.7084
R1304 VSS.t112 VSS.t216 24.7084
R1305 VSS.t256 VSS.t30 23.1479
R1306 VSS.t118 VSS.t28 23.1479
R1307 VSS.n251 VSS.t50 22.1076
R1308 VSS.n244 VSS.t20 22.1076
R1309 VSS.t3 VSS.n251 21.0672
R1310 VSS.n244 VSS.t235 21.0672
R1311 VSS.t213 VSS.t207 19.5067
R1312 VSS.t203 VSS.t14 19.2467
R1313 VSS.t243 VSS.t56 19.2467
R1314 VSS.t228 VSS.t4 19.2467
R1315 VSS.t76 VSS.t200 19.2467
R1316 VSS.t206 VSS.t80 18.2063
R1317 VSS.t240 VSS.t52 18.2063
R1318 VSS.t18 VSS.t231 18.2063
R1319 VSS.t72 VSS.t197 18.2063
R1320 VSS.t86 VSS.t136 17.166
R1321 VSS.t192 VSS.t46 17.166
R1322 VSS.t8 VSS.t234 17.166
R1323 VSS.t68 VSS.t139 17.166
R1324 VSS.t166 VSS.n146 16.9059
R1325 VSS.t221 VSS.t245 16.9059
R1326 VSS.t242 VSS.n253 16.9059
R1327 VSS.n242 VSS.t229 16.9059
R1328 VSS.t254 VSS.t226 16.9059
R1329 VSS.t157 VSS.n131 16.9059
R1330 VSS.n252 VSS.t24 16.6458
R1331 VSS.t6 VSS.n243 16.6458
R1332 VSS.n180 VSS.t147 16.4048
R1333 VSS.n190 VSS.t144 16.4048
R1334 VSS.n214 VSS.t150 16.4048
R1335 VSS.n199 VSS.t126 16.4048
R1336 VSS.n298 VSS.t129 16.4048
R1337 VSS.n299 VSS.t153 16.4048
R1338 VSS.n70 VSS.t133 16.3857
R1339 VSS.n147 VSS.t166 16.3857
R1340 VSS.n139 VSS.t157 16.3857
R1341 VSS.t48 VSS.t246 16.1257
R1342 VSS.t22 VSS.t237 16.1257
R1343 VSS.t80 VSS.t213 15.3454
R1344 VSS.t30 VSS.t108 15.0853
R1345 VSS.t28 VSS.t255 15.0853
R1346 VSS.t215 VSS.t256 14.8252
R1347 VSS.t119 VSS.t118 14.8252
R1348 VSS.t40 VSS.t214 14.045
R1349 VSS.t34 VSS.t107 14.045
R1350 VSS.t105 VSS.t38 13.0047
R1351 VSS.t260 VSS.t36 13.0047
R1352 VSS.t102 VSS.t48 12.2244
R1353 VSS.t216 VSS.t22 12.2244
R1354 VSS.n264 VSS.t208 11.9643
R1355 VSS.t209 VSS.t42 11.9643
R1356 VSS.t110 VSS.t32 11.9643
R1357 VSS.t101 VSS.t44 10.924
R1358 VSS.t98 VSS.t26 10.924
R1359 VSS VSS.n319 10.5016
R1360 VSS.n316 VSS 10.5
R1361 VSS.t163 VSS.t148 10.1437
R1362 VSS.t160 VSS.t145 10.1437
R1363 VSS VSS.n323 9.89259
R1364 VSS.n306 VSS 9.89208
R1365 VSS.t99 VSS.t50 9.88366
R1366 VSS.t236 VSS.t20 9.88366
R1367 VSS VSS.n89 9.21907
R1368 VSS VSS.n13 9.21907
R1369 VSS.n21 VSS 9.21907
R1370 VSS.n30 VSS 9.21907
R1371 VSS.n94 VSS 9.0005
R1372 VSS.n89 VSS 9.0005
R1373 VSS.n87 VSS 9.0005
R1374 VSS.n13 VSS 9.0005
R1375 VSS.n17 VSS 9.0005
R1376 VSS.n21 VSS 9.0005
R1377 VSS VSS.n22 9.0005
R1378 VSS.n170 VSS 9.0005
R1379 VSS.n168 VSS 9.0005
R1380 VSS.n166 VSS 9.0005
R1381 VSS.n164 VSS 9.0005
R1382 VSS.n162 VSS 9.0005
R1383 VSS.n160 VSS 9.0005
R1384 VSS.n158 VSS 9.0005
R1385 VSS.n156 VSS 9.0005
R1386 VSS.n154 VSS 9.0005
R1387 VSS.n152 VSS 9.0005
R1388 VSS.n150 VSS 9.0005
R1389 VSS.n137 VSS 9.0005
R1390 VSS.n191 VSS 9.0005
R1391 VSS VSS.n171 9.0005
R1392 VSS.n202 VSS 9.0005
R1393 VSS.n204 VSS 9.0005
R1394 VSS.n207 VSS 9.0005
R1395 VSS.n209 VSS 9.0005
R1396 VSS VSS.n212 9.0005
R1397 VSS.n200 VSS 9.0005
R1398 VSS.n278 VSS 9.0005
R1399 VSS.n280 VSS 9.0005
R1400 VSS.n282 VSS 9.0005
R1401 VSS.n284 VSS 9.0005
R1402 VSS.n286 VSS 9.0005
R1403 VSS.n288 VSS 9.0005
R1404 VSS.n289 VSS 9.0005
R1405 VSS.n276 VSS 9.0005
R1406 VSS.n34 VSS 9.0005
R1407 VSS.n33 VSS 9.0005
R1408 VSS.n30 VSS 9.0005
R1409 VSS.t82 VSS.t208 8.84333
R1410 VSS.t24 VSS.t238 8.84333
R1411 VSS.t233 VSS.t6 8.84333
R1412 VSS.t195 VSS.t70 8.84333
R1413 VSS.t78 VSS.t205 7.803
R1414 VSS.t54 VSS.t241 7.803
R1415 VSS.t230 VSS.t16 7.803
R1416 VSS.t198 VSS.t74 7.803
R1417 VSS.t10 VSS.n99 7.54291
R1418 VSS.t130 VSS.t202 6.76266
R1419 VSS.t148 VSS.t244 6.76266
R1420 VSS.t145 VSS.t227 6.76266
R1421 VSS.t201 VSS.t127 6.76266
R1422 VSS VSS.n180 5.6605
R1423 VSS VSS.n275 5.47841
R1424 VSS VSS.n86 5.38121
R1425 VSS VSS.n0 5.38121
R1426 VSS VSS.n211 5.38121
R1427 VSS VSS.n193 5.38121
R1428 VSS.n290 VSS 5.38121
R1429 VSS.n35 VSS 5.38121
R1430 VSS.n260 VSS 5.30813
R1431 VSS.n18 VSS 5.26871
R1432 VSS VSS.n19 5.26871
R1433 VSS.n192 VSS 5.26871
R1434 VSS VSS.n67 5.26871
R1435 VSS VSS.n53 5.11507
R1436 VSS.n105 VSS 5.07233
R1437 VSS.n210 VSS 5.06461
R1438 VSS.n227 VSS 5.06461
R1439 VSS VSS.n135 5.06461
R1440 VSS.n187 VSS 5.06461
R1441 VSS.n177 VSS 5.06461
R1442 VSS VSS.n173 5.06461
R1443 VSS VSS.n66 5.06461
R1444 VSS VSS.n271 5.06461
R1445 VSS.n275 VSS 5.06461
R1446 VSS VSS.n194 5.04371
R1447 VSS VSS.n228 5.04371
R1448 VSS VSS.n291 5.04371
R1449 VSS.n270 VSS 5.04371
R1450 VSS.n317 VSS 5.01157
R1451 VSS VSS.n316 5.01157
R1452 VSS VSS.n53 5.01157
R1453 VSS.n325 VSS 5.01157
R1454 VSS VSS.n324 5.01157
R1455 VSS VSS.n43 5.01157
R1456 VSS VSS.n318 5.01157
R1457 VSS.n319 VSS 5.01157
R1458 VSS.n305 VSS 5.01157
R1459 VSS.n335 VSS 4.96175
R1460 VSS VSS.n336 4.96175
R1461 VSS.t109 VSS.t257 4.94208
R1462 VSS.t106 VSS.t111 4.94208
R1463 VSS VSS.n105 4.93121
R1464 VSS.n115 VSS 4.93121
R1465 VSS VSS.n116 4.93121
R1466 VSS.n359 VSS 4.93121
R1467 VSS VSS.n1 4.93121
R1468 VSS VSS.n351 4.93121
R1469 VSS.n350 VSS 4.93121
R1470 VSS VSS.n188 4.93121
R1471 VSS.n142 VSS 4.93121
R1472 VSS.n174 VSS 4.93121
R1473 VSS VSS.n178 4.93121
R1474 VSS VSS.n237 4.93121
R1475 VSS VSS.n126 4.93121
R1476 VSS.n247 VSS 4.93121
R1477 VSS VSS.n248 4.93121
R1478 VSS VSS.n76 4.93121
R1479 VSS.n259 VSS 4.93121
R1480 VSS VSS.n260 4.93121
R1481 VSS.n117 VSS 4.5005
R1482 VSS VSS.n114 4.5005
R1483 VSS.n3 VSS 4.5005
R1484 VSS VSS.n358 4.5005
R1485 VSS VSS.n349 4.5005
R1486 VSS.n352 VSS 4.5005
R1487 VSS.n220 VSS 4.5005
R1488 VSS.n229 VSS 4.5005
R1489 VSS VSS.n172 4.5005
R1490 VSS VSS.n141 4.5005
R1491 VSS.n189 VSS 4.5005
R1492 VSS.n179 VSS 4.5005
R1493 VSS.n292 VSS 4.5005
R1494 VSS VSS.n269 4.5005
R1495 VSS VSS.n226 4.5005
R1496 VSS VSS.n196 4.5005
R1497 VSS VSS.n176 4.5005
R1498 VSS VSS.n186 4.5005
R1499 VSS.n185 VSS 4.5005
R1500 VSS.n175 VSS 4.5005
R1501 VSS VSS.n274 4.5005
R1502 VSS.n273 VSS 4.5005
R1503 VSS.n272 VSS 4.5005
R1504 VSS.n328 VSS.n327 4.5005
R1505 VSS.n41 VSS.n40 4.5005
R1506 VSS.n238 VSS 4.5005
R1507 VSS.n239 VSS 4.5005
R1508 VSS VSS.n246 4.5005
R1509 VSS.n249 VSS 4.5005
R1510 VSS.n78 VSS 4.5005
R1511 VSS VSS.n258 4.5005
R1512 VSS.n261 VSS 4.5005
R1513 VSS VSS.n75 4.5005
R1514 VSS.n331 VSS.n38 4.5005
R1515 VSS.n38 VSS.n37 4.5005
R1516 VSS.n337 VSS 4.5005
R1517 VSS VSS.n334 4.5005
R1518 VSS.n106 VSS 4.5005
R1519 VSS VSS.n104 4.5005
R1520 VSS.t14 VSS.t210 4.42191
R1521 VSS.n127 VSS.t218 4.2135
R1522 VSS.n125 VSS.t104 4.2135
R1523 VSS.n266 VSS.n265 4.16183
R1524 VSS.n128 VSS.t217 4.10325
R1525 VSS.n124 VSS.t103 4.10325
R1526 VSS.n262 VSS.t211 4.10212
R1527 VSS.n72 VSS.t1 4.10212
R1528 VSS.n73 VSS.t212 3.8985
R1529 VSS.n74 VSS.t2 3.8985
R1530 VSS.n327 VSS.n325 3.51359
R1531 VSS.n176 VSS.n175 3.4505
R1532 VSS.n186 VSS.n185 3.4505
R1533 VSS.n299 VSS 3.3805
R1534 VSS VSS.n298 3.3805
R1535 VSS.n179 VSS.n172 3.34425
R1536 VSS.n189 VSS.n141 3.34425
R1537 VSS.n58 VSS.n56 3.33211
R1538 VSS VSS.t179 3.28446
R1539 VSS VSS.t176 3.28446
R1540 VSS VSS.n199 3.0005
R1541 VSS VSS.n214 3.0005
R1542 VSS.n37 VSS 2.8744
R1543 VSS.n274 VSS.n273 2.7405
R1544 VSS.n273 VSS.n272 2.7405
R1545 VSS.n312 VSS.n55 2.6483
R1546 VSS.n315 VSS.n55 2.6483
R1547 VSS.n312 VSS.n54 2.6483
R1548 VSS.n321 VSS.n320 2.6483
R1549 VSS.n321 VSS.n50 2.6483
R1550 VSS.n52 VSS.n50 2.6483
R1551 VSS.t125 VSS 2.61167
R1552 VSS VSS.t173 2.61167
R1553 VSS.n323 VSS.t100 2.49329
R1554 VSS.n307 VSS.n306 2.49281
R1555 VSS VSS.n54 2.4449
R1556 VSS.n320 VSS 2.4449
R1557 VSS VSS.n124 2.3755
R1558 VSS.n226 VSS 2.3655
R1559 VSS VSS.n196 2.3655
R1560 VSS.n246 VSS 2.33287
R1561 VSS VSS.n249 2.33287
R1562 VSS.n323 VSS.n44 2.30519
R1563 VSS.n306 VSS.n303 2.3047
R1564 VSS.n330 VSS.n329 2.24472
R1565 VSS.n326 VSS.n41 2.23795
R1566 VSS.n328 VSS.n42 2.23795
R1567 VSS.n333 VSS.n332 2.23795
R1568 VSS.n39 VSS.n38 2.23795
R1569 VSS.n333 VSS.n36 2.23795
R1570 VSS VSS.n12 2.19246
R1571 VSS.t170 VSS 2.11011
R1572 VSS.t122 VSS 2.11011
R1573 VSS VSS.n125 2.02912
R1574 VSS.n127 VSS 2.02912
R1575 VSS VSS.t152 2.00766
R1576 VSS VSS.t128 2.00766
R1577 VSS VSS.t131 2.00766
R1578 VSS VSS.t155 2.00766
R1579 VSS VSS.n124 1.98175
R1580 VSS.n128 VSS 1.98175
R1581 VSS VSS.t149 1.9157
R1582 VSS VSS.t146 1.9157
R1583 VSS VSS.t158 1.85794
R1584 VSS VSS.t161 1.85794
R1585 VSS VSS.t164 1.85794
R1586 VSS VSS.t167 1.85794
R1587 VSS VSS.t140 1.8455
R1588 VSS VSS.t143 1.8455
R1589 VSS VSS.t134 1.8455
R1590 VSS VSS.t137 1.8455
R1591 VSS VSS.n20 1.79267
R1592 VSS.n96 VSS 1.7605
R1593 VSS.n176 VSS 1.7255
R1594 VSS.n186 VSS 1.7255
R1595 VSS VSS.t185 1.68846
R1596 VSS VSS.t182 1.68846
R1597 VSS.n172 VSS 1.67175
R1598 VSS VSS.n141 1.67175
R1599 VSS.n318 VSS 1.56398
R1600 VSS VSS.n317 1.5638
R1601 VSS.n90 VSS 1.5355
R1602 VSS VSS.n32 1.47767
R1603 VSS VSS.n31 1.47767
R1604 VSS VSS.n29 1.47767
R1605 VSS VSS.n72 1.458
R1606 VSS VSS.n330 1.44425
R1607 VSS.n175 VSS 1.43925
R1608 VSS VSS.n261 1.41412
R1609 VSS.n75 VSS 1.41412
R1610 VSS.n331 VSS 1.39175
R1611 VSS VSS.n201 1.35246
R1612 VSS VSS.n203 1.35246
R1613 VSS VSS.n205 1.35246
R1614 VSS VSS.n206 1.35246
R1615 VSS VSS.n208 1.35246
R1616 VSS VSS.n277 1.35246
R1617 VSS VSS.n279 1.35246
R1618 VSS VSS.n281 1.35246
R1619 VSS VSS.n283 1.35246
R1620 VSS VSS.n285 1.35246
R1621 VSS VSS.n287 1.35246
R1622 VSS VSS.n14 1.348
R1623 VSS.n342 VSS 1.3205
R1624 VSS VSS.n341 1.3205
R1625 VSS VSS.t191 1.28946
R1626 VSS VSS.t188 1.28946
R1627 VSS VSS.n169 1.2605
R1628 VSS VSS.n167 1.2605
R1629 VSS VSS.n165 1.2605
R1630 VSS VSS.n163 1.2605
R1631 VSS VSS.n161 1.2605
R1632 VSS VSS.n159 1.2605
R1633 VSS VSS.n157 1.2605
R1634 VSS VSS.n155 1.2605
R1635 VSS VSS.n153 1.2605
R1636 VSS VSS.n151 1.2605
R1637 VSS VSS.n149 1.2605
R1638 VSS VSS.n136 1.2605
R1639 VSS.n324 VSS 1.24121
R1640 VSS VSS.n305 1.24121
R1641 VSS.n229 VSS 1.233
R1642 VSS.n220 VSS 1.233
R1643 VSS.n269 VSS 1.233
R1644 VSS.n292 VSS 1.233
R1645 VSS.n74 VSS 1.21662
R1646 VSS VSS.n73 1.21662
R1647 VSS VSS.n72 1.16925
R1648 VSS VSS.n262 1.16925
R1649 VSS VSS.n337 1.16925
R1650 VSS VSS.n179 1.158
R1651 VSS VSS.n88 1.14246
R1652 VSS VSS.n23 1.1205
R1653 VSS.n237 VSS.n35 1.1084
R1654 VSS VSS.n352 1.0955
R1655 VSS.n12 VSS.t179 1.0925
R1656 VSS.n12 VSS.t220 1.0925
R1657 VSS.n226 VSS.n195 1.078
R1658 VSS.n274 VSS.n61 1.078
R1659 VSS VSS.n93 0.9655
R1660 VSS.n191 VSS.n137 0.939071
R1661 VSS.n150 VSS.n137 0.939071
R1662 VSS.n152 VSS.n150 0.939071
R1663 VSS.n154 VSS.n152 0.939071
R1664 VSS.n156 VSS.n154 0.939071
R1665 VSS.n158 VSS.n156 0.939071
R1666 VSS.n162 VSS.n160 0.939071
R1667 VSS.n164 VSS.n162 0.939071
R1668 VSS.n166 VSS.n164 0.939071
R1669 VSS.n168 VSS.n166 0.939071
R1670 VSS.n170 VSS.n168 0.939071
R1671 VSS.n171 VSS.n170 0.939071
R1672 VSS.n212 VSS.n209 0.939071
R1673 VSS.n209 VSS.n207 0.939071
R1674 VSS.n207 VSS 0.939071
R1675 VSS VSS.n204 0.939071
R1676 VSS.n204 VSS.n202 0.939071
R1677 VSS.n202 VSS.n200 0.939071
R1678 VSS.n289 VSS.n288 0.939071
R1679 VSS.n288 VSS.n286 0.939071
R1680 VSS.n286 VSS.n284 0.939071
R1681 VSS.n282 VSS.n280 0.939071
R1682 VSS.n280 VSS.n278 0.939071
R1683 VSS.n278 VSS.n276 0.939071
R1684 VSS.n316 VSS 0.887643
R1685 VSS.n305 VSS 0.886036
R1686 VSS.n319 VSS 0.886036
R1687 VSS.n324 VSS 0.886036
R1688 VSS VSS.n95 0.879957
R1689 VSS VSS.n85 0.8405
R1690 VSS.n20 VSS.t125 0.8195
R1691 VSS.n20 VSS.t194 0.8195
R1692 VSS VSS.n221 0.7855
R1693 VSS VSS.n230 0.7855
R1694 VSS VSS.n293 0.7855
R1695 VSS.n268 VSS 0.7855
R1696 VSS.n213 VSS 0.778
R1697 VSS VSS.n62 0.778
R1698 VSS.n236 VSS 0.76675
R1699 VSS VSS.n240 0.76675
R1700 VSS VSS.n254 0.76675
R1701 VSS VSS.n77 0.76675
R1702 VSS VSS.n107 0.7205
R1703 VSS.n103 VSS 0.7205
R1704 VSS.n96 VSS 0.704848
R1705 VSS VSS.n93 0.704848
R1706 VSS.n90 VSS 0.704848
R1707 VSS VSS.n85 0.704848
R1708 VSS.n14 VSS 0.704848
R1709 VSS VSS.n16 0.704848
R1710 VSS VSS.n11 0.704848
R1711 VSS.n24 VSS 0.704848
R1712 VSS VSS.n195 0.704848
R1713 VSS.n213 VSS 0.704848
R1714 VSS VSS.n61 0.704848
R1715 VSS VSS.n62 0.704848
R1716 VSS.n340 VSS 0.704848
R1717 VSS.n343 VSS 0.704848
R1718 VSS VSS.n19 0.6989
R1719 VSS.n115 VSS.n86 0.68666
R1720 VSS.n351 VSS.n18 0.68594
R1721 VSS.n337 VSS 0.6855
R1722 VSS.n334 VSS 0.6855
R1723 VSS.n169 VSS.t57 0.6557
R1724 VSS.n169 VSS.t55 0.6557
R1725 VSS.n167 VSS.t53 0.6557
R1726 VSS.n167 VSS.t25 0.6557
R1727 VSS.n165 VSS.t47 0.6557
R1728 VSS.n165 VSS.t51 0.6557
R1729 VSS.n163 VSS.t49 0.6557
R1730 VSS.n163 VSS.t45 0.6557
R1731 VSS.n161 VSS.t31 0.6557
R1732 VSS.n161 VSS.t43 0.6557
R1733 VSS.n159 VSS.t41 0.6557
R1734 VSS.n159 VSS.t39 0.6557
R1735 VSS.n157 VSS.t37 0.6557
R1736 VSS.n157 VSS.t35 0.6557
R1737 VSS.n155 VSS.t33 0.6557
R1738 VSS.n155 VSS.t29 0.6557
R1739 VSS.n153 VSS.t27 0.6557
R1740 VSS.n153 VSS.t23 0.6557
R1741 VSS.n151 VSS.t21 0.6557
R1742 VSS.n151 VSS.t9 0.6557
R1743 VSS.n149 VSS.t7 0.6557
R1744 VSS.n149 VSS.t19 0.6557
R1745 VSS.n136 VSS.t17 0.6557
R1746 VSS.n136 VSS.t5 0.6557
R1747 VSS.n201 VSS.t77 0.6557
R1748 VSS.n201 VSS.t75 0.6557
R1749 VSS.n203 VSS.t73 0.6557
R1750 VSS.n203 VSS.t71 0.6557
R1751 VSS.n205 VSS.t69 0.6557
R1752 VSS.n205 VSS.t67 0.6557
R1753 VSS.n206 VSS.t65 0.6557
R1754 VSS.n206 VSS.t59 0.6557
R1755 VSS.n208 VSS.t63 0.6557
R1756 VSS.n208 VSS.t61 0.6557
R1757 VSS.n277 VSS.t95 0.6557
R1758 VSS.n277 VSS.t93 0.6557
R1759 VSS.n279 VSS.t13 0.6557
R1760 VSS.n279 VSS.t11 0.6557
R1761 VSS.n281 VSS.t85 0.6557
R1762 VSS.n281 VSS.t91 0.6557
R1763 VSS.n283 VSS.t89 0.6557
R1764 VSS.n283 VSS.t87 0.6557
R1765 VSS.n285 VSS.t83 0.6557
R1766 VSS.n285 VSS.t81 0.6557
R1767 VSS.n287 VSS.t79 0.6557
R1768 VSS.n287 VSS.t15 0.6557
R1769 VSS.n16 VSS 0.653
R1770 VSS VSS.n4 0.6505
R1771 VSS.n84 VSS.n4 0.6505
R1772 VSS VSS.n5 0.6505
R1773 VSS.n356 VSS.n5 0.6505
R1774 VSS.n24 VSS 0.6355
R1775 VSS VSS.n359 0.6341
R1776 VSS.n32 VSS.t170 0.632932
R1777 VSS.n32 VSS.t250 0.632932
R1778 VSS.n31 VSS.t252 0.632932
R1779 VSS.n31 VSS.t248 0.632932
R1780 VSS.n29 VSS.t224 0.632932
R1781 VSS.n29 VSS.t122 0.632932
R1782 VSS.n118 VSS.n117 0.6255
R1783 VSS.n114 VSS.n113 0.6255
R1784 VSS.n15 VSS.n3 0.6255
R1785 VSS.n358 VSS.n2 0.6255
R1786 VSS.n349 VSS.n348 0.6255
R1787 VSS.n221 VSS.n220 0.6255
R1788 VSS.n230 VSS.n229 0.6255
R1789 VSS.n190 VSS.n189 0.6255
R1790 VSS.n293 VSS.n292 0.6255
R1791 VSS.n269 VSS.n268 0.6255
R1792 VSS.n238 VSS.n236 0.6255
R1793 VSS.n240 VSS.n239 0.6255
R1794 VSS.n254 VSS.n78 0.6255
R1795 VSS.n258 VSS.n77 0.6255
R1796 VSS.n107 VSS.n106 0.6255
R1797 VSS.n104 VSS.n103 0.6255
R1798 VSS.n211 VSS.n41 0.6251
R1799 VSS VSS.n118 0.5955
R1800 VSS.n113 VSS 0.5955
R1801 VSS.n239 VSS 0.5955
R1802 VSS VSS.n238 0.5955
R1803 VSS.n258 VSS 0.5955
R1804 VSS VSS.n78 0.5955
R1805 VSS.n353 VSS 0.578278
R1806 VSS.n354 VSS.n353 0.578278
R1807 VSS VSS.n347 0.578278
R1808 VSS.n347 VSS.n346 0.578278
R1809 VSS VSS.n191 0.556571
R1810 VSS.n171 VSS 0.556571
R1811 VSS.n22 VSS 0.550143
R1812 VSS.n212 VSS 0.550143
R1813 VSS.n88 VSS.t185 0.5465
R1814 VSS.n88 VSS.t117 0.5465
R1815 VSS VSS.n190 0.533
R1816 VSS.n180 VSS 0.533
R1817 VSS.n199 VSS 0.533
R1818 VSS.n214 VSS 0.533
R1819 VSS VSS.n299 0.533
R1820 VSS.n298 VSS 0.533
R1821 VSS VSS.n339 0.5205
R1822 VSS.n344 VSS 0.5205
R1823 VSS.n300 VSS 0.5205
R1824 VSS.n301 VSS.n300 0.5205
R1825 VSS VSS.n297 0.5205
R1826 VSS.n297 VSS.n296 0.5205
R1827 VSS VSS.n197 0.5205
R1828 VSS.n197 VSS.n132 0.5205
R1829 VSS VSS.n198 0.5205
R1830 VSS.n219 VSS.n198 0.5205
R1831 VSS VSS.n148 0.5205
R1832 VSS.n148 VSS.n147 0.5205
R1833 VSS VSS.n140 0.5205
R1834 VSS.n140 VSS.n139 0.5205
R1835 VSS.n276 VSS 0.511571
R1836 VSS.n22 VSS 0.4955
R1837 VSS.n200 VSS 0.4955
R1838 VSS VSS.n289 0.4955
R1839 VSS.n349 VSS 0.4855
R1840 VSS.n352 VSS 0.4855
R1841 VSS.n104 VSS 0.4855
R1842 VSS.n106 VSS 0.4855
R1843 VSS VSS.n94 0.476214
R1844 VSS VSS.n30 0.476214
R1845 VSS.n33 VSS 0.476214
R1846 VSS.n178 VSS.n177 0.4757
R1847 VSS.n188 VSS.n187 0.4757
R1848 VSS.n320 VSS.n49 0.473227
R1849 VSS.n50 VSS.n48 0.473227
R1850 VSS.n48 VSS.n47 0.473227
R1851 VSS.n57 VSS.n55 0.473227
R1852 VSS.n311 VSS.n57 0.473227
R1853 VSS.n56 VSS.n54 0.473227
R1854 VSS VSS.n112 0.473227
R1855 VSS.n112 VSS.n111 0.473227
R1856 VSS.n119 VSS 0.473227
R1857 VSS.n120 VSS.n119 0.473227
R1858 VSS.n49 VSS.n45 0.471002
R1859 VSS.n348 VSS 0.4705
R1860 VSS VSS.n158 0.469786
R1861 VSS.n160 VSS 0.469786
R1862 VSS.n284 VSS 0.469786
R1863 VSS VSS.n282 0.469786
R1864 VSS VSS.n17 0.460143
R1865 VSS.n94 VSS 0.456929
R1866 VSS VSS.n34 0.452107
R1867 VSS.n87 VSS 0.4505
R1868 VSS.n95 VSS.t259 0.41
R1869 VSS.n95 VSS.t115 0.41
R1870 VSS VSS.n15 0.408
R1871 VSS VSS.n2 0.408
R1872 VSS.n108 VSS 0.4005
R1873 VSS.n109 VSS.n108 0.4005
R1874 VSS VSS.n102 0.4005
R1875 VSS.n275 VSS.n271 0.3965
R1876 VSS.n117 VSS 0.3855
R1877 VSS.n114 VSS 0.3855
R1878 VSS VSS.n3 0.3855
R1879 VSS.n358 VSS 0.3855
R1880 VSS.n343 VSS.n342 0.38425
R1881 VSS.n341 VSS.n340 0.38425
R1882 VSS VSS.n79 0.371929
R1883 VSS.n79 VSS.n63 0.371929
R1884 VSS VSS.n80 0.371929
R1885 VSS.n253 VSS.n80 0.371929
R1886 VSS VSS.n69 0.371929
R1887 VSS.n99 VSS.n69 0.371929
R1888 VSS VSS.n71 0.371929
R1889 VSS.n71 VSS.n70 0.371929
R1890 VSS.n241 VSS 0.371929
R1891 VSS.n242 VSS.n241 0.371929
R1892 VSS VSS.n235 0.371929
R1893 VSS.n235 VSS.n234 0.371929
R1894 VSS VSS.n267 0.371929
R1895 VSS.n267 VSS.n266 0.371929
R1896 VSS.n294 VSS 0.371929
R1897 VSS.n295 VSS.n294 0.371929
R1898 VSS.n231 VSS 0.371929
R1899 VSS.n232 VSS.n231 0.371929
R1900 VSS.n222 VSS 0.371929
R1901 VSS.n223 VSS.n222 0.371929
R1902 VSS VSS.n87 0.366929
R1903 VSS.n17 VSS 0.366929
R1904 VSS.n260 VSS.n259 0.35474
R1905 VSS.n248 VSS.n76 0.35474
R1906 VSS.n247 VSS.n126 0.35474
R1907 VSS.n210 VSS.n194 0.3497
R1908 VSS VSS.n8 0.347167
R1909 VSS.t219 VSS.n8 0.347167
R1910 VSS VSS.n357 0.347167
R1911 VSS.n357 VSS.t219 0.347167
R1912 VSS VSS.n82 0.347167
R1913 VSS.t116 VSS.n82 0.347167
R1914 VSS VSS.n83 0.347167
R1915 VSS.t116 VSS.n83 0.347167
R1916 VSS VSS.n144 0.347167
R1917 VSS.n146 VSS.n144 0.347167
R1918 VSS VSS.n184 0.347167
R1919 VSS.n184 VSS.n131 0.347167
R1920 VSS VSS.n128 0.3355
R1921 VSS.n262 VSS 0.3355
R1922 VSS.n270 VSS.n66 0.33386
R1923 VSS.n227 VSS.n194 0.33386
R1924 VSS.n23 VSS.n11 0.3105
R1925 VSS.n322 VSS.n321 0.306382
R1926 VSS.t100 VSS.n322 0.306382
R1927 VSS.n52 VSS.n51 0.306382
R1928 VSS.n313 VSS.n312 0.306382
R1929 VSS.t97 VSS.n313 0.306382
R1930 VSS.n315 VSS.n314 0.306382
R1931 VSS.n314 VSS.t97 0.306382
R1932 VSS VSS.n9 0.306382
R1933 VSS.n25 VSS.n9 0.306382
R1934 VSS VSS.n10 0.306382
R1935 VSS.n25 VSS.n10 0.306382
R1936 VSS VSS.n92 0.306382
R1937 VSS.n97 VSS.n92 0.306382
R1938 VSS VSS.n91 0.306382
R1939 VSS.n97 VSS.n91 0.306382
R1940 VSS.n248 VSS 0.30596
R1941 VSS VSS.n247 0.30596
R1942 VSS.n51 VSS.n45 0.305119
R1943 VSS.n335 VSS.n333 0.2921
R1944 VSS VSS.n196 0.2905
R1945 VSS.n185 VSS 0.2905
R1946 VSS.n272 VSS 0.2905
R1947 VSS.n334 VSS 0.2905
R1948 VSS.n255 VSS 0.289389
R1949 VSS.n256 VSS.n255 0.289389
R1950 VSS VSS.n257 0.289389
R1951 VSS.n257 VSS.n256 0.289389
R1952 VSS VSS.n129 0.289389
R1953 VSS.n138 VSS.n129 0.289389
R1954 VSS VSS.n130 0.289389
R1955 VSS.n138 VSS.n130 0.289389
R1956 VSS VSS.n28 0.2605
R1957 VSS.n338 VSS.n28 0.2605
R1958 VSS VSS.n27 0.2605
R1959 VSS.n27 VSS.n26 0.2605
R1960 VSS.n174 VSS 0.24188
R1961 VSS VSS.n142 0.24188
R1962 VSS VSS.n21 0.238357
R1963 VSS.n34 VSS.n33 0.219071
R1964 VSS.n336 VSS.n335 0.19922
R1965 VSS VSS.n64 0.17981
R1966 VSS.t205 VSS.n64 0.17981
R1967 VSS VSS.n65 0.17981
R1968 VSS.t205 VSS.n65 0.17981
R1969 VSS VSS.n133 0.17981
R1970 VSS.t198 VSS.n133 0.17981
R1971 VSS VSS.n134 0.17981
R1972 VSS.t198 VSS.n134 0.17981
R1973 VSS.n290 VSS.n67 0.1769
R1974 VSS.n193 VSS.n192 0.1769
R1975 VSS.n250 VSS 0.173833
R1976 VSS.n251 VSS.n250 0.173833
R1977 VSS VSS.n245 0.173833
R1978 VSS.n245 VSS.n244 0.173833
R1979 VSS.n259 VSS.n76 0.1733
R1980 VSS.n237 VSS.n126 0.1733
R1981 VSS.n263 VSS 0.168242
R1982 VSS.n264 VSS.n263 0.168242
R1983 VSS VSS.n68 0.168242
R1984 VSS.n264 VSS.n68 0.168242
R1985 VSS VSS.n24 0.1605
R1986 VSS VSS.n11 0.1605
R1987 VSS VSS.n343 0.1605
R1988 VSS.n340 VSS 0.1605
R1989 VSS VSS.n315 0.1499
R1990 VSS VSS.n52 0.1499
R1991 VSS.n351 VSS.n350 0.14162
R1992 VSS VSS.n122 0.118682
R1993 VSS.n182 VSS.n122 0.118682
R1994 VSS VSS.n123 0.118682
R1995 VSS.n182 VSS.n123 0.118682
R1996 VSS.n116 VSS.n115 0.11282
R1997 VSS.n359 VSS.n1 0.11282
R1998 VSS.n89 VSS 0.109786
R1999 VSS.n13 VSS 0.109786
R2000 VSS VSS.n225 0.106622
R2001 VSS.n225 VSS.n224 0.106622
R2002 VSS.n215 VSS 0.106622
R2003 VSS.n224 VSS.n215 0.106622
R2004 VSS.n211 VSS.n210 0.10634
R2005 VSS.n350 VSS.n19 0.10634
R2006 VSS.n317 VSS.n53 0.10418
R2007 VSS.n318 VSS.n43 0.104
R2008 VSS.n325 VSS.n43 0.104
R2009 VSS.n273 VSS.n59 0.0950455
R2010 VSS.n265 VSS.n59 0.0950455
R2011 VSS VSS.n60 0.0950455
R2012 VSS.n265 VSS.n60 0.0950455
R2013 VSS.n18 VSS.n1 0.08618
R2014 VSS.n246 VSS.n127 0.0857632
R2015 VSS.n249 VSS.n125 0.0857632
R2016 VSS.n261 VSS.n73 0.0857632
R2017 VSS.n75 VSS.n74 0.0857632
R2018 VSS.n105 VSS.n86 0.08546
R2019 VSS.n173 VSS.n67 0.08474
R2020 VSS.n192 VSS.n135 0.08474
R2021 VSS.n336 VSS.n35 0.08438
R2022 VSS.n116 VSS.n0 0.08402
R2023 VSS VSS.n85 0.0805
R2024 VSS VSS.n90 0.0805
R2025 VSS.n16 VSS 0.0805
R2026 VSS.n14 VSS 0.0805
R2027 VSS VSS.n195 0.0805
R2028 VSS VSS.n213 0.0805
R2029 VSS VSS.n61 0.0805
R2030 VSS VSS.n62 0.0805
R2031 VSS VSS.n93 0.0805
R2032 VSS VSS.n96 0.0805
R2033 VSS.n291 VSS.n290 0.07106
R2034 VSS.n228 VSS.n193 0.07106
R2035 VSS.n271 VSS.n270 0.06314
R2036 VSS.n181 VSS 0.0558191
R2037 VSS.n182 VSS.n181 0.0558191
R2038 VSS VSS.n145 0.0558191
R2039 VSS.n182 VSS.n145 0.0558191
R2040 VSS.n143 VSS 0.0541082
R2041 VSS.n182 VSS.n143 0.0541082
R2042 VSS.n183 VSS 0.0541082
R2043 VSS.n183 VSS.n182 0.0541082
R2044 VSS.n332 VSS.n39 0.0536955
R2045 VSS.n39 VSS.n36 0.0536955
R2046 VSS.n326 VSS.n42 0.0536955
R2047 VSS.n330 VSS.n40 0.053
R2048 VSS.n327 VSS.n326 0.0270978
R2049 VSS.n42 VSS.n40 0.0270978
R2050 VSS.n332 VSS.n331 0.0270978
R2051 VSS.n37 VSS.n36 0.0270978
R2052 VSS.n333 VSS.n38 0.0257
R2053 VSS VSS.n0 0.0257
R2054 VSS.n291 VSS.n66 0.02354
R2055 VSS.n178 VSS.n173 0.02354
R2056 VSS.n188 VSS.n135 0.02354
R2057 VSS.n228 VSS.n227 0.02354
R2058 VSS.n329 VSS.n328 0.0135648
R2059 VSS.n329 VSS.n41 0.0135648
R2060 VSS.n177 VSS.n174 0.00824
R2061 VSS.n187 VSS.n142 0.00824
R2062 VSS.t100 VSS.n45 0.00207056
R2063 i2.0.n0 i2.0.t5 0.485833
R2064 i2.0.n0 i2.0.t1 0.485833
R2065 i2.0 i2.0.n0 0.742457
R2066 i2.0.n2 i2.0 0.238357
R2067 i2.0 i2.0.n2 0.68675
R2068 i2.0 i2.0.n3 0.032
R2069 i2.0.n3 i2.0 0.331571
R2070 i2.0 i2.0.n5 0.768714
R2071 i2.0.n5 i2.0 0.148357
R2072 i2.0 i2.0.n9 0.329196
R2073 i2.0.t10 i2.0.n9 66.8888
R2074 i2.0.t11 i2.0.n9 66.5757
R2075 i2.0.n5 i2.0 4.59371
R2076 i2.0 i2.0.n6 0.0787609
R2077 i2.0.n6 i2.0.n7 0.313543
R2078 i2.0.n7 i2.0.n8 0.313543
R2079 i2.0.t6 i2.0.n8 79.9245
R2080 i2.0.t7 i2.0.n8 79.6114
R2081 i2.0.t8 i2.0.n7 79.6114
R2082 i2.0.t9 i2.0.n6 79.6114
R2083 i2.0 i2.0.n3 5.68336
R2084 i2.0 i2.0.n4 1.14246
R2085 i2.0.t4 i2.0.n4 0.5465
R2086 i2.0.n4 i2.0.t3 0.5465
R2087 i2.0 i2.0.n2 9.0005
R2088 i2.0 i2.0.n1 0.742457
R2089 i2.0.t0 i2.0.n1 0.485833
R2090 i2.0.n1 i2.0.t2 0.485833
R2091 i1.0.t1 i1.0.n0 1.0925
R2092 i1.0.n0 i1.0.t3 1.0925
R2093 i1.0 i1.0.n0 2.19246
R2094 i1.0 i1.0.n1 0.19175
R2095 i1.0.n1 i1.0 0.156393
R2096 i1.0 i1.0.n5 0.835314
R2097 i1.0.t0 i1.0.n5 0.492392
R2098 i1.0.n5 i1.0.t2 0.492392
R2099 i1.0 i1.0.n1 4.59371
R2100 i1.0 i1.0.n2 0.656214
R2101 i1.0.n2 i1.0 0.100143
R2102 i1.0.t6 i1.0 54.0252
R2103 i1.0.n2 i1.0 4.59371
R2104 i1.0 i1.0.n3 0.425345
R2105 i1.0.n3 i1.0 1.91999
R2106 i1.0 i1.0.n4 0.391804
R2107 i1.0.t4 i1.0.n4 63.6298
R2108 i1.0.t5 i1.0.n4 63.3168
R2109 i1.0.n3 i1.0 4.59082
R2110 nm.0 nm.0.n0 1.5755
R2111 nm.0.n0 nm.0.t1 0.8195
R2112 nm.0.n0 nm.0.t0 0.8195
R2113 nd.0.n0 nd.0.t3 0.607167
R2114 nd.0.n0 nd.0.t1 0.607167
R2115 nd.0 nd.0.n0 0.959123
R2116 nd.0.n2 nd.0 0.238357
R2117 nd.0 nd.0.n2 0.689964
R2118 nd.0.n3 nd.0 4.5005
R2119 nd.0.n3 nd.0 0.0905
R2120 nd.0 nd.0.n3 6.47407
R2121 nd.0 nd.0.n5 1.78121
R2122 nd.0.n5 nd.0 0.0937143
R2123 nd.0.t6 nd.0 63.2128
R2124 nd.0.n5 nd.0 4.70621
R2125 nd.0.t7 nd.0 34.4736
R2126 nd.0 nd.0.n4 1.79267
R2127 nd.0.t2 nd.0.n4 0.8195
R2128 nd.0.n4 nd.0.t5 0.8195
R2129 nd.0 nd.0.n2 9.0005
R2130 nd.0 nd.0.n1 0.959123
R2131 nd.0.t0 nd.0.n1 0.607167
R2132 nd.0.n1 nd.0.t4 0.607167
R2133 d3.0.n0 d3.0.t1 0.9105
R2134 d3.0.n0 d3.0.t0 0.9105
R2135 d3.0 d3.0.n0 1.51767
R2136 d3.0 d3.0.n9 9.0005
R2137 d3.0.n9 d3.0 0.939071
R2138 d3.0.n7 d3.0 3.35621
R2139 d3.0 d3.0.n7 5.00514
R2140 d3.0.n8 d3.0 1.47767
R2141 d3.0.t5 d3.0.n8 0.632932
R2142 d3.0.n8 d3.0.t4 0.632932
R2143 d3.0 d3.0.n7 7.51871
R2144 d3.0.n6 d3.0 2.11871
R2145 d3.0 d3.0.n6 1.0355
R2146 d3.0.t11 d3.0 40.9895
R2147 d3.0.n6 d3.0 5.38121
R2148 d3.0.t10 d3.0 54.0878
R2149 d3.0.n9 d3.0.n2 0.9905
R2150 d3.0 d3.0.n2 0.4955
R2151 d3.0.n4 d3.0 0.4955
R2152 d3.0 d3.0.n4 9.9905
R2153 d3.0.n5 d3.0 1.51767
R2154 d3.0.t3 d3.0.n5 0.9105
R2155 d3.0.n5 d3.0.t9 0.9105
R2156 d3.0 d3.0.n4 9.0005
R2157 d3.0.n3 d3.0 1.51767
R2158 d3.0.t8 d3.0.n3 0.9105
R2159 d3.0.n3 d3.0.t7 0.9105
R2160 d3.0 d3.0.n2 9.0005
R2161 d3.0.n1 d3.0 1.51767
R2162 d3.0.t6 d3.0.n1 0.9105
R2163 d3.0.n1 d3.0.t2 0.9105
R2164 n3a.0.n0 n3a.0.t2 0.9105
R2165 n3a.0.n0 n3a.0.t1 0.9105
R2166 n3a.0 n3a.0.n0 1.51767
R2167 n3a.0 n3a.0.n2 9.9905
R2168 n3a.0 n3a.0.n2 0.9905
R2169 n3a.0.n5 n3a.0 0.9905
R2170 n3a.0.n7 n3a.0.n5 0.9905
R2171 n3a.0 n3a.0.n7 1.238
R2172 n3a.0.n12 n3a.0 5.66086
R2173 n3a.0 n3a.0.n12 0.0969286
R2174 n3a.0.n12 n3a.0 0.129071
R2175 n3a.0 n3a.0.n9 0.0161522
R2176 n3a.0.n9 n3a.0.n10 0.313543
R2177 n3a.0.n10 n3a.0.n11 0.313543
R2178 n3a.0.t14 n3a.0.n11 48.5084
R2179 n3a.0.t15 n3a.0.n11 48.1954
R2180 n3a.0.t12 n3a.0.n10 48.1954
R2181 n3a.0.t10 n3a.0.n9 48.1954
R2182 n3a.0.n8 n3a.0 1.2605
R2183 n3a.0.t11 n3a.0.n8 0.632932
R2184 n3a.0.n8 n3a.0.t13 0.632932
R2185 n3a.0 n3a.0.n7 9.0005
R2186 n3a.0 n3a.0.n6 1.51767
R2187 n3a.0.t0 n3a.0.n6 0.9105
R2188 n3a.0.n6 n3a.0.t9 0.9105
R2189 n3a.0 n3a.0.n5 9.0005
R2190 n3a.0 n3a.0.n4 1.51767
R2191 n3a.0.t8 n3a.0.n4 0.9105
R2192 n3a.0.n4 n3a.0.t7 0.9105
R2193 n3a.0 n3a.0.n3 1.51767
R2194 n3a.0.t6 n3a.0.n3 0.9105
R2195 n3a.0.n3 n3a.0.t5 0.9105
R2196 n3a.0 n3a.0.n2 9.0005
R2197 n3a.0 n3a.0.n1 1.51767
R2198 n3a.0.t4 n3a.0.n1 0.9105
R2199 n3a.0.n1 n3a.0.t3 0.9105
R2200 sb.0 sb.0.t0 3.57
R2201 sb.0.n0 sb.0 0.792457
R2202 sb.0.t1 sb.0.n0 0.375328
R2203 sb.0.n0 sb.0.t2 0.375328
R2204 d2b.0.n0 d2b.0.t13 0.9105
R2205 d2b.0.n0 d2b.0.t15 0.9105
R2206 d2b.0 d2b.0.n0 1.51767
R2207 d2b.0 d2b.0.n30 9.0005
R2208 d2b.0.n30 d2b.0.n7 0.9905
R2209 d2b.0.n7 d2b.0.n29 0.723714
R2210 d2b.0.n29 d2b.0 0.0519286
R2211 d2b.0 d2b.0.n29 0.746214
R2212 d2b.0.n28 d2b.0.n27 0.313543
R2213 d2b.0.n27 d2b.0.n26 0.313543
R2214 d2b.0.n26 d2b.0.n25 0.313543
R2215 d2b.0.n25 d2b.0 1.33093
R2216 d2b.0 d2b.0.n24 0.235283
R2217 d2b.0.n24 d2b.0.n23 0.313543
R2218 d2b.0.n23 d2b.0.n22 0.313543
R2219 d2b.0.n22 d2b.0.n21 0.313543
R2220 d2b.0.n21 d2b.0 10.9668
R2221 d2b.0.n28 d2b.0.t24 41.4434
R2222 d2b.0.n28 d2b.0.t8 40.5043
R2223 d2b.0.n27 d2b.0.t10 40.5043
R2224 d2b.0.n26 d2b.0.t23 40.5043
R2225 d2b.0.n25 d2b.0.t22 40.5043
R2226 d2b.0.n24 d2b.0.t21 40.5043
R2227 d2b.0.n23 d2b.0.t20 40.5043
R2228 d2b.0.n22 d2b.0.t12 40.5043
R2229 d2b.0.n21 d2b.0.t14 40.5043
R2230 d2b.0 d2b.0.n20 5.198
R2231 d2b.0 d2b.0.n20 0.119429
R2232 d2b.0 d2b.0.n19 1.39246
R2233 d2b.0.t1 d2b.0.n19 0.9105
R2234 d2b.0.n19 d2b.0.t4 0.9105
R2235 d2b.0.n20 d2b.0 0.109786
R2236 d2b.0 d2b.0.n8 0.993714
R2237 d2b.0.n8 d2b.0 1.10621
R2238 d2b.0 d2b.0.n17 1.27496
R2239 d2b.0.n17 d2b.0 0.309071
R2240 d2b.0 d2b.0.n18 0.792457
R2241 d2b.0.t17 d2b.0.n18 0.375328
R2242 d2b.0.n18 d2b.0.t3 0.375328
R2243 d2b.0 d2b.0.n17 9.0005
R2244 d2b.0 d2b.0.n16 0.792457
R2245 d2b.0.t2 d2b.0.n16 0.375328
R2246 d2b.0.n16 d2b.0.t16 0.375328
R2247 d2b.0 d2b.0.n8 10.4437
R2248 d2b.0.n15 d2b.0.n14 0.93963
R2249 d2b.0.n14 d2b.0.n13 0.313543
R2250 d2b.0.n13 d2b.0.n12 0.93963
R2251 d2b.0.n12 d2b.0 0.235283
R2252 d2b.0 d2b.0.n11 0.0787609
R2253 d2b.0.n11 d2b.0.n10 0.93963
R2254 d2b.0.n10 d2b.0.n9 0.313543
R2255 d2b.0.n9 d2b.0 10.3407
R2256 d2b.0.n15 d2b.0.t32 40.8173
R2257 d2b.0.n15 d2b.0.t31 40.5043
R2258 d2b.0.n14 d2b.0.t30 40.5043
R2259 d2b.0.n13 d2b.0.t29 40.5043
R2260 d2b.0.n12 d2b.0.t28 40.5043
R2261 d2b.0.n11 d2b.0.t27 40.5043
R2262 d2b.0.n10 d2b.0.t26 40.5043
R2263 d2b.0.n9 d2b.0.t25 40.5043
R2264 d2b.0 d2b.0.n7 9.0005
R2265 d2b.0.n6 d2b.0 1.51767
R2266 d2b.0.t18 d2b.0.n6 0.9105
R2267 d2b.0.n6 d2b.0.t0 0.9105
R2268 d2b.0 d2b.0.n30 0.752643
R2269 d2b.0.n2 d2b.0 0.238357
R2270 d2b.0.n4 d2b.0.n2 0.476214
R2271 d2b.0 d2b.0.n4 9.9905
R2272 d2b.0.n5 d2b.0 1.51767
R2273 d2b.0.t9 d2b.0.n5 0.9105
R2274 d2b.0.n5 d2b.0.t11 0.9105
R2275 d2b.0 d2b.0.n4 9.0005
R2276 d2b.0.n3 d2b.0 1.51767
R2277 d2b.0.t7 d2b.0.n3 0.9105
R2278 d2b.0.n3 d2b.0.t6 0.9105
R2279 d2b.0 d2b.0.n2 9.0005
R2280 d2b.0.n1 d2b.0 1.51767
R2281 d2b.0.t5 d2b.0.n1 0.9105
R2282 d2b.0.n1 d2b.0.t19 0.9105
R2283 rlb_m1.0 rlb_m1.0.t0 3.57
R2284 rlb_m1.0 rlb_m1.0.t1 3.57
R2285 rla_m1.0 rla_m1.0.t0 3.57
R2286 rla_m1.0 rla_m1.0.t1 3.57
R2287 sa.0 sa.0.t0 3.57
R2288 sa.0.n0 sa.0 0.792457
R2289 sa.0.t1 sa.0.n0 0.375328
R2290 sa.0.n0 sa.0.t2 0.375328
R2291 d2a.0.n0 d2a.0.t8 0.9105
R2292 d2a.0.n0 d2a.0.t9 0.9105
R2293 d2a.0 d2a.0.n0 1.51767
R2294 d2a.0 d2a.0.n30 9.0005
R2295 d2a.0 d2a.0.n30 9.9905
R2296 d2a.0 d2a.0.n29 1.51767
R2297 d2a.0.t17 d2a.0.n29 0.9105
R2298 d2a.0.n29 d2a.0.t19 0.9105
R2299 d2a.0 d2a.0.n30 1.00979
R2300 d2a.0.n2 d2a.0 0.4955
R2301 d2a.0.n4 d2a.0.n2 0.9905
R2302 d2a.0.n6 d2a.0.n4 0.476214
R2303 d2a.0 d2a.0.n28 0.0519286
R2304 d2a.0.n28 d2a.0.n6 0.723714
R2305 d2a.0.n28 d2a.0 0.746214
R2306 d2a.0 d2a.0.n20 10.3407
R2307 d2a.0.n20 d2a.0.n21 0.313543
R2308 d2a.0.n21 d2a.0 1.48746
R2309 d2a.0 d2a.0.n22 0.0787609
R2310 d2a.0.n22 d2a.0.n23 0.313543
R2311 d2a.0.n23 d2a.0.n24 0.313543
R2312 d2a.0.n24 d2a.0.n25 0.313543
R2313 d2a.0.n25 d2a.0.n26 1.56572
R2314 d2a.0.n26 d2a.0.n27 0.313543
R2315 d2a.0.t20 d2a.0.n27 40.8173
R2316 d2a.0.t18 d2a.0.n27 40.5043
R2317 d2a.0.t16 d2a.0.n26 40.5043
R2318 d2a.0.t21 d2a.0.n25 40.5043
R2319 d2a.0.t22 d2a.0.n24 40.5043
R2320 d2a.0.t23 d2a.0.n23 40.5043
R2321 d2a.0.t24 d2a.0.n22 40.5043
R2322 d2a.0.t14 d2a.0.n21 40.5043
R2323 d2a.0.t12 d2a.0.n20 40.5043
R2324 d2a.0 d2a.0.n7 0.3155
R2325 d2a.0.n7 d2a.0.n9 0.861929
R2326 d2a.0.n9 d2a.0 1.10621
R2327 d2a.0.n18 d2a.0 1.27496
R2328 d2a.0 d2a.0.n18 0.309071
R2329 d2a.0 d2a.0.n19 0.792457
R2330 d2a.0.t2 d2a.0.n19 0.375328
R2331 d2a.0.n19 d2a.0.t10 0.375328
R2332 d2a.0 d2a.0.n18 9.0005
R2333 d2a.0 d2a.0.n17 0.792457
R2334 d2a.0.t11 d2a.0.n17 0.375328
R2335 d2a.0.n17 d2a.0.t3 0.375328
R2336 d2a.0 d2a.0.n9 10.5562
R2337 d2a.0 d2a.0.n10 10.0277
R2338 d2a.0.n10 d2a.0.n11 0.93963
R2339 d2a.0.n11 d2a.0.n12 0.313543
R2340 d2a.0.n12 d2a.0 0.548326
R2341 d2a.0 d2a.0.n13 0.391804
R2342 d2a.0.n13 d2a.0.n14 0.313543
R2343 d2a.0.n14 d2a.0.n15 0.93963
R2344 d2a.0.n15 d2a.0.n16 0.313543
R2345 d2a.0.t25 d2a.0.n16 41.4434
R2346 d2a.0.t26 d2a.0.n16 40.5043
R2347 d2a.0.t27 d2a.0.n15 40.5043
R2348 d2a.0.t28 d2a.0.n14 40.5043
R2349 d2a.0.t29 d2a.0.n13 40.5043
R2350 d2a.0.t30 d2a.0.n12 40.5043
R2351 d2a.0.t31 d2a.0.n11 40.5043
R2352 d2a.0.t32 d2a.0.n10 40.5043
R2353 d2a.0 d2a.0.n7 4.70621
R2354 d2a.0 d2a.0.n8 1.39246
R2355 d2a.0.t0 d2a.0.n8 0.9105
R2356 d2a.0.n8 d2a.0.t4 0.9105
R2357 d2a.0 d2a.0.n6 9.0005
R2358 d2a.0 d2a.0.n5 1.51767
R2359 d2a.0.t1 d2a.0.n5 0.9105
R2360 d2a.0.n5 d2a.0.t5 0.9105
R2361 d2a.0 d2a.0.n4 9.0005
R2362 d2a.0 d2a.0.n3 1.51767
R2363 d2a.0.t13 d2a.0.n3 0.9105
R2364 d2a.0.n3 d2a.0.t15 0.9105
R2365 d2a.0 d2a.0.n2 9.0005
R2366 d2a.0 d2a.0.n1 1.51767
R2367 d2a.0.t6 d2a.0.n1 0.9105
R2368 d2a.0.n1 d2a.0.t7 0.9105
R2369 ts.0.t11 ts.0.n0 0.6557
R2370 ts.0.n0 ts.0.t14 0.6557
R2371 ts.0 ts.0.n0 1.35246
R2372 ts.0 ts.0.n2 9.93907
R2373 ts.0.n2 ts.0.n4 0.939071
R2374 ts.0 ts.0.n4 0.939071
R2375 ts.0.n7 ts.0 0.939071
R2376 ts.0.n9 ts.0.n7 0.939071
R2377 ts.0.n11 ts.0.n9 0.939071
R2378 ts.0 ts.0.n11 0.852286
R2379 ts.0.t12 ts.0 3.57
R2380 ts.0.t15 ts.0 3.57
R2381 ts.0 ts.0.n11 9.0005
R2382 ts.0 ts.0.n10 1.35246
R2383 ts.0.t13 ts.0.n10 0.6557
R2384 ts.0.n10 ts.0.t0 0.6557
R2385 ts.0 ts.0.n9 9.0005
R2386 ts.0 ts.0.n8 1.35246
R2387 ts.0.t1 ts.0.n8 0.6557
R2388 ts.0.n8 ts.0.t2 0.6557
R2389 ts.0 ts.0.n7 9.0005
R2390 ts.0 ts.0.n6 1.35246
R2391 ts.0.t3 ts.0.n6 0.6557
R2392 ts.0.n6 ts.0.t4 0.6557
R2393 ts.0 ts.0.n5 1.35246
R2394 ts.0.t5 ts.0.n5 0.6557
R2395 ts.0.n5 ts.0.t6 0.6557
R2396 ts.0 ts.0.n4 9.0005
R2397 ts.0 ts.0.n3 1.35246
R2398 ts.0.t7 ts.0.n3 0.6557
R2399 ts.0.n3 ts.0.t8 0.6557
R2400 ts.0 ts.0.n2 9.0005
R2401 ts.0 ts.0.n1 1.35246
R2402 ts.0.t9 ts.0.n1 0.6557
R2403 ts.0.n1 ts.0.t10 0.6557
R2404 tn.0.t10 tn.0.n0 0.6557
R2405 tn.0.n0 tn.0.t24 0.6557
R2406 tn.0 tn.0.n0 1.35246
R2407 tn.0 tn.0.n49 9.0005
R2408 tn.0.n49 tn.0 1.30229
R2409 tn.0 tn.0.n11 0.842643
R2410 tn.0.n11 tn.0.n13 0.617643
R2411 tn.0.n13 tn.0.n15 0.617643
R2412 tn.0.n15 tn.0.n17 0.617643
R2413 tn.0.n17 tn.0.n19 0.617643
R2414 tn.0.n19 tn.0.n21 0.617643
R2415 tn.0.n21 tn.0.n23 0.617643
R2416 tn.0.n23 tn.0.n25 0.617643
R2417 tn.0.n25 tn.0.n27 0.617643
R2418 tn.0.n27 tn.0.n29 0.617643
R2419 tn.0.n29 tn.0 0.309071
R2420 tn.0 tn.0.n31 0.309071
R2421 tn.0.n31 tn.0.n33 0.617643
R2422 tn.0.n33 tn.0.n35 0.617643
R2423 tn.0.n35 tn.0.n37 0.617643
R2424 tn.0.n37 tn.0.n39 0.617643
R2425 tn.0.n39 tn.0.n41 0.617643
R2426 tn.0.n41 tn.0.n43 0.617643
R2427 tn.0.n43 tn.0.n45 0.617643
R2428 tn.0.n45 tn.0.n47 0.617643
R2429 tn.0 tn.0.n47 9.61764
R2430 tn.0.n48 tn.0 0.6305
R2431 tn.0.t48 tn.0.n48 0.345342
R2432 tn.0.n48 tn.0.t32 0.345342
R2433 tn.0 tn.0.n47 9.0005
R2434 tn.0.n46 tn.0 0.6305
R2435 tn.0.t31 tn.0.n46 0.345342
R2436 tn.0.n46 tn.0.t47 0.345342
R2437 tn.0 tn.0.n45 9.0005
R2438 tn.0.n44 tn.0 0.6305
R2439 tn.0.t42 tn.0.n44 0.345342
R2440 tn.0.n44 tn.0.t30 0.345342
R2441 tn.0 tn.0.n43 9.0005
R2442 tn.0.n42 tn.0 0.6305
R2443 tn.0.t29 tn.0.n42 0.345342
R2444 tn.0.n42 tn.0.t41 0.345342
R2445 tn.0 tn.0.n41 9.0005
R2446 tn.0.n40 tn.0 0.6305
R2447 tn.0.t0 tn.0.n40 0.345342
R2448 tn.0.n40 tn.0.t25 0.345342
R2449 tn.0 tn.0.n39 9.0005
R2450 tn.0.n38 tn.0 0.6305
R2451 tn.0.t49 tn.0.n38 0.345342
R2452 tn.0.n38 tn.0.t12 0.345342
R2453 tn.0 tn.0.n37 9.0005
R2454 tn.0.n36 tn.0 0.6305
R2455 tn.0.t13 tn.0.n36 0.345342
R2456 tn.0.n36 tn.0.t21 0.345342
R2457 tn.0 tn.0.n35 9.0005
R2458 tn.0.n34 tn.0 0.6305
R2459 tn.0.t28 tn.0.n34 0.345342
R2460 tn.0.n34 tn.0.t17 0.345342
R2461 tn.0 tn.0.n33 9.0005
R2462 tn.0.n32 tn.0 0.6305
R2463 tn.0.t27 tn.0.n32 0.345342
R2464 tn.0.n32 tn.0.t26 0.345342
R2465 tn.0 tn.0.n31 9.0005
R2466 tn.0.n30 tn.0 0.6305
R2467 tn.0.t14 tn.0.n30 0.345342
R2468 tn.0.n30 tn.0.t18 0.345342
R2469 tn.0 tn.0.n29 9.0005
R2470 tn.0.n28 tn.0 0.6305
R2471 tn.0.t15 tn.0.n28 0.345342
R2472 tn.0.n28 tn.0.t51 0.345342
R2473 tn.0 tn.0.n27 9.0005
R2474 tn.0.n26 tn.0 0.6305
R2475 tn.0.t19 tn.0.n26 0.345342
R2476 tn.0.n26 tn.0.t16 0.345342
R2477 tn.0 tn.0.n25 9.0005
R2478 tn.0.n24 tn.0 0.6305
R2479 tn.0.t50 tn.0.n24 0.345342
R2480 tn.0.n24 tn.0.t22 0.345342
R2481 tn.0 tn.0.n23 9.0005
R2482 tn.0.n22 tn.0 0.6305
R2483 tn.0.t20 tn.0.n22 0.345342
R2484 tn.0.n22 tn.0.t11 0.345342
R2485 tn.0 tn.0.n21 9.0005
R2486 tn.0.n20 tn.0 0.6305
R2487 tn.0.t40 tn.0.n20 0.345342
R2488 tn.0.n20 tn.0.t36 0.345342
R2489 tn.0 tn.0.n19 9.0005
R2490 tn.0.n18 tn.0 0.6305
R2491 tn.0.t35 tn.0.n18 0.345342
R2492 tn.0.n18 tn.0.t39 0.345342
R2493 tn.0 tn.0.n17 9.0005
R2494 tn.0.n16 tn.0 0.6305
R2495 tn.0.t46 tn.0.n16 0.345342
R2496 tn.0.n16 tn.0.t34 0.345342
R2497 tn.0 tn.0.n15 9.0005
R2498 tn.0.n14 tn.0 0.6305
R2499 tn.0.t33 tn.0.n14 0.345342
R2500 tn.0.n14 tn.0.t45 0.345342
R2501 tn.0 tn.0.n13 9.0005
R2502 tn.0.n12 tn.0 0.6305
R2503 tn.0.t44 tn.0.n12 0.345342
R2504 tn.0.n12 tn.0.t38 0.345342
R2505 tn.0 tn.0.n11 9.0005
R2506 tn.0.n10 tn.0 0.6305
R2507 tn.0.t37 tn.0.n10 0.345342
R2508 tn.0.n10 tn.0.t43 0.345342
R2509 tn.0.n49 tn.0.n2 0.939071
R2510 tn.0.n2 tn.0.n4 0.939071
R2511 tn.0 tn.0.n4 0.469786
R2512 tn.0.n6 tn.0 0.469786
R2513 tn.0.n8 tn.0.n6 0.939071
R2514 tn.0 tn.0.n8 9.93907
R2515 tn.0 tn.0.n9 1.35246
R2516 tn.0.t23 tn.0.n9 0.6557
R2517 tn.0.n9 tn.0.t1 0.6557
R2518 tn.0 tn.0.n8 9.0005
R2519 tn.0 tn.0.n7 1.35246
R2520 tn.0.t2 tn.0.n7 0.6557
R2521 tn.0.n7 tn.0.t3 0.6557
R2522 tn.0 tn.0.n6 9.0005
R2523 tn.0 tn.0.n5 1.35246
R2524 tn.0.t4 tn.0.n5 0.6557
R2525 tn.0.n5 tn.0.t5 0.6557
R2526 tn.0 tn.0.n4 9.0005
R2527 tn.0 tn.0.n3 1.35246
R2528 tn.0.t6 tn.0.n3 0.6557
R2529 tn.0.n3 tn.0.t7 0.6557
R2530 tn.0 tn.0.n2 9.0005
R2531 tn.0 tn.0.n1 1.35246
R2532 tn.0.t8 tn.0.n1 0.6557
R2533 tn.0.n1 tn.0.t9 0.6557
R2534 ob.0.t25 ob.0 1.19252
R2535 ob.0 ob.0.n27 9.0005
R2536 ob.0.n27 ob.0 0.566214
R2537 ob.0 ob.0.n26 4.98907
R2538 ob.0 ob.0.n26 0.654607
R2539 ob.0.n25 ob.0 5.38121
R2540 ob.0.n25 ob.0 0.318714
R2541 ob.0.n24 ob.0 0.350717
R2542 ob.0.t29 ob.0.n24 44.1558
R2543 ob.0.t30 ob.0.n24 44.555
R2544 ob.0 ob.0.n25 3.35621
R2545 ob.0.t27 ob.0 3.57
R2546 ob.0.n26 ob.0 0.0953214
R2547 ob.0 ob.0.n18 1.23157
R2548 ob.0.n18 ob.0.n20 0.617643
R2549 ob.0.n20 ob.0 0.309071
R2550 ob.0 ob.0.n22 0.309071
R2551 ob.0 ob.0.n22 9.61764
R2552 ob.0 ob.0.n23 0.792457
R2553 ob.0.t10 ob.0.n23 0.362889
R2554 ob.0.n23 ob.0.t7 0.362889
R2555 ob.0 ob.0.n22 9.0005
R2556 ob.0 ob.0.n21 0.792457
R2557 ob.0.t8 ob.0.n21 0.362889
R2558 ob.0.n21 ob.0.t9 0.362889
R2559 ob.0 ob.0.n20 9.0005
R2560 ob.0 ob.0.n19 0.792457
R2561 ob.0.t12 ob.0.n19 0.362889
R2562 ob.0.n19 ob.0.t13 0.362889
R2563 ob.0 ob.0.n18 9.0005
R2564 ob.0 ob.0.n17 0.792457
R2565 ob.0.t5 ob.0.n17 0.362889
R2566 ob.0.n17 ob.0.t11 0.362889
R2567 ob.0.n27 ob.0.n1 1.27336
R2568 ob.0.n1 ob.0.n3 1.27336
R2569 ob.0.n3 ob.0.n5 1.27336
R2570 ob.0.n5 ob.0.n7 1.27336
R2571 ob.0 ob.0.n7 1.27336
R2572 ob.0.n10 ob.0 1.27336
R2573 ob.0.n12 ob.0.n10 1.27336
R2574 ob.0.n14 ob.0.n12 1.27336
R2575 ob.0.n16 ob.0.n14 1.27336
R2576 ob.0 ob.0.n16 10.2734
R2577 ob.0 ob.0.t16 1.19252
R2578 ob.0 ob.0.n16 9.0005
R2579 ob.0 ob.0.n15 0.847674
R2580 ob.0.t17 ob.0.n15 0.345342
R2581 ob.0.n15 ob.0.t18 0.345342
R2582 ob.0 ob.0.n14 9.0005
R2583 ob.0 ob.0.n13 0.847674
R2584 ob.0.t19 ob.0.n13 0.345342
R2585 ob.0.n13 ob.0.t20 0.345342
R2586 ob.0 ob.0.n12 9.0005
R2587 ob.0 ob.0.n11 0.847674
R2588 ob.0.t21 ob.0.n11 0.345342
R2589 ob.0.n11 ob.0.t2 0.345342
R2590 ob.0 ob.0.n10 9.0005
R2591 ob.0 ob.0.n9 0.847674
R2592 ob.0.t4 ob.0.n9 0.345342
R2593 ob.0.n9 ob.0.t1 0.345342
R2594 ob.0 ob.0.n8 0.847674
R2595 ob.0.t28 ob.0.n8 0.345342
R2596 ob.0.n8 ob.0.t0 0.345342
R2597 ob.0 ob.0.n7 9.0005
R2598 ob.0 ob.0.n6 0.847674
R2599 ob.0.t14 ob.0.n6 0.345342
R2600 ob.0.n6 ob.0.t15 0.345342
R2601 ob.0 ob.0.n5 9.0005
R2602 ob.0 ob.0.n4 0.847674
R2603 ob.0.t3 ob.0.n4 0.345342
R2604 ob.0.n4 ob.0.t26 0.345342
R2605 ob.0 ob.0.n3 9.0005
R2606 ob.0 ob.0.n2 0.847674
R2607 ob.0.t6 ob.0.n2 0.345342
R2608 ob.0.n2 ob.0.t22 0.345342
R2609 ob.0 ob.0.n1 9.0005
R2610 ob.0 ob.0.n0 0.847674
R2611 ob.0.t23 ob.0.n0 0.345342
R2612 ob.0.n0 ob.0.t24 0.345342
R2613 oa.0.n0 oa.0.t26 0.345342
R2614 oa.0.n0 oa.0.t27 0.345342
R2615 oa.0 oa.0.n0 0.847674
R2616 oa.0 oa.0.n2 10.2734
R2617 oa.0.n2 oa.0.n4 1.27336
R2618 oa.0.n4 oa.0.n6 1.27336
R2619 oa.0.n6 oa.0.n8 1.27336
R2620 oa.0 oa.0.n8 0.636929
R2621 oa.0.n10 oa.0 0.636929
R2622 oa.0.n12 oa.0.n10 1.27336
R2623 oa.0.n14 oa.0.n12 1.27336
R2624 oa.0.n16 oa.0.n14 1.27336
R2625 oa.0.n18 oa.0.n16 1.27336
R2626 oa.0 oa.0.n18 0.894071
R2627 oa.0 oa.0.n19 0.114607
R2628 oa.0.n19 oa.0 2.34371
R2629 oa.0.n23 oa.0 1.3955
R2630 oa.0.n25 oa.0.n23 0.617643
R2631 oa.0 oa.0.n25 0.309071
R2632 oa.0.n27 oa.0 0.309071
R2633 oa.0 oa.0.n27 9.61764
R2634 oa.0 oa.0.n28 0.792457
R2635 oa.0.t9 oa.0.n28 0.362889
R2636 oa.0.n28 oa.0.t10 0.362889
R2637 oa.0 oa.0.n27 9.0005
R2638 oa.0 oa.0.n26 0.792457
R2639 oa.0.t11 oa.0.n26 0.362889
R2640 oa.0.n26 oa.0.t12 0.362889
R2641 oa.0 oa.0.n25 9.0005
R2642 oa.0 oa.0.n24 0.792457
R2643 oa.0.t14 oa.0.n24 0.362889
R2644 oa.0.n24 oa.0.t15 0.362889
R2645 oa.0 oa.0.n23 9.0005
R2646 oa.0 oa.0.n22 0.792457
R2647 oa.0.t16 oa.0.n22 0.362889
R2648 oa.0.n22 oa.0.t13 0.362889
R2649 oa.0.n19 oa.0 4.59371
R2650 oa.0.n21 oa.0 5.60621
R2651 oa.0.n21 oa.0 2.79371
R2652 oa.0.t8 oa.0 3.57
R2653 oa.0 oa.0.n21 0.431214
R2654 oa.0 oa.0.n20 0.350717
R2655 oa.0.t29 oa.0.n20 44.555
R2656 oa.0.t30 oa.0.n20 44.1558
R2657 oa.0 oa.0.n18 9.0005
R2658 oa.0.n17 oa.0 0.847674
R2659 oa.0.t18 oa.0.n17 0.345342
R2660 oa.0.n17 oa.0.t19 0.345342
R2661 oa.0 oa.0.n16 9.0005
R2662 oa.0.n15 oa.0 0.847674
R2663 oa.0.t20 oa.0.n15 0.345342
R2664 oa.0.n15 oa.0.t21 0.345342
R2665 oa.0 oa.0.n14 9.0005
R2666 oa.0.n13 oa.0 0.847674
R2667 oa.0.t22 oa.0.n13 0.345342
R2668 oa.0.n13 oa.0.t23 0.345342
R2669 oa.0 oa.0.n12 9.0005
R2670 oa.0.n11 oa.0 0.847674
R2671 oa.0.t1 oa.0.n11 0.345342
R2672 oa.0.n11 oa.0.t28 0.345342
R2673 oa.0 oa.0.n10 9.0005
R2674 oa.0.n9 oa.0 0.847674
R2675 oa.0.t5 oa.0.n9 0.345342
R2676 oa.0.n9 oa.0.t4 0.345342
R2677 oa.0 oa.0.n8 9.0005
R2678 oa.0.n7 oa.0 0.847674
R2679 oa.0.t7 oa.0.n7 0.345342
R2680 oa.0.n7 oa.0.t17 0.345342
R2681 oa.0 oa.0.n6 9.0005
R2682 oa.0.n5 oa.0 0.847674
R2683 oa.0.t6 oa.0.n5 0.345342
R2684 oa.0.n5 oa.0.t3 0.345342
R2685 oa.0 oa.0.n4 9.0005
R2686 oa.0.n3 oa.0 0.847674
R2687 oa.0.t2 oa.0.n3 0.345342
R2688 oa.0.n3 oa.0.t0 0.345342
R2689 oa.0 oa.0.n2 9.0005
R2690 oa.0.n1 oa.0 0.847674
R2691 oa.0.t24 oa.0.n1 0.345342
R2692 oa.0.n1 oa.0.t25 0.345342
R2693 fa.0.t13 fa.0.n0 0.6557
R2694 fa.0.n0 fa.0.t29 0.6557
R2695 fa.0 fa.0.n0 1.47767
R2696 fa.0 fa.0.n2 10.9162
R2697 fa.0.n2 fa.0.n4 1.91621
R2698 fa.0 fa.0.n4 1.91621
R2699 fa.0.n7 fa.0 1.91621
R2700 fa.0.n9 fa.0.n7 1.91621
R2701 fa.0.n11 fa.0.n9 1.91621
R2702 fa.0 fa.0.n11 1.25086
R2703 fa.0.n62 fa.0 7.63121
R2704 fa.0 fa.0.n62 1.30871
R2705 fa.0 fa.0.n56 1.31193
R2706 fa.0.n56 fa.0.n58 0.617643
R2707 fa.0.n58 fa.0 0.309071
R2708 fa.0 fa.0.n60 0.309071
R2709 fa.0 fa.0.n60 9.61764
R2710 fa.0.n61 fa.0 0.792457
R2711 fa.0.t36 fa.0.n61 0.362889
R2712 fa.0.n61 fa.0.t27 0.362889
R2713 fa.0 fa.0.n60 9.0005
R2714 fa.0.n59 fa.0 0.792457
R2715 fa.0.t34 fa.0.n59 0.362889
R2716 fa.0.n59 fa.0.t35 0.362889
R2717 fa.0 fa.0.n58 9.0005
R2718 fa.0.n57 fa.0 0.792457
R2719 fa.0.t32 fa.0.n57 0.362889
R2720 fa.0.n57 fa.0.t33 0.362889
R2721 fa.0 fa.0.n56 9.0005
R2722 fa.0.n55 fa.0 0.792457
R2723 fa.0.t30 fa.0.n55 0.362889
R2724 fa.0.n55 fa.0.t31 0.362889
R2725 fa.0.n62 fa.0 0.768714
R2726 fa.0 fa.0.n13 1.12229
R2727 fa.0.n13 fa.0.n15 1.14479
R2728 fa.0.n15 fa.0.n17 1.14479
R2729 fa.0.n17 fa.0.n19 1.14479
R2730 fa.0.n19 fa.0.n21 1.14479
R2731 fa.0.n21 fa.0.n23 1.14479
R2732 fa.0.n23 fa.0.n25 1.14479
R2733 fa.0.n25 fa.0.n27 1.14479
R2734 fa.0.n27 fa.0.n29 1.14479
R2735 fa.0.n29 fa.0.n31 1.14479
R2736 fa.0.n31 fa.0.n33 1.14479
R2737 fa.0.n33 fa.0 0.572643
R2738 fa.0 fa.0.n35 0.572643
R2739 fa.0.n35 fa.0.n37 1.14479
R2740 fa.0.n37 fa.0.n39 1.14479
R2741 fa.0.n39 fa.0.n41 1.14479
R2742 fa.0.n41 fa.0.n43 1.14479
R2743 fa.0.n43 fa.0.n45 1.14479
R2744 fa.0.n45 fa.0.n47 1.14479
R2745 fa.0.n47 fa.0.n49 1.14479
R2746 fa.0.n49 fa.0.n51 1.14479
R2747 fa.0.n51 fa.0.n53 1.14479
R2748 fa.0 fa.0.n53 10.1448
R2749 fa.0.n54 fa.0 0.737674
R2750 fa.0.t61 fa.0.n54 0.379667
R2751 fa.0.n54 fa.0.t62 0.379667
R2752 fa.0 fa.0.n53 9.0005
R2753 fa.0.n52 fa.0 0.737674
R2754 fa.0.t59 fa.0.n52 0.379667
R2755 fa.0.n52 fa.0.t60 0.379667
R2756 fa.0 fa.0.n51 9.0005
R2757 fa.0.n50 fa.0 0.737674
R2758 fa.0.t57 fa.0.n50 0.379667
R2759 fa.0.n50 fa.0.t58 0.379667
R2760 fa.0 fa.0.n49 9.0005
R2761 fa.0.n48 fa.0 0.737674
R2762 fa.0.t55 fa.0.n48 0.379667
R2763 fa.0.n48 fa.0.t56 0.379667
R2764 fa.0 fa.0.n47 9.0005
R2765 fa.0.n46 fa.0 0.737674
R2766 fa.0.t53 fa.0.n46 0.379667
R2767 fa.0.n46 fa.0.t54 0.379667
R2768 fa.0 fa.0.n45 9.0005
R2769 fa.0.n44 fa.0 0.737674
R2770 fa.0.t51 fa.0.n44 0.379667
R2771 fa.0.n44 fa.0.t52 0.379667
R2772 fa.0 fa.0.n43 9.0005
R2773 fa.0.n42 fa.0 0.737674
R2774 fa.0.t25 fa.0.n42 0.379667
R2775 fa.0.n42 fa.0.t15 0.379667
R2776 fa.0 fa.0.n41 9.0005
R2777 fa.0.n40 fa.0 0.737674
R2778 fa.0.t14 fa.0.n40 0.379667
R2779 fa.0.n40 fa.0.t0 0.379667
R2780 fa.0 fa.0.n39 9.0005
R2781 fa.0.n38 fa.0 0.737674
R2782 fa.0.t16 fa.0.n38 0.379667
R2783 fa.0.n38 fa.0.t19 0.379667
R2784 fa.0 fa.0.n37 9.0005
R2785 fa.0.n36 fa.0 0.737674
R2786 fa.0.t26 fa.0.n36 0.379667
R2787 fa.0.n36 fa.0.t1 0.379667
R2788 fa.0 fa.0.n35 9.0005
R2789 fa.0.n34 fa.0 0.737674
R2790 fa.0.t18 fa.0.n34 0.379667
R2791 fa.0.n34 fa.0.t24 0.379667
R2792 fa.0 fa.0.n33 9.0005
R2793 fa.0.n32 fa.0 0.737674
R2794 fa.0.t64 fa.0.n32 0.379667
R2795 fa.0.n32 fa.0.t37 0.379667
R2796 fa.0 fa.0.n31 9.0005
R2797 fa.0.n30 fa.0 0.737674
R2798 fa.0.t40 fa.0.n30 0.379667
R2799 fa.0.n30 fa.0.t63 0.379667
R2800 fa.0 fa.0.n29 9.0005
R2801 fa.0.n28 fa.0 0.737674
R2802 fa.0.t21 fa.0.n28 0.379667
R2803 fa.0.n28 fa.0.t65 0.379667
R2804 fa.0 fa.0.n27 9.0005
R2805 fa.0.n26 fa.0 0.737674
R2806 fa.0.t17 fa.0.n26 0.379667
R2807 fa.0.n26 fa.0.t23 0.379667
R2808 fa.0 fa.0.n25 9.0005
R2809 fa.0.n24 fa.0 0.737674
R2810 fa.0.t38 fa.0.n24 0.379667
R2811 fa.0.n24 fa.0.t22 0.379667
R2812 fa.0 fa.0.n23 9.0005
R2813 fa.0.n22 fa.0 0.737674
R2814 fa.0.t20 fa.0.n22 0.379667
R2815 fa.0.n22 fa.0.t39 0.379667
R2816 fa.0 fa.0.n21 9.0005
R2817 fa.0.n20 fa.0 0.737674
R2818 fa.0.t49 fa.0.n20 0.379667
R2819 fa.0.n20 fa.0.t50 0.379667
R2820 fa.0 fa.0.n19 9.0005
R2821 fa.0.n18 fa.0 0.737674
R2822 fa.0.t47 fa.0.n18 0.379667
R2823 fa.0.n18 fa.0.t48 0.379667
R2824 fa.0 fa.0.n17 9.0005
R2825 fa.0.n16 fa.0 0.737674
R2826 fa.0.t45 fa.0.n16 0.379667
R2827 fa.0.n16 fa.0.t46 0.379667
R2828 fa.0 fa.0.n15 9.0005
R2829 fa.0.n14 fa.0 0.737674
R2830 fa.0.t43 fa.0.n14 0.379667
R2831 fa.0.n14 fa.0.t44 0.379667
R2832 fa.0 fa.0.n13 9.0005
R2833 fa.0.n12 fa.0 0.737674
R2834 fa.0.t41 fa.0.n12 0.379667
R2835 fa.0.n12 fa.0.t42 0.379667
R2836 fa.0 fa.0.n11 9.0005
R2837 fa.0 fa.0.n10 1.47767
R2838 fa.0.t28 fa.0.n10 0.6557
R2839 fa.0.n10 fa.0.t2 0.6557
R2840 fa.0 fa.0.n9 9.0005
R2841 fa.0 fa.0.n8 1.47767
R2842 fa.0.t3 fa.0.n8 0.6557
R2843 fa.0.n8 fa.0.t4 0.6557
R2844 fa.0 fa.0.n7 9.0005
R2845 fa.0 fa.0.n6 1.47767
R2846 fa.0.t5 fa.0.n6 0.6557
R2847 fa.0.n6 fa.0.t6 0.6557
R2848 fa.0 fa.0.n5 1.47767
R2849 fa.0.t7 fa.0.n5 0.6557
R2850 fa.0.n5 fa.0.t8 0.6557
R2851 fa.0 fa.0.n4 9.0005
R2852 fa.0 fa.0.n3 1.47767
R2853 fa.0.t9 fa.0.n3 0.6557
R2854 fa.0.n3 fa.0.t10 0.6557
R2855 fa.0 fa.0.n2 9.0005
R2856 fa.0 fa.0.n1 1.47767
R2857 fa.0.t11 fa.0.n1 0.6557
R2858 fa.0.n1 fa.0.t12 0.6557
R2859 fb.0.n0 fb.0.t13 0.6557
R2860 fb.0.n0 fb.0.t14 0.6557
R2861 fb.0 fb.0.n0 1.47767
R2862 fb.0 fb.0.n60 9.0005
R2863 fb.0.n60 fb.0 1.73943
R2864 fb.0 fb.0.n59 7.63121
R2865 fb.0 fb.0.n59 1.30871
R2866 fb.0.n53 fb.0 1.148
R2867 fb.0.n55 fb.0.n53 0.617643
R2868 fb.0 fb.0.n55 0.309071
R2869 fb.0.n57 fb.0 0.309071
R2870 fb.0 fb.0.n57 9.61764
R2871 fb.0.n58 fb.0 0.792457
R2872 fb.0.t25 fb.0.n58 0.362889
R2873 fb.0.n58 fb.0.t26 0.362889
R2874 fb.0 fb.0.n57 9.0005
R2875 fb.0.n56 fb.0 0.792457
R2876 fb.0.t27 fb.0.n56 0.362889
R2877 fb.0.n56 fb.0.t28 0.362889
R2878 fb.0 fb.0.n55 9.0005
R2879 fb.0.n54 fb.0 0.792457
R2880 fb.0.t29 fb.0.n54 0.362889
R2881 fb.0.n54 fb.0.t30 0.362889
R2882 fb.0 fb.0.n53 9.0005
R2883 fb.0.n52 fb.0 0.792457
R2884 fb.0.t31 fb.0.n52 0.362889
R2885 fb.0.n52 fb.0.t24 0.362889
R2886 fb.0.n59 fb.0 0.656214
R2887 fb.0.n10 fb.0 0.826571
R2888 fb.0.n12 fb.0.n10 1.14479
R2889 fb.0.n14 fb.0.n12 1.14479
R2890 fb.0.n16 fb.0.n14 1.14479
R2891 fb.0.n18 fb.0.n16 1.14479
R2892 fb.0.n20 fb.0.n18 1.14479
R2893 fb.0.n22 fb.0.n20 1.14479
R2894 fb.0.n24 fb.0.n22 1.14479
R2895 fb.0.n26 fb.0.n24 1.14479
R2896 fb.0.n28 fb.0.n26 1.14479
R2897 fb.0.n30 fb.0.n28 1.14479
R2898 fb.0 fb.0.n30 1.14479
R2899 fb.0.n33 fb.0 1.14479
R2900 fb.0.n35 fb.0.n33 1.14479
R2901 fb.0.n37 fb.0.n35 1.14479
R2902 fb.0.n39 fb.0.n37 1.14479
R2903 fb.0.n41 fb.0.n39 1.14479
R2904 fb.0.n43 fb.0.n41 1.14479
R2905 fb.0.n45 fb.0.n43 1.14479
R2906 fb.0.n47 fb.0.n45 1.14479
R2907 fb.0.n49 fb.0.n47 1.14479
R2908 fb.0.n51 fb.0.n49 1.14479
R2909 fb.0 fb.0.n51 10.1448
R2910 fb.0 fb.0.t34 1.11684
R2911 fb.0 fb.0.n51 9.0005
R2912 fb.0 fb.0.n50 0.737674
R2913 fb.0.t35 fb.0.n50 0.379667
R2914 fb.0.n50 fb.0.t36 0.379667
R2915 fb.0 fb.0.n49 9.0005
R2916 fb.0 fb.0.n48 0.737674
R2917 fb.0.t37 fb.0.n48 0.379667
R2918 fb.0.n48 fb.0.t38 0.379667
R2919 fb.0 fb.0.n47 9.0005
R2920 fb.0 fb.0.n46 0.737674
R2921 fb.0.t39 fb.0.n46 0.379667
R2922 fb.0.n46 fb.0.t40 0.379667
R2923 fb.0 fb.0.n45 9.0005
R2924 fb.0 fb.0.n44 0.737674
R2925 fb.0.t41 fb.0.n44 0.379667
R2926 fb.0.n44 fb.0.t42 0.379667
R2927 fb.0 fb.0.n43 9.0005
R2928 fb.0 fb.0.n42 0.737674
R2929 fb.0.t43 fb.0.n42 0.379667
R2930 fb.0.n42 fb.0.t15 0.379667
R2931 fb.0 fb.0.n41 9.0005
R2932 fb.0 fb.0.n40 0.737674
R2933 fb.0.t61 fb.0.n40 0.379667
R2934 fb.0.n40 fb.0.t60 0.379667
R2935 fb.0 fb.0.n39 9.0005
R2936 fb.0 fb.0.n38 0.737674
R2937 fb.0.t59 fb.0.n38 0.379667
R2938 fb.0.n38 fb.0.t2 0.379667
R2939 fb.0 fb.0.n37 9.0005
R2940 fb.0 fb.0.n36 0.737674
R2941 fb.0.t1 fb.0.n36 0.379667
R2942 fb.0.n36 fb.0.t0 0.379667
R2943 fb.0 fb.0.n35 9.0005
R2944 fb.0 fb.0.n34 0.737674
R2945 fb.0.t18 fb.0.n34 0.379667
R2946 fb.0.n34 fb.0.t17 0.379667
R2947 fb.0 fb.0.n33 9.0005
R2948 fb.0 fb.0.n32 0.737674
R2949 fb.0.t16 fb.0.n32 0.379667
R2950 fb.0.n32 fb.0.t58 0.379667
R2951 fb.0 fb.0.n31 0.737674
R2952 fb.0.t57 fb.0.n31 0.379667
R2953 fb.0.n31 fb.0.t56 0.379667
R2954 fb.0 fb.0.n30 9.0005
R2955 fb.0 fb.0.n29 0.737674
R2956 fb.0.t22 fb.0.n29 0.379667
R2957 fb.0.n29 fb.0.t63 0.379667
R2958 fb.0 fb.0.n28 9.0005
R2959 fb.0 fb.0.n27 0.737674
R2960 fb.0.t21 fb.0.n27 0.379667
R2961 fb.0.n27 fb.0.t20 0.379667
R2962 fb.0 fb.0.n26 9.0005
R2963 fb.0 fb.0.n25 0.737674
R2964 fb.0.t23 fb.0.n25 0.379667
R2965 fb.0.n25 fb.0.t19 0.379667
R2966 fb.0 fb.0.n24 9.0005
R2967 fb.0 fb.0.n23 0.737674
R2968 fb.0.t62 fb.0.n23 0.379667
R2969 fb.0.n23 fb.0.t33 0.379667
R2970 fb.0 fb.0.n22 9.0005
R2971 fb.0 fb.0.n21 0.737674
R2972 fb.0.t32 fb.0.n21 0.379667
R2973 fb.0.n21 fb.0.t44 0.379667
R2974 fb.0 fb.0.n20 9.0005
R2975 fb.0 fb.0.n19 0.737674
R2976 fb.0.t45 fb.0.n19 0.379667
R2977 fb.0.n19 fb.0.t46 0.379667
R2978 fb.0 fb.0.n18 9.0005
R2979 fb.0 fb.0.n17 0.737674
R2980 fb.0.t47 fb.0.n17 0.379667
R2981 fb.0.n17 fb.0.t48 0.379667
R2982 fb.0 fb.0.n16 9.0005
R2983 fb.0 fb.0.n15 0.737674
R2984 fb.0.t49 fb.0.n15 0.379667
R2985 fb.0.n15 fb.0.t50 0.379667
R2986 fb.0 fb.0.n14 9.0005
R2987 fb.0 fb.0.n13 0.737674
R2988 fb.0.t51 fb.0.n13 0.379667
R2989 fb.0.n13 fb.0.t52 0.379667
R2990 fb.0 fb.0.n12 9.0005
R2991 fb.0 fb.0.n11 0.737674
R2992 fb.0.t53 fb.0.n11 0.379667
R2993 fb.0.n11 fb.0.t54 0.379667
R2994 fb.0 fb.0.n10 9.0005
R2995 fb.0.t55 fb.0 1.11684
R2996 fb.0.n60 fb.0.n2 1.91621
R2997 fb.0.n2 fb.0.n4 1.91621
R2998 fb.0 fb.0.n4 0.958357
R2999 fb.0.n6 fb.0 0.958357
R3000 fb.0.n8 fb.0.n6 1.91621
R3001 fb.0 fb.0.n8 10.9162
R3002 fb.0.n9 fb.0 1.47767
R3003 fb.0.t3 fb.0.n9 0.6557
R3004 fb.0.n9 fb.0.t4 0.6557
R3005 fb.0 fb.0.n8 9.0005
R3006 fb.0.n7 fb.0 1.47767
R3007 fb.0.t5 fb.0.n7 0.6557
R3008 fb.0.n7 fb.0.t6 0.6557
R3009 fb.0 fb.0.n6 9.0005
R3010 fb.0.n5 fb.0 1.47767
R3011 fb.0.t7 fb.0.n5 0.6557
R3012 fb.0.n5 fb.0.t8 0.6557
R3013 fb.0 fb.0.n4 9.0005
R3014 fb.0.n3 fb.0 1.47767
R3015 fb.0.t9 fb.0.n3 0.6557
R3016 fb.0.n3 fb.0.t10 0.6557
R3017 fb.0 fb.0.n2 9.0005
R3018 fb.0.n1 fb.0 1.47767
R3019 fb.0.t11 fb.0.n1 0.6557
R3020 fb.0.n1 fb.0.t12 0.6557
R3021 gn.0.t0 gn.0 1.2823
R3022 gn.0.n5 gn.0.n2 9.0005
R3023 gn.0 gn.0.n0 0.985824
R3024 gn.0.n1 gn.0.n0 1.21457
R3025 gn.0.n1 gn.0 0.08675
R3026 gn.0 gn.0.n2 0.21275
R3027 gn.0.n3 gn.0.n2 0.447521
R3028 gn.0 gn.0.n3 10.4681
R3029 gn.0.n36 gn.0 4.58118
R3030 gn.0.n36 gn.0 0.075987
R3031 gn.0.n27 gn.0.n28 0.39963
R3032 gn.0.n28 gn.0.n29 1.19789
R3033 gn.0.n29 gn.0.n30 0.39963
R3034 gn.0.n30 gn.0.n31 1.19789
R3035 gn.0.n31 gn.0.n32 0.39963
R3036 gn.0.n32 gn.0 0.95137
R3037 gn.0 gn.0.n33 0.247022
R3038 gn.0.n33 gn.0.n34 0.39963
R3039 gn.0.n34 gn.0.n35 1.19789
R3040 gn.0.n35 gn.0 12.8294
R3041 gn.0.t1 gn.0.n35 46.9298
R3042 gn.0.t2 gn.0.n34 46.9298
R3043 gn.0.t3 gn.0.n33 46.9298
R3044 gn.0.t4 gn.0.n32 46.9298
R3045 gn.0.t5 gn.0.n31 46.9298
R3046 gn.0.t6 gn.0.n30 46.9298
R3047 gn.0.t7 gn.0.n29 46.9298
R3048 gn.0.t8 gn.0.n28 46.9298
R3049 gn.0.t9 gn.0.n27 46.9298
R3050 gn.0.t10 gn.0.n27 48.1272
R3051 gn.0 gn.0.n36 0.264023
R3052 gn.0.n6 gn.0.n7 0.3605
R3053 gn.0.n7 gn.0.n8 1.0805
R3054 gn.0.n8 gn.0.n9 0.3605
R3055 gn.0.n9 gn.0.n10 1.0805
R3056 gn.0.n10 gn.0.n11 0.3605
R3057 gn.0.n11 gn.0.n12 1.0805
R3058 gn.0.n12 gn.0.n13 0.3605
R3059 gn.0.n13 gn.0.n14 1.0805
R3060 gn.0.n14 gn.0.n15 0.3605
R3061 gn.0.n15 gn.0.n16 1.0805
R3062 gn.0.n16 gn.0.n17 0.3605
R3063 gn.0.n17 gn.0.n18 1.0805
R3064 gn.0.n18 gn.0.n19 0.3605
R3065 gn.0.n19 gn.0.n20 1.0805
R3066 gn.0.n20 gn.0.n21 0.3605
R3067 gn.0.n21 gn.0 0.941587
R3068 gn.0 gn.0.n22 0.139413
R3069 gn.0.n22 gn.0.n23 0.3605
R3070 gn.0.n23 gn.0.n24 1.0805
R3071 gn.0.n24 gn.0.n25 0.3605
R3072 gn.0.n25 gn.0.n26 1.0805
R3073 gn.0.n26 gn.0 18.3781
R3074 gn.0.t11 gn.0.n26 57.0825
R3075 gn.0.t12 gn.0.n25 57.0825
R3076 gn.0.t13 gn.0.n24 57.0825
R3077 gn.0.t14 gn.0.n23 57.0825
R3078 gn.0.t15 gn.0.n22 57.0825
R3079 gn.0.t16 gn.0.n21 57.0825
R3080 gn.0.t17 gn.0.n20 57.0825
R3081 gn.0.t18 gn.0.n19 57.0825
R3082 gn.0.t19 gn.0.n18 57.0825
R3083 gn.0.t20 gn.0.n17 57.0825
R3084 gn.0.t21 gn.0.n16 57.0825
R3085 gn.0.t22 gn.0.n15 57.0825
R3086 gn.0.t23 gn.0.n14 57.0825
R3087 gn.0.t24 gn.0.n13 57.0825
R3088 gn.0.t25 gn.0.n12 57.0825
R3089 gn.0.t26 gn.0.n11 57.0825
R3090 gn.0.t27 gn.0.n10 57.0825
R3091 gn.0.t28 gn.0.n9 57.0825
R3092 gn.0.t29 gn.0.n8 57.0825
R3093 gn.0.t30 gn.0.n7 57.0825
R3094 gn.0.t31 gn.0.n6 57.0825
R3095 gn.0.t32 gn.0.n6 58.1625
R3096 gn.0.n4 gn.0.t33 0.033
R3097 gn.0.n5 gn.0.n1 9.03728
R3098 gn.0.n4 gn.0.n5 0.0189805
R3099 gn.0.n3 gn.0.n4 4.45525
R3100 gn.0.n0 gn.0.t34 2.12852
R3101 gp.0.t0 gp.0 1.2823
R3102 gp.0.n3 gp.0.n0 9.0005
R3103 gp.0 gp.0.n2 10.4681
R3104 gp.0.n2 gp.0.n0 0.447521
R3105 gp.0.n0 gp.0 0.21275
R3106 gp.0 gp.0.n4 0.08675
R3107 gp.0.n4 gp.0.n5 1.21457
R3108 gp.0.n5 gp.0 0.985824
R3109 gp.0.n6 gp.0 1.33121
R3110 gp.0 gp.0.n6 0.177286
R3111 gp.0 gp.0.n36 17.2981
R3112 gp.0.n36 gp.0.n35 0.3605
R3113 gp.0.n35 gp.0.n34 1.0805
R3114 gp.0.n34 gp.0.n33 0.3605
R3115 gp.0.n33 gp.0.n32 1.0805
R3116 gp.0.n32 gp.0 0.319413
R3117 gp.0 gp.0.n31 0.041587
R3118 gp.0.n31 gp.0.n30 1.0805
R3119 gp.0.n30 gp.0.n29 0.3605
R3120 gp.0.n29 gp.0.n28 1.0805
R3121 gp.0.n28 gp.0.n27 0.3605
R3122 gp.0.n27 gp.0.n26 1.0805
R3123 gp.0.n26 gp.0.n25 0.3605
R3124 gp.0.n25 gp.0.n24 1.0805
R3125 gp.0.n24 gp.0.n23 0.3605
R3126 gp.0.n23 gp.0.n22 1.0805
R3127 gp.0.n22 gp.0.n21 0.3605
R3128 gp.0.n21 gp.0.n20 1.0805
R3129 gp.0.n20 gp.0.n19 0.3605
R3130 gp.0.n19 gp.0.n18 1.0805
R3131 gp.0.n18 gp.0.n17 0.3605
R3132 gp.0.n17 gp.0.n16 1.0805
R3133 gp.0.n36 gp.0.t32 57.0825
R3134 gp.0.n35 gp.0.t31 57.0825
R3135 gp.0.n34 gp.0.t30 57.0825
R3136 gp.0.n33 gp.0.t29 57.0825
R3137 gp.0.n32 gp.0.t28 57.0825
R3138 gp.0.n31 gp.0.t27 57.0825
R3139 gp.0.n30 gp.0.t26 57.0825
R3140 gp.0.n29 gp.0.t25 57.0825
R3141 gp.0.n28 gp.0.t24 57.0825
R3142 gp.0.n27 gp.0.t23 57.0825
R3143 gp.0.n26 gp.0.t22 57.0825
R3144 gp.0.n25 gp.0.t21 57.0825
R3145 gp.0.n24 gp.0.t20 57.0825
R3146 gp.0.n23 gp.0.t19 57.0825
R3147 gp.0.n22 gp.0.t18 57.0825
R3148 gp.0.n21 gp.0.t17 57.0825
R3149 gp.0.n20 gp.0.t16 57.0825
R3150 gp.0.n19 gp.0.t15 57.0825
R3151 gp.0.n18 gp.0.t14 57.0825
R3152 gp.0.n17 gp.0.t13 57.0825
R3153 gp.0.n16 gp.0.t12 57.0825
R3154 gp.0.n16 gp.0.t11 57.4425
R3155 gp.0 gp.0.n6 4.59371
R3156 gp.0 gp.0.n15 14.8251
R3157 gp.0.n15 gp.0.n14 0.39963
R3158 gp.0.n14 gp.0 0.0474565
R3159 gp.0 gp.0.n13 1.15093
R3160 gp.0.n13 gp.0.n12 0.39963
R3161 gp.0.n12 gp.0.n11 1.19789
R3162 gp.0.n11 gp.0.n10 0.39963
R3163 gp.0.n10 gp.0.n9 1.19789
R3164 gp.0.n9 gp.0.n8 0.39963
R3165 gp.0.n8 gp.0.n7 1.19789
R3166 gp.0.n15 gp.0.t10 46.9298
R3167 gp.0.n14 gp.0.t9 46.9298
R3168 gp.0.n13 gp.0.t8 46.9298
R3169 gp.0.n12 gp.0.t7 46.9298
R3170 gp.0.n11 gp.0.t6 46.9298
R3171 gp.0.n10 gp.0.t5 46.9298
R3172 gp.0.n9 gp.0.t4 46.9298
R3173 gp.0.n8 gp.0.t3 46.9298
R3174 gp.0.n7 gp.0.t2 46.9298
R3175 gp.0.n7 gp.0.t1 47.329
R3176 gp.0.n5 gp.0.t33 2.12852
R3177 gp.0.n1 gp.0.t34 0.033
R3178 gp.0.n2 gp.0.n1 4.45525
R3179 gp.0.n1 gp.0.n3 0.0189805
R3180 gp.0.n3 gp.0.n4 9.03728
R3181 tp.0.n0 tp.0.t0 83.3193
C0 d3.0 d2b.0 0.34009f
C1 gn.0 VB2 0.05558f
C2 ob.0 d2b.0 0.16374f
C3 ob.0 sb.0 0.20964f
C4 tn.0 ob.0 9.55392f
C5 fb.0 ob.0 2.81909f
C6 rla_m1.0 rlb_m1.0 0.39394f
C7 VDD d3.0 4.47773f
C8 ob.0 oa.0 0.59251f
C9 VDD ob.0 1.92789f
C10 ob.0 gp.0 0.3633f
C11 VB2 VREF 6.32706f
C12 VB2 fa.0 1.75715f
C13 sa.0 d2b.0 0.20995f
C14 VDD VBP 28.4203f
C15 sb.0 sa.0 0.7765f
C16 gp.0 VBP 0.26446f
C17 oa.0 sa.0 0.14911f
C18 nd.0 EN 0.90578f
C19 EN d2b.0 0.44208f
C20 VDD i2.0 4.2831f
C21 VDD sa.0 0.00366f
C22 n3a.0 d2a.0 0.24692f
C23 i1.0 i2.0 0.28557f
C24 gn.0 VBN 0.11482f
C25 VDD EN 16.8221f
C26 ob.0 VB2 0.57476f
C27 EN i1.0 0.26447f
C28 VBN ts.0 0.99312f
C29 VDD INP 2.26778f
C30 gp.0 INP 0.14621f
C31 VDD INN 2.56298f
C32 VBN VREF 0.90664f
C33 gn.0 ts.0 0.01921f
C34 VBN fa.0 2.39287f
C35 sa.0 rlb_m1.0 0
C36 gn.0 VREF 2.33633f
C37 d3.0 n3a.0 0.80741f
C38 gn.0 fa.0 0.67123f
C39 d2a.0 rla_m1.0 0
C40 VREF ts.0 0.07669f
C41 VREF fa.0 2.64932f
C42 sb.0 d2b.0 0.68313f
C43 ob.0 VBN 0.19136f
C44 ob.0 gn.0 1.03804f
C45 nd.0 VDD 2.72485f
C46 tn.0 oa.0 9.87797f
C47 d3.0 nm.0 0.01765f
C48 d3.0 d2a.0 2.37176f
C49 OUT i2.0 0.50501f
C50 VDD d2b.0 11.7806f
C51 gn.0 VBP 0.26446f
C52 tn.0 VDD 0.19528f
C53 EN n3a.0 0.00585f
C54 tn.0 gp.0 1.20627f
C55 nd.0 i1.0 0.21598f
C56 fb.0 gp.0 0.86843f
C57 VDD oa.0 1.56447f
C58 oa.0 gp.0 1.23135f
C59 ob.0 ts.0 0.21086f
C60 OUT EN 0.00492f
C61 VDD gp.0 4.5498f
C62 ob.0 VREF 2.70252f
C63 ob.0 fa.0 0
C64 VDD i1.0 2.62232f
C65 sa.0 d2a.0 1.67001f
C66 sa.0 rla_m1.0 0.30587f
C67 sa.0 ts.0 0.03853f
C68 EN nm.0 0.02238f
C69 EN d2a.0 0.17357f
C70 fb.0 VB2 2.14447f
C71 oa.0 VB2 0.57905f
C72 gn.0 INN 0.14621f
C73 VDD VB2 0.12285f
C74 gp.0 VB2 0.05601f
C75 n3a.0 d2b.0 0.16863f
C76 ob.0 sa.0 0.00738f
C77 d3.0 EN 0.46698f
C78 VDD n3a.0 4.08941f
C79 tn.0 VBN 0.82513f
C80 VDD OUT 3.99882f
C81 fb.0 VBN 1.48704f
C82 oa.0 VBN 0.33374f
C83 tn.0 gn.0 0.99696f
C84 fb.0 gn.0 2.59553f
C85 OUT i1.0 0
C86 nd.0 nm.0 0.2193f
C87 gn.0 oa.0 0.30476f
C88 VDD VBN 0.15007f
C89 gp.0 VBN 0.14191f
C90 d2a.0 d2b.0 2.76659f
C91 EN i2.0 0.31277f
C92 rla_m1.0 d2b.0 0.00423f
C93 VBP INP 0.03875f
C94 VDD gn.0 4.52025f
C95 gn.0 gp.0 2.07546f
C96 VBP INN 0.03712f
C97 sb.0 ts.0 0.06367f
C98 oa.0 d2a.0 0.16422f
C99 tn.0 ts.0 0
C100 VDD d2a.0 12.6668f
C101 tn.0 VREF 1.62411f
C102 fb.0 VREF 2.88984f
C103 fb.0 fa.0 0.80129f
C104 oa.0 VREF 2.14744f
C105 VDD ts.0 0.93712f
C106 oa.0 fa.0 2.90441f
C107 VDD VREF 0.13393f
C108 gp.0 VREF 1.91483f
C109 gp.0 fa.0 2.44274f
C110 VBN VB2 0.12676f
C111 nd.0 d3.0 0.22426f
C112 OUT VSS 4.00479f
C113 EN VSS 4.32665f
C114 VBN VSS 43.171f
C115 VB2 VSS 5.49285f
C116 VREF VSS 4.26945f
C117 INN VSS 1.5011f
C118 VBP VSS 0.726562f
C119 INP VSS 1.78005f
C120 VDD VSS 145.104f
C121 i2.0 VSS 3.15583f
C122 i1.0 VSS 3.20908f
C123 nm.0 VSS 0.189663f
C124 nd.0 VSS 2.84283f
C125 d3.0 VSS 3.83876f
C126 n3a.0 VSS 2.26664f
C127 sb.0 VSS 2.07768f
C128 d2b.0 VSS 2.74065f
C129 rlb_m1.0 VSS 0.983954f
C130 rla_m1.0 VSS 1.34728f
C131 sa.0 VSS 4.04802f
C132 d2a.0 VSS 1.61613f
C133 ts.0 VSS 6.49317f
C134 tn.0 VSS 0.183509f
C135 ob.0 VSS 3.4307f
C136 oa.0 VSS 3.65639f
C137 fa.0 VSS 3.252f
C138 fb.0 VSS 2.73074f
C139 gn.0 VSS 5.50037f
C140 gp.0 VSS 5.71365f
C141 tp.0.t0 VSS 47.5309f
C142 tp.0.n0 VSS 55.3691f
C143 gp.0.t0 VSS 0.0597429f
C144 gp.0.n0 VSS 0.0479272f
C145 gp.0.t34 VSS 1.25671f
C146 gp.0.n1 VSS 0.688532f
C147 gp.0.n2 VSS 0.209848f
C148 gp.0.n3 VSS 0.537789f
C149 gp.0.n4 VSS 0.0937009f
C150 gp.0.n5 VSS 0.16362f
C151 gp.0.t33 VSS 2.45815f
C152 gp.0.n6 VSS 0.0231039f
C153 gp.0.t1 VSS 0.0553257f
C154 gp.0.t2 VSS 0.055072f
C155 gp.0.n7 VSS 0.0703766f
C156 gp.0.t3 VSS 0.055072f
C157 gp.0.n8 VSS 0.0404284f
C158 gp.0.t4 VSS 0.055072f
C159 gp.0.n9 VSS 0.0404284f
C160 gp.0.t5 VSS 0.055072f
C161 gp.0.n10 VSS 0.0404284f
C162 gp.0.t6 VSS 0.055072f
C163 gp.0.n11 VSS 0.0404284f
C164 gp.0.t7 VSS 0.055072f
C165 gp.0.n12 VSS 0.0404284f
C166 gp.0.t8 VSS 0.055072f
C167 gp.0.n13 VSS 0.0399944f
C168 gp.0.t9 VSS 0.055072f
C169 gp.0.n14 VSS 0.0298047f
C170 gp.0.t10 VSS 0.055072f
C171 gp.0.n15 VSS 0.119876f
C172 gp.0.t11 VSS 0.0441277f
C173 gp.0.t12 VSS 0.0439675f
C174 gp.0.n16 VSS 0.060838f
C175 gp.0.t13 VSS 0.0439675f
C176 gp.0.n17 VSS 0.0350698f
C177 gp.0.t14 VSS 0.0439675f
C178 gp.0.n18 VSS 0.0350698f
C179 gp.0.t15 VSS 0.0439675f
C180 gp.0.n19 VSS 0.0350698f
C181 gp.0.t16 VSS 0.0439675f
C182 gp.0.n20 VSS 0.0350698f
C183 gp.0.t17 VSS 0.0439675f
C184 gp.0.n21 VSS 0.0350698f
C185 gp.0.t18 VSS 0.0439675f
C186 gp.0.n22 VSS 0.0350698f
C187 gp.0.t19 VSS 0.0439675f
C188 gp.0.n23 VSS 0.0350698f
C189 gp.0.t20 VSS 0.0439675f
C190 gp.0.n24 VSS 0.0350698f
C191 gp.0.t21 VSS 0.0439675f
C192 gp.0.n25 VSS 0.0350698f
C193 gp.0.t22 VSS 0.0439675f
C194 gp.0.n26 VSS 0.0350698f
C195 gp.0.t23 VSS 0.0439675f
C196 gp.0.n27 VSS 0.0350698f
C197 gp.0.t24 VSS 0.0439675f
C198 gp.0.n28 VSS 0.0350698f
C199 gp.0.t25 VSS 0.0439675f
C200 gp.0.n29 VSS 0.0350698f
C201 gp.0.t26 VSS 0.0439675f
C202 gp.0.n30 VSS 0.0350698f
C203 gp.0.t27 VSS 0.0439675f
C204 gp.0.n31 VSS 0.0321284f
C205 gp.0.t28 VSS 0.0439675f
C206 gp.0.n32 VSS 0.0346925f
C207 gp.0.t29 VSS 0.0439675f
C208 gp.0.n33 VSS 0.0350698f
C209 gp.0.t30 VSS 0.0439675f
C210 gp.0.n34 VSS 0.0350698f
C211 gp.0.t31 VSS 0.0439675f
C212 gp.0.n35 VSS 0.0350698f
C213 gp.0.t32 VSS 0.0439675f
C214 gp.0.n36 VSS 0.14507f
C215 gn.0.t0 VSS 0.0598493f
C216 gn.0.n0 VSS 0.163908f
C217 gn.0.t34 VSS 2.46245f
C218 gn.0.n1 VSS 0.0938639f
C219 gn.0.n2 VSS 0.0480096f
C220 gn.0.n3 VSS 0.210217f
C221 gn.0.t33 VSS 1.25891f
C222 gn.0.n4 VSS 0.689737f
C223 gn.0.n5 VSS 0.538732f
C224 gn.0.t32 VSS 0.0446507f
C225 gn.0.t31 VSS 0.0440423f
C226 gn.0.n6 VSS 0.0671624f
C227 gn.0.t30 VSS 0.0440423f
C228 gn.0.n7 VSS 0.0351331f
C229 gn.0.t29 VSS 0.0440423f
C230 gn.0.n8 VSS 0.0351331f
C231 gn.0.t28 VSS 0.0440423f
C232 gn.0.n9 VSS 0.0351331f
C233 gn.0.t27 VSS 0.0440423f
C234 gn.0.n10 VSS 0.0351331f
C235 gn.0.t26 VSS 0.0440423f
C236 gn.0.n11 VSS 0.0351331f
C237 gn.0.t25 VSS 0.0440423f
C238 gn.0.n12 VSS 0.0351331f
C239 gn.0.t24 VSS 0.0440423f
C240 gn.0.n13 VSS 0.0351331f
C241 gn.0.t23 VSS 0.0440423f
C242 gn.0.n14 VSS 0.0351331f
C243 gn.0.t22 VSS 0.0440423f
C244 gn.0.n15 VSS 0.0351331f
C245 gn.0.t21 VSS 0.0440423f
C246 gn.0.n16 VSS 0.0351331f
C247 gn.0.t20 VSS 0.0440423f
C248 gn.0.n17 VSS 0.0351331f
C249 gn.0.t19 VSS 0.0440423f
C250 gn.0.n18 VSS 0.0351331f
C251 gn.0.t18 VSS 0.0440423f
C252 gn.0.n19 VSS 0.0351331f
C253 gn.0.t17 VSS 0.0440423f
C254 gn.0.n20 VSS 0.0351331f
C255 gn.0.t16 VSS 0.0440423f
C256 gn.0.n21 VSS 0.0338478f
C257 gn.0.t15 VSS 0.0440423f
C258 gn.0.n22 VSS 0.0264267f
C259 gn.0.t14 VSS 0.0440423f
C260 gn.0.n23 VSS 0.0351331f
C261 gn.0.t13 VSS 0.0440423f
C262 gn.0.n24 VSS 0.0351331f
C263 gn.0.t12 VSS 0.0440423f
C264 gn.0.n25 VSS 0.0351331f
C265 gn.0.t11 VSS 0.0440423f
C266 gn.0.n26 VSS 0.164313f
C267 gn.0.t10 VSS 0.0561044f
C268 gn.0.t9 VSS 0.055169f
C269 gn.0.n27 VSS 0.0772f
C270 gn.0.t8 VSS 0.055169f
C271 gn.0.n28 VSS 0.040497f
C272 gn.0.t7 VSS 0.055169f
C273 gn.0.n29 VSS 0.040497f
C274 gn.0.t6 VSS 0.055169f
C275 gn.0.n30 VSS 0.040497f
C276 gn.0.t5 VSS 0.055169f
C277 gn.0.n31 VSS 0.040497f
C278 gn.0.t4 VSS 0.055169f
C279 gn.0.n32 VSS 0.0382173f
C280 gn.0.t3 VSS 0.055169f
C281 gn.0.n33 VSS 0.0317022f
C282 gn.0.t2 VSS 0.055169f
C283 gn.0.n34 VSS 0.040497f
C284 gn.0.t1 VSS 0.055169f
C285 gn.0.n35 VSS 0.101785f
C286 gn.0.n36 VSS 0.0107833f
C287 fb.0.t14 VSS 0.014658f
C288 fb.0.n0 VSS 0.0316656f
C289 fb.0.t11 VSS 0.014658f
C290 fb.0.t12 VSS 0.014658f
C291 fb.0.n1 VSS 0.0316656f
C292 fb.0.n2 VSS 0.0825524f
C293 fb.0.t9 VSS 0.014658f
C294 fb.0.t10 VSS 0.014658f
C295 fb.0.n3 VSS 0.0316656f
C296 fb.0.n4 VSS 0.0636937f
C297 fb.0.t7 VSS 0.014658f
C298 fb.0.t8 VSS 0.014658f
C299 fb.0.n5 VSS 0.0316656f
C300 fb.0.n6 VSS 0.0636937f
C301 fb.0.t5 VSS 0.014658f
C302 fb.0.t6 VSS 0.014658f
C303 fb.0.n7 VSS 0.0316656f
C304 fb.0.n8 VSS 0.121047f
C305 fb.0.t3 VSS 0.014658f
C306 fb.0.t4 VSS 0.014658f
C307 fb.0.n9 VSS 0.0316656f
C308 fb.0.t55 VSS 0.0778902f
C309 fb.0.n10 VSS 0.0459426f
C310 fb.0.t53 VSS 0.0281429f
C311 fb.0.t54 VSS 0.0281429f
C312 fb.0.n11 VSS 0.064511f
C313 fb.0.n12 VSS 0.0522445f
C314 fb.0.t51 VSS 0.0281429f
C315 fb.0.t52 VSS 0.0281429f
C316 fb.0.n13 VSS 0.064511f
C317 fb.0.n14 VSS 0.0522445f
C318 fb.0.t49 VSS 0.0281429f
C319 fb.0.t50 VSS 0.0281429f
C320 fb.0.n15 VSS 0.064511f
C321 fb.0.n16 VSS 0.0522445f
C322 fb.0.t47 VSS 0.0281429f
C323 fb.0.t48 VSS 0.0281429f
C324 fb.0.n17 VSS 0.064511f
C325 fb.0.n18 VSS 0.0522445f
C326 fb.0.t45 VSS 0.0281429f
C327 fb.0.t46 VSS 0.0281429f
C328 fb.0.n19 VSS 0.064511f
C329 fb.0.n20 VSS 0.0522445f
C330 fb.0.t32 VSS 0.0281429f
C331 fb.0.t44 VSS 0.0281429f
C332 fb.0.n21 VSS 0.064511f
C333 fb.0.n22 VSS 0.0522445f
C334 fb.0.t62 VSS 0.0281429f
C335 fb.0.t33 VSS 0.0281429f
C336 fb.0.n23 VSS 0.064511f
C337 fb.0.n24 VSS 0.0522445f
C338 fb.0.t23 VSS 0.0281429f
C339 fb.0.t19 VSS 0.0281429f
C340 fb.0.n25 VSS 0.064511f
C341 fb.0.n26 VSS 0.0522445f
C342 fb.0.t21 VSS 0.0281429f
C343 fb.0.t20 VSS 0.0281429f
C344 fb.0.n27 VSS 0.064511f
C345 fb.0.n28 VSS 0.0522445f
C346 fb.0.t22 VSS 0.0281429f
C347 fb.0.t63 VSS 0.0281429f
C348 fb.0.n29 VSS 0.064511f
C349 fb.0.n30 VSS 0.0522445f
C350 fb.0.t57 VSS 0.0281429f
C351 fb.0.t56 VSS 0.0281429f
C352 fb.0.n31 VSS 0.064511f
C353 fb.0.t16 VSS 0.0281429f
C354 fb.0.t58 VSS 0.0281429f
C355 fb.0.n32 VSS 0.064511f
C356 fb.0.n33 VSS 0.0522445f
C357 fb.0.t18 VSS 0.0281429f
C358 fb.0.t17 VSS 0.0281429f
C359 fb.0.n34 VSS 0.064511f
C360 fb.0.n35 VSS 0.0522445f
C361 fb.0.t1 VSS 0.0281429f
C362 fb.0.t0 VSS 0.0281429f
C363 fb.0.n36 VSS 0.064511f
C364 fb.0.n37 VSS 0.0522445f
C365 fb.0.t59 VSS 0.0281429f
C366 fb.0.t2 VSS 0.0281429f
C367 fb.0.n38 VSS 0.064511f
C368 fb.0.n39 VSS 0.0522445f
C369 fb.0.t61 VSS 0.0281429f
C370 fb.0.t60 VSS 0.0281429f
C371 fb.0.n40 VSS 0.064511f
C372 fb.0.n41 VSS 0.0522445f
C373 fb.0.t43 VSS 0.0281429f
C374 fb.0.t15 VSS 0.0281429f
C375 fb.0.n42 VSS 0.064511f
C376 fb.0.n43 VSS 0.0522445f
C377 fb.0.t41 VSS 0.0281429f
C378 fb.0.t42 VSS 0.0281429f
C379 fb.0.n44 VSS 0.064511f
C380 fb.0.n45 VSS 0.0522445f
C381 fb.0.t39 VSS 0.0281429f
C382 fb.0.t40 VSS 0.0281429f
C383 fb.0.n46 VSS 0.064511f
C384 fb.0.n47 VSS 0.0522445f
C385 fb.0.t37 VSS 0.0281429f
C386 fb.0.t38 VSS 0.0281429f
C387 fb.0.n48 VSS 0.064511f
C388 fb.0.n49 VSS 0.0522445f
C389 fb.0.t35 VSS 0.0281429f
C390 fb.0.t36 VSS 0.0281429f
C391 fb.0.n50 VSS 0.064511f
C392 fb.0.n51 VSS 0.0802213f
C393 fb.0.t34 VSS 0.0778902f
C394 fb.0.t31 VSS 0.0265016f
C395 fb.0.t24 VSS 0.0265016f
C396 fb.0.n52 VSS 0.0559216f
C397 fb.0.n53 VSS 0.0419165f
C398 fb.0.t29 VSS 0.0265016f
C399 fb.0.t30 VSS 0.0265016f
C400 fb.0.n54 VSS 0.0559216f
C401 fb.0.n55 VSS 0.0253385f
C402 fb.0.t27 VSS 0.0265016f
C403 fb.0.t28 VSS 0.0265016f
C404 fb.0.n56 VSS 0.0559216f
C405 fb.0.n57 VSS 0.0451589f
C406 fb.0.t25 VSS 0.0265016f
C407 fb.0.t26 VSS 0.0265016f
C408 fb.0.n58 VSS 0.0559216f
C409 fb.0.n59 VSS 0.0696264f
C410 fb.0.n60 VSS 0.0790549f
C411 fb.0.t13 VSS 0.014658f
C412 fa.0.t13 VSS 0.016211f
C413 fa.0.n0 VSS 0.0350211f
C414 fa.0.t11 VSS 0.016211f
C415 fa.0.t12 VSS 0.016211f
C416 fa.0.n1 VSS 0.0350211f
C417 fa.0.n2 VSS 0.133869f
C418 fa.0.t9 VSS 0.016211f
C419 fa.0.t10 VSS 0.016211f
C420 fa.0.n3 VSS 0.0350211f
C421 fa.0.n4 VSS 0.091297f
C422 fa.0.t7 VSS 0.016211f
C423 fa.0.t8 VSS 0.016211f
C424 fa.0.n5 VSS 0.0350211f
C425 fa.0.t5 VSS 0.016211f
C426 fa.0.t6 VSS 0.016211f
C427 fa.0.n6 VSS 0.0350211f
C428 fa.0.n7 VSS 0.091297f
C429 fa.0.t3 VSS 0.016211f
C430 fa.0.t4 VSS 0.016211f
C431 fa.0.n8 VSS 0.0350211f
C432 fa.0.n9 VSS 0.091297f
C433 fa.0.t28 VSS 0.016211f
C434 fa.0.t2 VSS 0.016211f
C435 fa.0.n10 VSS 0.0350211f
C436 fa.0.n11 VSS 0.0768049f
C437 fa.0.t41 VSS 0.0311234f
C438 fa.0.t42 VSS 0.0311234f
C439 fa.0.n12 VSS 0.0713447f
C440 fa.0.n13 VSS 0.0572484f
C441 fa.0.t43 VSS 0.0311234f
C442 fa.0.t44 VSS 0.0311234f
C443 fa.0.n14 VSS 0.0713447f
C444 fa.0.n15 VSS 0.057778f
C445 fa.0.t45 VSS 0.0311234f
C446 fa.0.t46 VSS 0.0311234f
C447 fa.0.n16 VSS 0.0713447f
C448 fa.0.n17 VSS 0.057778f
C449 fa.0.t47 VSS 0.0311234f
C450 fa.0.t48 VSS 0.0311234f
C451 fa.0.n18 VSS 0.0713447f
C452 fa.0.n19 VSS 0.057778f
C453 fa.0.t49 VSS 0.0311234f
C454 fa.0.t50 VSS 0.0311234f
C455 fa.0.n20 VSS 0.0713447f
C456 fa.0.n21 VSS 0.057778f
C457 fa.0.t20 VSS 0.0311234f
C458 fa.0.t39 VSS 0.0311234f
C459 fa.0.n22 VSS 0.0713447f
C460 fa.0.n23 VSS 0.057778f
C461 fa.0.t38 VSS 0.0311234f
C462 fa.0.t22 VSS 0.0311234f
C463 fa.0.n24 VSS 0.0713447f
C464 fa.0.n25 VSS 0.057778f
C465 fa.0.t17 VSS 0.0311234f
C466 fa.0.t23 VSS 0.0311234f
C467 fa.0.n26 VSS 0.0713447f
C468 fa.0.n27 VSS 0.057778f
C469 fa.0.t21 VSS 0.0311234f
C470 fa.0.t65 VSS 0.0311234f
C471 fa.0.n28 VSS 0.0713447f
C472 fa.0.n29 VSS 0.057778f
C473 fa.0.t40 VSS 0.0311234f
C474 fa.0.t63 VSS 0.0311234f
C475 fa.0.n30 VSS 0.0713447f
C476 fa.0.n31 VSS 0.057778f
C477 fa.0.t64 VSS 0.0311234f
C478 fa.0.t37 VSS 0.0311234f
C479 fa.0.n32 VSS 0.0713447f
C480 fa.0.n33 VSS 0.0452687f
C481 fa.0.t18 VSS 0.0311234f
C482 fa.0.t24 VSS 0.0311234f
C483 fa.0.n34 VSS 0.0713447f
C484 fa.0.n35 VSS 0.0452687f
C485 fa.0.t26 VSS 0.0311234f
C486 fa.0.t1 VSS 0.0311234f
C487 fa.0.n36 VSS 0.0713447f
C488 fa.0.n37 VSS 0.057778f
C489 fa.0.t16 VSS 0.0311234f
C490 fa.0.t19 VSS 0.0311234f
C491 fa.0.n38 VSS 0.0713447f
C492 fa.0.n39 VSS 0.057778f
C493 fa.0.t14 VSS 0.0311234f
C494 fa.0.t0 VSS 0.0311234f
C495 fa.0.n40 VSS 0.0713447f
C496 fa.0.n41 VSS 0.057778f
C497 fa.0.t25 VSS 0.0311234f
C498 fa.0.t15 VSS 0.0311234f
C499 fa.0.n42 VSS 0.0713447f
C500 fa.0.n43 VSS 0.057778f
C501 fa.0.t51 VSS 0.0311234f
C502 fa.0.t52 VSS 0.0311234f
C503 fa.0.n44 VSS 0.0713447f
C504 fa.0.n45 VSS 0.057778f
C505 fa.0.t53 VSS 0.0311234f
C506 fa.0.t54 VSS 0.0311234f
C507 fa.0.n46 VSS 0.0713447f
C508 fa.0.n47 VSS 0.057778f
C509 fa.0.t55 VSS 0.0311234f
C510 fa.0.t56 VSS 0.0311234f
C511 fa.0.n48 VSS 0.0713447f
C512 fa.0.n49 VSS 0.057778f
C513 fa.0.t57 VSS 0.0311234f
C514 fa.0.t58 VSS 0.0311234f
C515 fa.0.n50 VSS 0.0713447f
C516 fa.0.n51 VSS 0.057778f
C517 fa.0.t59 VSS 0.0311234f
C518 fa.0.t60 VSS 0.0311234f
C519 fa.0.n52 VSS 0.0713447f
C520 fa.0.n53 VSS 0.0887186f
C521 fa.0.t61 VSS 0.0311234f
C522 fa.0.t62 VSS 0.0311234f
C523 fa.0.n54 VSS 0.0713447f
C524 fa.0.t30 VSS 0.0293084f
C525 fa.0.t31 VSS 0.0293084f
C526 fa.0.n55 VSS 0.0618454f
C527 fa.0.n56 VSS 0.0499222f
C528 fa.0.t32 VSS 0.0293084f
C529 fa.0.t33 VSS 0.0293084f
C530 fa.0.n57 VSS 0.0618454f
C531 fa.0.n58 VSS 0.0280229f
C532 fa.0.t34 VSS 0.0293084f
C533 fa.0.t35 VSS 0.0293084f
C534 fa.0.n59 VSS 0.0618454f
C535 fa.0.n60 VSS 0.049943f
C536 fa.0.t36 VSS 0.0293084f
C537 fa.0.t27 VSS 0.0293084f
C538 fa.0.n61 VSS 0.0618454f
C539 fa.0.n62 VSS 0.0794549f
C540 fa.0.t29 VSS 0.016211f
C541 oa.0.t27 VSS 0.0375586f
C542 oa.0.n0 VSS 0.0846803f
C543 oa.0.t24 VSS 0.0375586f
C544 oa.0.t25 VSS 0.0375586f
C545 oa.0.n1 VSS 0.0846803f
C546 oa.0.n2 VSS 0.117513f
C547 oa.0.t2 VSS 0.0375586f
C548 oa.0.t0 VSS 0.0375586f
C549 oa.0.n3 VSS 0.0846803f
C550 oa.0.n4 VSS 0.0772705f
C551 oa.0.t6 VSS 0.0375586f
C552 oa.0.t3 VSS 0.0375586f
C553 oa.0.n5 VSS 0.0846803f
C554 oa.0.n6 VSS 0.0772705f
C555 oa.0.t7 VSS 0.0375586f
C556 oa.0.t17 VSS 0.0375586f
C557 oa.0.n7 VSS 0.0846803f
C558 oa.0.n8 VSS 0.0603216f
C559 oa.0.t5 VSS 0.0375586f
C560 oa.0.t4 VSS 0.0375586f
C561 oa.0.n9 VSS 0.0846803f
C562 oa.0.n10 VSS 0.0603216f
C563 oa.0.t1 VSS 0.0375586f
C564 oa.0.t28 VSS 0.0375586f
C565 oa.0.n11 VSS 0.0846803f
C566 oa.0.n12 VSS 0.0772705f
C567 oa.0.t22 VSS 0.0375586f
C568 oa.0.t23 VSS 0.0375586f
C569 oa.0.n13 VSS 0.0846803f
C570 oa.0.n14 VSS 0.0772705f
C571 oa.0.t20 VSS 0.0375586f
C572 oa.0.t21 VSS 0.0375586f
C573 oa.0.n15 VSS 0.0846803f
C574 oa.0.n16 VSS 0.0772705f
C575 oa.0.t18 VSS 0.0375586f
C576 oa.0.t19 VSS 0.0375586f
C577 oa.0.n17 VSS 0.0846803f
C578 oa.0.n18 VSS 0.0671604f
C579 oa.0.n19 VSS 0.0697379f
C580 oa.0.t30 VSS 0.0979202f
C581 oa.0.n20 VSS 0.115381f
C582 oa.0.t29 VSS 0.0984192f
C583 oa.0.t8 VSS 0.0530773f
C584 oa.0.n21 VSS 0.0974399f
C585 oa.0.t16 VSS 0.0357388f
C586 oa.0.t13 VSS 0.0357388f
C587 oa.0.n22 VSS 0.0754187f
C588 oa.0.n23 VSS 0.0630939f
C589 oa.0.t14 VSS 0.0357388f
C590 oa.0.t15 VSS 0.0357388f
C591 oa.0.n24 VSS 0.0754187f
C592 oa.0.n25 VSS 0.0341725f
C593 oa.0.t11 VSS 0.0357388f
C594 oa.0.t12 VSS 0.0357388f
C595 oa.0.n26 VSS 0.0754187f
C596 oa.0.n27 VSS 0.0609006f
C597 oa.0.t9 VSS 0.0357388f
C598 oa.0.t10 VSS 0.0357388f
C599 oa.0.n28 VSS 0.0754187f
C600 oa.0.t26 VSS 0.0375586f
C601 ob.0.t25 VSS 0.100794f
C602 ob.0.t23 VSS 0.0350496f
C603 ob.0.t24 VSS 0.0350496f
C604 ob.0.n0 VSS 0.0790262f
C605 ob.0.n1 VSS 0.0721099f
C606 ob.0.t6 VSS 0.0350496f
C607 ob.0.t22 VSS 0.0350496f
C608 ob.0.n2 VSS 0.0790262f
C609 ob.0.n3 VSS 0.0721099f
C610 ob.0.t3 VSS 0.0350496f
C611 ob.0.t26 VSS 0.0350496f
C612 ob.0.n4 VSS 0.0790262f
C613 ob.0.n5 VSS 0.0721099f
C614 ob.0.t14 VSS 0.0350496f
C615 ob.0.t15 VSS 0.0350496f
C616 ob.0.n6 VSS 0.0790262f
C617 ob.0.n7 VSS 0.0721099f
C618 ob.0.t28 VSS 0.0350496f
C619 ob.0.t0 VSS 0.0350496f
C620 ob.0.n8 VSS 0.0790262f
C621 ob.0.t4 VSS 0.0350496f
C622 ob.0.t1 VSS 0.0350496f
C623 ob.0.n9 VSS 0.0790262f
C624 ob.0.n10 VSS 0.0721099f
C625 ob.0.t21 VSS 0.0350496f
C626 ob.0.t2 VSS 0.0350496f
C627 ob.0.n11 VSS 0.0790262f
C628 ob.0.n12 VSS 0.0721099f
C629 ob.0.t19 VSS 0.0350496f
C630 ob.0.t20 VSS 0.0350496f
C631 ob.0.n13 VSS 0.0790262f
C632 ob.0.n14 VSS 0.0721099f
C633 ob.0.t17 VSS 0.0350496f
C634 ob.0.t18 VSS 0.0350496f
C635 ob.0.n15 VSS 0.0790262f
C636 ob.0.n16 VSS 0.109666f
C637 ob.0.t16 VSS 0.100794f
C638 ob.0.t5 VSS 0.0333543f
C639 ob.0.t11 VSS 0.0333543f
C640 ob.0.n17 VSS 0.0703821f
C641 ob.0.n18 VSS 0.0548243f
C642 ob.0.t12 VSS 0.0333543f
C643 ob.0.t13 VSS 0.0333543f
C644 ob.0.n19 VSS 0.0703821f
C645 ob.0.n20 VSS 0.0318894f
C646 ob.0.t8 VSS 0.0333543f
C647 ob.0.t9 VSS 0.0333543f
C648 ob.0.n21 VSS 0.0703821f
C649 ob.0.n22 VSS 0.0568351f
C650 ob.0.t10 VSS 0.0333543f
C651 ob.0.t7 VSS 0.0333543f
C652 ob.0.n23 VSS 0.0703821f
C653 ob.0.t27 VSS 0.0495332f
C654 ob.0.t30 VSS 0.0918471f
C655 ob.0.t29 VSS 0.0913813f
C656 ob.0.n24 VSS 0.107675f
C657 ob.0.n25 VSS 0.0999603f
C658 ob.0.n26 VSS 0.0243622f
C659 ob.0.n27 VSS 0.0545363f
C660 tn.0.t10 VSS 0.0179291f
C661 tn.0.n0 VSS 0.0370808f
C662 tn.0.t8 VSS 0.0179291f
C663 tn.0.t9 VSS 0.0179291f
C664 tn.0.n1 VSS 0.0370808f
C665 tn.0.n2 VSS 0.054021f
C666 tn.0.t6 VSS 0.0179291f
C667 tn.0.t7 VSS 0.0179291f
C668 tn.0.n3 VSS 0.0370808f
C669 tn.0.n4 VSS 0.0426363f
C670 tn.0.t4 VSS 0.0179291f
C671 tn.0.t5 VSS 0.0179291f
C672 tn.0.n5 VSS 0.0370808f
C673 tn.0.n6 VSS 0.0426363f
C674 tn.0.t2 VSS 0.0179291f
C675 tn.0.t3 VSS 0.0179291f
C676 tn.0.n7 VSS 0.0370808f
C677 tn.0.n8 VSS 0.0844749f
C678 tn.0.t23 VSS 0.0179291f
C679 tn.0.t1 VSS 0.0179291f
C680 tn.0.n9 VSS 0.0370808f
C681 tn.0.t37 VSS 0.0340669f
C682 tn.0.t43 VSS 0.0340669f
C683 tn.0.n10 VSS 0.0681338f
C684 tn.0.n11 VSS 0.0439202f
C685 tn.0.t44 VSS 0.0340669f
C686 tn.0.t38 VSS 0.0340669f
C687 tn.0.n12 VSS 0.0681338f
C688 tn.0.n13 VSS 0.038574f
C689 tn.0.t33 VSS 0.0340669f
C690 tn.0.t45 VSS 0.0340669f
C691 tn.0.n14 VSS 0.0681338f
C692 tn.0.n15 VSS 0.038574f
C693 tn.0.t46 VSS 0.0340669f
C694 tn.0.t34 VSS 0.0340669f
C695 tn.0.n16 VSS 0.0681338f
C696 tn.0.n17 VSS 0.038574f
C697 tn.0.t35 VSS 0.0340669f
C698 tn.0.t39 VSS 0.0340669f
C699 tn.0.n18 VSS 0.0681338f
C700 tn.0.n19 VSS 0.038574f
C701 tn.0.t40 VSS 0.0340669f
C702 tn.0.t36 VSS 0.0340669f
C703 tn.0.n20 VSS 0.0681338f
C704 tn.0.n21 VSS 0.038574f
C705 tn.0.t20 VSS 0.0340669f
C706 tn.0.t11 VSS 0.0340669f
C707 tn.0.n22 VSS 0.0681338f
C708 tn.0.n23 VSS 0.038574f
C709 tn.0.t50 VSS 0.0340669f
C710 tn.0.t22 VSS 0.0340669f
C711 tn.0.n24 VSS 0.0681338f
C712 tn.0.n25 VSS 0.038574f
C713 tn.0.t19 VSS 0.0340669f
C714 tn.0.t16 VSS 0.0340669f
C715 tn.0.n26 VSS 0.0681338f
C716 tn.0.n27 VSS 0.038574f
C717 tn.0.t15 VSS 0.0340669f
C718 tn.0.t51 VSS 0.0340669f
C719 tn.0.n28 VSS 0.0681338f
C720 tn.0.n29 VSS 0.0309949f
C721 tn.0.t14 VSS 0.0340669f
C722 tn.0.t18 VSS 0.0340669f
C723 tn.0.n30 VSS 0.0681338f
C724 tn.0.n31 VSS 0.0309949f
C725 tn.0.t27 VSS 0.0340669f
C726 tn.0.t26 VSS 0.0340669f
C727 tn.0.n32 VSS 0.0681338f
C728 tn.0.n33 VSS 0.038574f
C729 tn.0.t28 VSS 0.0340669f
C730 tn.0.t17 VSS 0.0340669f
C731 tn.0.n34 VSS 0.0681338f
C732 tn.0.n35 VSS 0.038574f
C733 tn.0.t13 VSS 0.0340669f
C734 tn.0.t21 VSS 0.0340669f
C735 tn.0.n36 VSS 0.0681338f
C736 tn.0.n37 VSS 0.038574f
C737 tn.0.t49 VSS 0.0340669f
C738 tn.0.t12 VSS 0.0340669f
C739 tn.0.n38 VSS 0.0681338f
C740 tn.0.n39 VSS 0.038574f
C741 tn.0.t0 VSS 0.0340669f
C742 tn.0.t25 VSS 0.0340669f
C743 tn.0.n40 VSS 0.0681338f
C744 tn.0.n41 VSS 0.038574f
C745 tn.0.t29 VSS 0.0340669f
C746 tn.0.t41 VSS 0.0340669f
C747 tn.0.n42 VSS 0.0681338f
C748 tn.0.n43 VSS 0.038574f
C749 tn.0.t42 VSS 0.0340669f
C750 tn.0.t30 VSS 0.0340669f
C751 tn.0.n44 VSS 0.0681338f
C752 tn.0.n45 VSS 0.038574f
C753 tn.0.t31 VSS 0.0340669f
C754 tn.0.t47 VSS 0.0340669f
C755 tn.0.n46 VSS 0.0681338f
C756 tn.0.n47 VSS 0.0628182f
C757 tn.0.t48 VSS 0.0340669f
C758 tn.0.t32 VSS 0.0340669f
C759 tn.0.n48 VSS 0.0681338f
C760 tn.0.n49 VSS 0.0627097f
C761 tn.0.t24 VSS 0.0179291f
C762 ts.0.t11 VSS 0.0174295f
C763 ts.0.n0 VSS 0.0360356f
C764 ts.0.t9 VSS 0.0174295f
C765 ts.0.t10 VSS 0.0174295f
C766 ts.0.n1 VSS 0.0360356f
C767 ts.0.n2 VSS 0.0820993f
C768 ts.0.t7 VSS 0.0174295f
C769 ts.0.t8 VSS 0.0174295f
C770 ts.0.n3 VSS 0.0360356f
C771 ts.0.n4 VSS 0.052501f
C772 ts.0.t5 VSS 0.0174295f
C773 ts.0.t6 VSS 0.0174295f
C774 ts.0.n5 VSS 0.0360356f
C775 ts.0.t3 VSS 0.0174295f
C776 ts.0.t4 VSS 0.0174295f
C777 ts.0.n6 VSS 0.0360356f
C778 ts.0.n7 VSS 0.052501f
C779 ts.0.t1 VSS 0.0174295f
C780 ts.0.t2 VSS 0.0174295f
C781 ts.0.n8 VSS 0.0360356f
C782 ts.0.n9 VSS 0.052501f
C783 ts.0.t13 VSS 0.0174295f
C784 ts.0.t0 VSS 0.0174295f
C785 ts.0.n10 VSS 0.0360356f
C786 ts.0.n11 VSS 0.050421f
C787 ts.0.t15 VSS 0.0467924f
C788 ts.0.t12 VSS 0.0467924f
C789 ts.0.t14 VSS 0.0174295f
C790 d2a.0.t9 VSS 0.0114145f
C791 d2a.0.n0 VSS 0.0246387f
C792 d2a.0.t6 VSS 0.0114145f
C793 d2a.0.t7 VSS 0.0114145f
C794 d2a.0.n1 VSS 0.0246387f
C795 d2a.0.n2 VSS 0.0354098f
C796 d2a.0.t13 VSS 0.0114145f
C797 d2a.0.t15 VSS 0.0114145f
C798 d2a.0.n3 VSS 0.0246387f
C799 d2a.0.n4 VSS 0.0351218f
C800 d2a.0.t1 VSS 0.0114145f
C801 d2a.0.t5 VSS 0.0114145f
C802 d2a.0.n5 VSS 0.0246387f
C803 d2a.0.n6 VSS 0.0299648f
C804 d2a.0.n7 VSS 0.0263453f
C805 d2a.0.t0 VSS 0.0114145f
C806 d2a.0.t4 VSS 0.0114145f
C807 d2a.0.n8 VSS 0.0236056f
C808 d2a.0.n9 VSS 0.110633f
C809 d2a.0.t32 VSS 0.0178654f
C810 d2a.0.n10 VSS 0.0620346f
C811 d2a.0.t31 VSS 0.0178654f
C812 d2a.0.n11 VSS 0.0325054f
C813 d2a.0.t30 VSS 0.0178654f
C814 d2a.0.n12 VSS 0.0274558f
C815 d2a.0.t29 VSS 0.0178654f
C816 d2a.0.n13 VSS 0.0254369f
C817 d2a.0.t28 VSS 0.0178654f
C818 d2a.0.n14 VSS 0.0325054f
C819 d2a.0.t27 VSS 0.0178654f
C820 d2a.0.n15 VSS 0.0325054f
C821 d2a.0.t26 VSS 0.0178654f
C822 d2a.0.n16 VSS 0.06146f
C823 d2a.0.t25 VSS 0.018536f
C824 d2a.0.t11 VSS 0.0249411f
C825 d2a.0.t3 VSS 0.0249411f
C826 d2a.0.n17 VSS 0.0526376f
C827 d2a.0.n18 VSS 0.0372038f
C828 d2a.0.t2 VSS 0.0249411f
C829 d2a.0.t10 VSS 0.0249411f
C830 d2a.0.n19 VSS 0.0526376f
C831 d2a.0.t12 VSS 0.0178654f
C832 d2a.0.n20 VSS 0.0608954f
C833 d2a.0.t14 VSS 0.0178654f
C834 d2a.0.n21 VSS 0.0395739f
C835 d2a.0.t24 VSS 0.0178654f
C836 d2a.0.n22 VSS 0.0213975f
C837 d2a.0.t23 VSS 0.0178654f
C838 d2a.0.n23 VSS 0.0244267f
C839 d2a.0.t22 VSS 0.0178654f
C840 d2a.0.n24 VSS 0.0244267f
C841 d2a.0.t21 VSS 0.0178654f
C842 d2a.0.n25 VSS 0.0405826f
C843 d2a.0.t16 VSS 0.0178654f
C844 d2a.0.n26 VSS 0.0405826f
C845 d2a.0.t18 VSS 0.0178654f
C846 d2a.0.n27 VSS 0.0458098f
C847 d2a.0.t20 VSS 0.0180302f
C848 d2a.0.n28 VSS 0.0291825f
C849 d2a.0.t17 VSS 0.0114145f
C850 d2a.0.t19 VSS 0.0114145f
C851 d2a.0.n29 VSS 0.0246387f
C852 d2a.0.n30 VSS 0.0702823f
C853 d2a.0.t8 VSS 0.0114145f
C854 sa.0.t0 VSS 0.0706513f
C855 sa.0.t1 VSS 0.0459917f
C856 sa.0.t2 VSS 0.0459917f
C857 sa.0.n0 VSS 0.097064f
C858 rla_m1.0.t0 VSS 0.067471f
C859 rla_m1.0.t1 VSS 0.067471f
C860 rlb_m1.0.t0 VSS 0.064148f
C861 rlb_m1.0.t1 VSS 0.064148f
C862 d2b.0.t15 VSS 0.0152216f
C863 d2b.0.n0 VSS 0.032858f
C864 d2b.0.t5 VSS 0.0152216f
C865 d2b.0.t19 VSS 0.0152216f
C866 d2b.0.n1 VSS 0.032858f
C867 d2b.0.n2 VSS 0.0274329f
C868 d2b.0.t7 VSS 0.0152216f
C869 d2b.0.t6 VSS 0.0152216f
C870 d2b.0.n3 VSS 0.032858f
C871 d2b.0.n4 VSS 0.0801746f
C872 d2b.0.t9 VSS 0.0152216f
C873 d2b.0.t11 VSS 0.0152216f
C874 d2b.0.n5 VSS 0.032858f
C875 d2b.0.t18 VSS 0.0152216f
C876 d2b.0.t0 VSS 0.0152216f
C877 d2b.0.n6 VSS 0.032858f
C878 d2b.0.n7 VSS 0.0530767f
C879 d2b.0.n8 VSS 0.148471f
C880 d2b.0.t25 VSS 0.0238246f
C881 d2b.0.n9 VSS 0.0812098f
C882 d2b.0.t26 VSS 0.0238246f
C883 d2b.0.n10 VSS 0.0433477f
C884 d2b.0.t27 VSS 0.0238246f
C885 d2b.0.n11 VSS 0.0393091f
C886 d2b.0.t28 VSS 0.0238246f
C887 d2b.0.n12 VSS 0.0420007f
C888 d2b.0.t29 VSS 0.0238246f
C889 d2b.0.n13 VSS 0.0433477f
C890 d2b.0.t30 VSS 0.0238246f
C891 d2b.0.n14 VSS 0.0433477f
C892 d2b.0.t31 VSS 0.0238246f
C893 d2b.0.n15 VSS 0.0718647f
C894 d2b.0.t32 VSS 0.0240456f
C895 d2b.0.t2 VSS 0.0332605f
C896 d2b.0.t16 VSS 0.0332605f
C897 d2b.0.n16 VSS 0.0701967f
C898 d2b.0.n17 VSS 0.0496127f
C899 d2b.0.t17 VSS 0.0332605f
C900 d2b.0.t3 VSS 0.0332605f
C901 d2b.0.n18 VSS 0.0701967f
C902 d2b.0.t1 VSS 0.0152216f
C903 d2b.0.t4 VSS 0.0152216f
C904 d2b.0.n19 VSS 0.0314808f
C905 d2b.0.n20 VSS 0.012979f
C906 d2b.0.t14 VSS 0.0238246f
C907 d2b.0.n21 VSS 0.0990556f
C908 d2b.0.t12 VSS 0.0238246f
C909 d2b.0.n22 VSS 0.0325742f
C910 d2b.0.t20 VSS 0.0238246f
C911 d2b.0.n23 VSS 0.0325742f
C912 d2b.0.t21 VSS 0.0238246f
C913 d2b.0.n24 VSS 0.0312295f
C914 d2b.0.t22 VSS 0.0238246f
C915 d2b.0.n25 VSS 0.0500803f
C916 d2b.0.t23 VSS 0.0238246f
C917 d2b.0.n26 VSS 0.0325742f
C918 d2b.0.t10 VSS 0.0238246f
C919 d2b.0.n27 VSS 0.0325742f
C920 d2b.0.t8 VSS 0.0238246f
C921 d2b.0.n28 VSS 0.0819636f
C922 d2b.0.t24 VSS 0.0247203f
C923 d2b.0.n29 VSS 0.0389159f
C924 d2b.0.n30 VSS 0.0538165f
C925 d2b.0.t13 VSS 0.0152216f
C926 sb.0.t0 VSS 0.0710901f
C927 sb.0.t1 VSS 0.0462809f
C928 sb.0.t2 VSS 0.0462809f
C929 sb.0.n0 VSS 0.0976742f
C930 n3a.0.t1 VSS 0.0222927f
C931 n3a.0.n0 VSS 0.0481215f
C932 n3a.0.t4 VSS 0.0222927f
C933 n3a.0.t3 VSS 0.0222927f
C934 n3a.0.n1 VSS 0.0481215f
C935 n3a.0.n2 VSS 0.136622f
C936 n3a.0.t6 VSS 0.0222927f
C937 n3a.0.t5 VSS 0.0222927f
C938 n3a.0.n3 VSS 0.0481215f
C939 n3a.0.t8 VSS 0.0222927f
C940 n3a.0.t7 VSS 0.0222927f
C941 n3a.0.n4 VSS 0.0481215f
C942 n3a.0.n5 VSS 0.087802f
C943 n3a.0.t0 VSS 0.0222927f
C944 n3a.0.t9 VSS 0.0222927f
C945 n3a.0.n6 VSS 0.0481215f
C946 n3a.0.n7 VSS 0.0969816f
C947 n3a.0.t11 VSS 0.0288713f
C948 n3a.0.t13 VSS 0.0288713f
C949 n3a.0.n8 VSS 0.0577386f
C950 n3a.0.t10 VSS 0.045364f
C951 n3a.0.n9 VSS 0.043903f
C952 n3a.0.t12 VSS 0.045364f
C953 n3a.0.n10 VSS 0.0513968f
C954 n3a.0.t15 VSS 0.045364f
C955 n3a.0.n11 VSS 0.0968812f
C956 n3a.0.t14 VSS 0.045657f
C957 n3a.0.n12 VSS 0.0249619f
C958 n3a.0.t2 VSS 0.0222927f
C959 d3.0.t0 VSS 0.0203515f
C960 d3.0.n0 VSS 0.0439299f
C961 d3.0.t6 VSS 0.0203515f
C962 d3.0.t2 VSS 0.0203515f
C963 d3.0.n1 VSS 0.0439299f
C964 d3.0.n2 VSS 0.0631359f
C965 d3.0.t8 VSS 0.0203515f
C966 d3.0.t7 VSS 0.0203515f
C967 d3.0.n3 VSS 0.0439299f
C968 d3.0.n4 VSS 0.107705f
C969 d3.0.t3 VSS 0.0203515f
C970 d3.0.t9 VSS 0.0203515f
C971 d3.0.n5 VSS 0.0439299f
C972 d3.0.n6 VSS 0.120241f
C973 d3.0.t10 VSS 0.0485842f
C974 d3.0.t11 VSS 0.0323557f
C975 d3.0.n7 VSS 0.188736f
C976 d3.0.t5 VSS 0.0263572f
C977 d3.0.t4 VSS 0.0263572f
C978 d3.0.n8 VSS 0.0568086f
C979 d3.0.n9 VSS 0.0783273f
C980 d3.0.t1 VSS 0.0203515f
C981 nd.0.t1 VSS 0.0266707f
C982 nd.0.n0 VSS 0.0557887f
C983 nd.0.t0 VSS 0.0266707f
C984 nd.0.t4 VSS 0.0266707f
C985 nd.0.n1 VSS 0.0557887f
C986 nd.0.n2 VSS 0.0383153f
C987 nd.0.n3 VSS 0.043745f
C988 nd.0.t2 VSS 0.0177805f
C989 nd.0.t5 VSS 0.0177805f
C990 nd.0.n4 VSS 0.0379425f
C991 nd.0.t7 VSS 0.021276f
C992 nd.0.n5 VSS 0.0613018f
C993 nd.0.t6 VSS 0.0523765f
C994 nd.0.t3 VSS 0.0266707f
C995 nm.0.t0 VSS 0.0315017f
C996 nm.0.n0 VSS 0.0630033f
C997 nm.0.t1 VSS 0.0315017f
C998 i1.0.t1 VSS 0.0124723f
C999 i1.0.n0 VSS 0.0254838f
C1000 i1.0.n1 VSS 0.0144036f
C1001 i1.0.n2 VSS 0.0257769f
C1002 i1.0.n3 VSS 0.0727091f
C1003 i1.0.t5 VSS 0.0492718f
C1004 i1.0.n4 VSS 0.0844277f
C1005 i1.0.t4 VSS 0.0494654f
C1006 i1.0.t6 VSS 0.0396362f
C1007 i1.0.t0 VSS 0.0307595f
C1008 i1.0.t2 VSS 0.0307595f
C1009 i1.0.n5 VSS 0.0644605f
C1010 i1.0.t3 VSS 0.0124723f
C1011 i2.0.t1 VSS 0.0312037f
C1012 i2.0.n0 VSS 0.0660576f
C1013 i2.0.t0 VSS 0.0312037f
C1014 i2.0.t2 VSS 0.0312037f
C1015 i2.0.n1 VSS 0.0660576f
C1016 i2.0.n2 VSS 0.0357753f
C1017 i2.0.n3 VSS 0.0219193f
C1018 i2.0.t4 VSS 0.0249612f
C1019 i2.0.t3 VSS 0.0249612f
C1020 i2.0.n4 VSS 0.0518533f
C1021 i2.0.n5 VSS 0.0304851f
C1022 i2.0.t9 VSS 0.0660223f
C1023 i2.0.n6 VSS 0.0449848f
C1024 i2.0.t8 VSS 0.0660223f
C1025 i2.0.n7 VSS 0.0494021f
C1026 i2.0.t7 VSS 0.0660223f
C1027 i2.0.n8 VSS 0.0944266f
C1028 i2.0.t6 VSS 0.0661987f
C1029 i2.0.t11 VSS 0.0526512f
C1030 i2.0.n9 VSS 0.0856095f
C1031 i2.0.t10 VSS 0.0528408f
C1032 i2.0.t5 VSS 0.0312037f
C1033 VDD.n0 VSS 0.688421f
C1034 VDD.n1 VSS 0.688421f
C1035 VDD.n2 VSS 0.113401f
C1036 VDD.n3 VSS 0.0922062f
C1037 VDD.n4 VSS 0.673984f
C1038 VDD.n5 VSS 0.673984f
C1039 VDD.t13 VSS 0.552162f
C1040 VDD.t175 VSS 0.351572f
C1041 VDD.t173 VSS 0.351572f
C1042 VDD.t171 VSS 0.351572f
C1043 VDD.t169 VSS 0.351572f
C1044 VDD.t167 VSS 0.351572f
C1045 VDD.t165 VSS 0.351572f
C1046 VDD.t163 VSS 0.351572f
C1047 VDD.t161 VSS 0.351572f
C1048 VDD.t159 VSS 0.351572f
C1049 VDD.t157 VSS 0.351572f
C1050 VDD.t155 VSS 0.26368f
C1051 VDD.t10 VSS 0.552162f
C1052 VDD.t133 VSS 0.351572f
C1053 VDD.t135 VSS 0.351572f
C1054 VDD.t137 VSS 0.351572f
C1055 VDD.t139 VSS 0.351572f
C1056 VDD.t141 VSS 0.351572f
C1057 VDD.t143 VSS 0.351572f
C1058 VDD.t145 VSS 0.351572f
C1059 VDD.t147 VSS 0.351572f
C1060 VDD.t149 VSS 0.351572f
C1061 VDD.t151 VSS 0.351572f
C1062 VDD.t153 VSS 0.26368f
C1063 VDD.t12 VSS 0.0961668f
C1064 VDD.n6 VSS 0.171942f
C1065 VDD.t9 VSS 0.0961668f
C1066 VDD.t11 VSS 0.0425981f
C1067 VDD.n7 VSS 0.232553f
C1068 VDD.n8 VSS 0.3709f
C1069 VDD.n9 VSS 0.3709f
C1070 VDD.n10 VSS 0.0569029f
C1071 VDD.t95 VSS 0.540223f
C1072 VDD.n13 VSS 0.0569029f
C1073 VDD.t56 VSS 0.022131f
C1074 VDD.n14 VSS 0.0158865f
C1075 VDD.t177 VSS 0.022131f
C1076 VDD.n15 VSS 0.0158865f
C1077 VDD.n16 VSS 2.2162f
C1078 VDD.n17 VSS 2.08201f
C1079 VDD.n18 VSS 0.0106543f
C1080 VDD.n19 VSS 0.0213022f
C1081 VDD.n20 VSS 0.285293f
C1082 VDD.n21 VSS 0.0335318f
C1083 VDD.n22 VSS 0.0199799f
C1084 VDD.n23 VSS 0.486768f
C1085 VDD.n24 VSS 0.486768f
C1086 VDD.t52 VSS 0.427278f
C1087 VDD.t119 VSS 0.185039f
C1088 VDD.t188 VSS 0.138778f
C1089 VDD.t51 VSS 0.0264712f
C1090 VDD.n25 VSS 0.07346f
C1091 VDD.t48 VSS 0.0264712f
C1092 VDD.t53 VSS 0.0425791f
C1093 VDD.t120 VSS 0.0164875f
C1094 VDD.t189 VSS 0.0164875f
C1095 VDD.n26 VSS 0.0352717f
C1096 VDD.n27 VSS 0.0217134f
C1097 VDD.t191 VSS 0.0164875f
C1098 VDD.t193 VSS 0.0164875f
C1099 VDD.n28 VSS 0.0352717f
C1100 VDD.n29 VSS 0.0118817f
C1101 VDD.n30 VSS 0.100494f
C1102 VDD.t27 VSS 0.0189803f
C1103 VDD.n31 VSS 0.0496524f
C1104 VDD.n32 VSS 0.0226814f
C1105 VDD.n33 VSS 0.34124f
C1106 VDD.n34 VSS 0.34124f
C1107 VDD.t28 VSS 0.312371f
C1108 VDD.n35 VSS 0.0373342f
C1109 VDD.t29 VSS 0.0229661f
C1110 VDD.t84 VSS 0.00659249f
C1111 VDD.n36 VSS 0.0136342f
C1112 VDD.n37 VSS 0.0167596f
C1113 VDD.n38 VSS 0.118608f
C1114 VDD.n39 VSS 0.187335f
C1115 VDD.n40 VSS 0.216565f
C1116 VDD.n41 VSS 0.00873093f
C1117 VDD.t0 VSS 0.0189803f
C1118 VDD.n42 VSS 0.0496524f
C1119 VDD.n43 VSS 0.0615467f
C1120 VDD.n44 VSS 0.0615467f
C1121 VDD.t17 VSS 0.0163737f
C1122 VDD.n45 VSS 0.0210302f
C1123 VDD.t15 VSS 0.0189803f
C1124 VDD.n46 VSS 0.0225676f
C1125 VDD.n47 VSS 0.15183f
C1126 VDD.t82 VSS 0.00988873f
C1127 VDD.t113 VSS 0.00988873f
C1128 VDD.n48 VSS 0.0206885f
C1129 VDD.t35 VSS 0.0248895f
C1130 VDD.t33 VSS 0.0159624f
C1131 VDD.n49 VSS 0.049393f
C1132 VDD.n50 VSS 0.0668739f
C1133 VDD.n51 VSS 0.0668739f
C1134 VDD.n52 VSS 0.0228839f
C1135 VDD.n53 VSS 0.144604f
C1136 VDD.t6 VSS 0.0107808f
C1137 VDD.n54 VSS 0.385066f
C1138 VDD.t8 VSS 0.0158422f
C1139 VDD.t5 VSS 0.0158422f
C1140 VDD.t3 VSS 0.0107808f
C1141 VDD.n55 VSS 0.0830071f
C1142 VDD.n56 VSS 0.0575546f
C1143 VDD.n57 VSS 0.112718f
C1144 VDD.n58 VSS 0.112718f
C1145 VDD.t7 VSS 0.286767f
C1146 VDD.t125 VSS 0.124169f
C1147 VDD.t104 VSS 0.124169f
C1148 VDD.t184 VSS 0.124169f
C1149 VDD.t123 VSS 0.124169f
C1150 VDD.t121 VSS 0.124169f
C1151 VDD.t182 VSS 0.124169f
C1152 VDD.t180 VSS 0.124169f
C1153 VDD.t102 VSS 0.0931299f
C1154 VDD.n59 VSS 0.0620845f
C1155 VDD.t100 VSS 0.0931299f
C1156 VDD.t178 VSS 0.124169f
C1157 VDD.t65 VSS 0.124169f
C1158 VDD.t98 VSS 0.124169f
C1159 VDD.t96 VSS 0.124169f
C1160 VDD.t63 VSS 0.124169f
C1161 VDD.t61 VSS 0.124169f
C1162 VDD.t93 VSS 0.124169f
C1163 VDD.t4 VSS 0.286767f
C1164 VDD.n60 VSS 0.385066f
C1165 VDD.t94 VSS 0.00659249f
C1166 VDD.t62 VSS 0.00659249f
C1167 VDD.n61 VSS 0.013185f
C1168 VDD.n62 VSS 0.024434f
C1169 VDD.t64 VSS 0.00659249f
C1170 VDD.t97 VSS 0.00659249f
C1171 VDD.n63 VSS 0.013185f
C1172 VDD.n64 VSS 0.0146085f
C1173 VDD.t99 VSS 0.00659249f
C1174 VDD.t66 VSS 0.00659249f
C1175 VDD.n65 VSS 0.013185f
C1176 VDD.n66 VSS 0.0146085f
C1177 VDD.t179 VSS 0.00659249f
C1178 VDD.t101 VSS 0.00659249f
C1179 VDD.n67 VSS 0.013185f
C1180 VDD.n68 VSS 0.0118817f
C1181 VDD.t103 VSS 0.00659249f
C1182 VDD.t181 VSS 0.00659249f
C1183 VDD.n69 VSS 0.013185f
C1184 VDD.n70 VSS 0.0118817f
C1185 VDD.t183 VSS 0.00659249f
C1186 VDD.t122 VSS 0.00659249f
C1187 VDD.n71 VSS 0.013185f
C1188 VDD.n72 VSS 0.0146085f
C1189 VDD.t124 VSS 0.00659249f
C1190 VDD.t185 VSS 0.00659249f
C1191 VDD.n73 VSS 0.013185f
C1192 VDD.n74 VSS 0.0146085f
C1193 VDD.t105 VSS 0.00659249f
C1194 VDD.t126 VSS 0.00659249f
C1195 VDD.n75 VSS 0.013185f
C1196 VDD.n76 VSS 0.0146085f
C1197 VDD.n77 VSS 0.0153487f
C1198 VDD.n78 VSS 0.0465397f
C1199 VDD.n79 VSS 0.0485769f
C1200 VDD.n80 VSS 1.94168f
C1201 VDD.n81 VSS 0.500232f
C1202 VDD.n82 VSS 0.016323f
C1203 VDD.t32 VSS 0.0248895f
C1204 VDD.n83 VSS 0.0232572f
C1205 VDD.t30 VSS 0.0159624f
C1206 VDD.n84 VSS 0.0614518f
C1207 VDD.n85 VSS 0.381997f
C1208 VDD.t31 VSS 0.333604f
C1209 VDD.t112 VSS 0.108346f
C1210 VDD.n86 VSS 0.0722326f
C1211 VDD.t81 VSS 0.108346f
C1212 VDD.t34 VSS 0.333604f
C1213 VDD.n87 VSS 0.381997f
C1214 VDD.n88 VSS 0.017019f
C1215 VDD.n89 VSS 0.0152602f
C1216 VDD.n90 VSS 0.22286f
C1217 VDD.n91 VSS 0.279339f
C1218 VDD.n92 VSS 0.0226814f
C1219 VDD.n93 VSS 0.0495322f
C1220 VDD.n94 VSS 0.34124f
C1221 VDD.t16 VSS 0.312371f
C1222 VDD.t79 VSS 0.158315f
C1223 VDD.t1 VSS 0.312371f
C1224 VDD.n95 VSS 0.34124f
C1225 VDD.n96 VSS 0.0373342f
C1226 VDD.t80 VSS 0.00659249f
C1227 VDD.n97 VSS 0.0136342f
C1228 VDD.t2 VSS 0.0229661f
C1229 VDD.n98 VSS 0.0129319f
C1230 VDD.n99 VSS 0.275897f
C1231 VDD.t38 VSS 0.0312352f
C1232 VDD.n100 VSS 0.174359f
C1233 VDD.n101 VSS 0.012527f
C1234 VDD.n102 VSS 0.0326461f
C1235 VDD.t39 VSS 0.0196256f
C1236 VDD.n103 VSS 0.0625717f
C1237 VDD.n104 VSS 0.0665892f
C1238 VDD.t36 VSS 0.0196256f
C1239 VDD.n105 VSS 0.0625021f
C1240 VDD.n106 VSS 0.0665892f
C1241 VDD.n107 VSS 0.412296f
C1242 VDD.t37 VSS 0.366402f
C1243 VDD.t106 VSS 0.158663f
C1244 VDD.t40 VSS 0.366402f
C1245 VDD.n108 VSS 0.412296f
C1246 VDD.n109 VSS 0.0306405f
C1247 VDD.t41 VSS 0.0434332f
C1248 VDD.t107 VSS 0.012198f
C1249 VDD.n110 VSS 0.0255664f
C1250 VDD.n111 VSS 0.00750987f
C1251 VDD.n112 VSS 0.0248262f
C1252 VDD.n113 VSS 0.0144946f
C1253 VDD.n114 VSS 0.214597f
C1254 VDD.n115 VSS 0.11924f
C1255 VDD.n116 VSS 0.0522338f
C1256 VDD.n117 VSS 0.392411f
C1257 VDD.n118 VSS 0.392411f
C1258 VDD.t22 VSS 0.286767f
C1259 VDD.t129 VSS 0.124169f
C1260 VDD.t127 VSS 0.124169f
C1261 VDD.t116 VSS 0.124169f
C1262 VDD.t77 VSS 0.124169f
C1263 VDD.t75 VSS 0.124169f
C1264 VDD.t67 VSS 0.124169f
C1265 VDD.t69 VSS 0.124169f
C1266 VDD.t131 VSS 0.124169f
C1267 VDD.t87 VSS 0.0931299f
C1268 VDD.t21 VSS 0.0107808f
C1269 VDD.n119 VSS 0.0866703f
C1270 VDD.t18 VSS 0.0107808f
C1271 VDD.n120 VSS 0.0465397f
C1272 VDD.t20 VSS 0.0158422f
C1273 VDD.t23 VSS 0.0158422f
C1274 VDD.t130 VSS 0.00659249f
C1275 VDD.t128 VSS 0.00659249f
C1276 VDD.n121 VSS 0.013185f
C1277 VDD.n122 VSS 0.024434f
C1278 VDD.t117 VSS 0.00659249f
C1279 VDD.t78 VSS 0.00659249f
C1280 VDD.n123 VSS 0.013185f
C1281 VDD.n124 VSS 0.0146085f
C1282 VDD.t76 VSS 0.00659249f
C1283 VDD.t68 VSS 0.00659249f
C1284 VDD.n125 VSS 0.013185f
C1285 VDD.n126 VSS 0.0146085f
C1286 VDD.t70 VSS 0.00659249f
C1287 VDD.t132 VSS 0.00659249f
C1288 VDD.n127 VSS 0.013185f
C1289 VDD.n128 VSS 0.0146085f
C1290 VDD.t88 VSS 0.00659249f
C1291 VDD.t90 VSS 0.00659249f
C1292 VDD.n129 VSS 0.013185f
C1293 VDD.t92 VSS 0.00659249f
C1294 VDD.t72 VSS 0.00659249f
C1295 VDD.n130 VSS 0.013185f
C1296 VDD.n131 VSS 0.0146085f
C1297 VDD.t74 VSS 0.00659249f
C1298 VDD.t111 VSS 0.00659249f
C1299 VDD.n132 VSS 0.013185f
C1300 VDD.n133 VSS 0.0146085f
C1301 VDD.t109 VSS 0.00659249f
C1302 VDD.t115 VSS 0.00659249f
C1303 VDD.n134 VSS 0.013185f
C1304 VDD.n135 VSS 0.0146085f
C1305 VDD.t86 VSS 0.00659249f
C1306 VDD.t60 VSS 0.00659249f
C1307 VDD.n136 VSS 0.013185f
C1308 VDD.n137 VSS 0.024434f
C1309 VDD.n138 VSS 0.119981f
C1310 VDD.t19 VSS 0.286767f
C1311 VDD.t59 VSS 0.124169f
C1312 VDD.t85 VSS 0.124169f
C1313 VDD.t114 VSS 0.124169f
C1314 VDD.t108 VSS 0.124169f
C1315 VDD.t110 VSS 0.124169f
C1316 VDD.t73 VSS 0.124169f
C1317 VDD.t71 VSS 0.124169f
C1318 VDD.t91 VSS 0.124169f
C1319 VDD.t89 VSS 0.0931299f
C1320 VDD.n139 VSS 0.0620845f
C1321 VDD.n140 VSS 0.119981f
C1322 VDD.n141 VSS 0.0612114f
C1323 VDD.n142 VSS 0.462891f
C1324 VDD.t44 VSS 0.0310644f
C1325 VDD.t47 VSS 0.0310644f
C1326 VDD.n143 VSS 0.124568f
C1327 VDD.n144 VSS 0.0345947f
C1328 VDD.t45 VSS 0.0198913f
C1329 VDD.n145 VSS 0.0646279f
C1330 VDD.n146 VSS 0.0703916f
C1331 VDD.t42 VSS 0.0198913f
C1332 VDD.n147 VSS 0.0645646f
C1333 VDD.n148 VSS 0.0703916f
C1334 VDD.n149 VSS 0.418503f
C1335 VDD.t43 VSS 0.368711f
C1336 VDD.t57 VSS 0.119759f
C1337 VDD.n150 VSS 0.0798374f
C1338 VDD.t186 VSS 0.119759f
C1339 VDD.t46 VSS 0.368711f
C1340 VDD.n151 VSS 0.418503f
C1341 VDD.n152 VSS 0.0307481f
C1342 VDD.n153 VSS 0.0152918f
C1343 VDD.t187 VSS 0.0123625f
C1344 VDD.t58 VSS 0.0123625f
C1345 VDD.n154 VSS 0.0261738f
C1346 VDD.n155 VSS 0.0249401f
C1347 VDD.n156 VSS 0.016323f
C1348 VDD.n157 VSS 0.214597f
C1349 VDD.n158 VSS 0.104075f
C1350 VDD.n159 VSS 0.0149059f
C1351 VDD.t26 VSS 0.0163737f
C1352 VDD.t24 VSS 0.0189803f
C1353 VDD.n160 VSS 0.0495322f
C1354 VDD.n161 VSS 0.0210302f
C1355 VDD.n162 VSS 0.0615467f
C1356 VDD.t25 VSS 0.312371f
C1357 VDD.t83 VSS 0.158315f
C1358 VDD.n163 VSS 0.0615467f
C1359 VDD.n164 VSS 0.0225676f
C1360 VDD.n165 VSS 0.488888f
C1361 VDD.n166 VSS 0.564448f
C1362 VDD.n167 VSS 0.015722f
C1363 VDD.t50 VSS 0.0425791f
C1364 VDD.n168 VSS 0.0277555f
C1365 VDD.n169 VSS 0.0734094f
C1366 VDD.n170 VSS 0.0833931f
C1367 VDD.t49 VSS 0.427278f
C1368 VDD.t192 VSS 0.185039f
C1369 VDD.t190 VSS 0.138778f
C1370 VDD.n171 VSS 0.0925162f
C1371 VDD.n172 VSS 0.0833931f
C1372 VDD.n173 VSS 0.0411682f
C1373 VDD.n174 VSS 2.01094f
C1374 VDD.n175 VSS 0.93743f
C1375 VDD.n177 VSS 0.0760856f
C1376 VDD.n178 VSS 0.0106543f
C1377 VDD.n179 VSS 0.207708f
C1378 VDD.n180 VSS 1.32179f
C1379 VDD.n181 VSS 0.0620276f
C1380 VDD.n182 VSS 0.0457931f
C1381 VDD.n183 VSS 0.0476026f
C1382 VDD.n184 VSS 0.499821f
C1383 VDD.n185 VSS 0.499821f
C1384 VDD.n186 VSS 0.0472483f
C1385 VDD.n187 VSS 0.0716632f
C1386 VDD.t54 VSS 0.752277f
C1387 VDD.n190 VSS 0.0716632f
C1388 VDD.n191 VSS 0.0251299f
C1389 VDD.n192 VSS 0.0523856f
C1390 VDD.n193 VSS 1.18614f
C1391 VDD.n194 VSS 1.15975f
C1392 VDD.t14 VSS 0.0425981f
C1393 VDD.n195 VSS 0.0335318f
C1394 VDD.n196 VSS 0.0207834f
C1395 VDD.t176 VSS 0.0164875f
C1396 VDD.t174 VSS 0.0164875f
C1397 VDD.n197 VSS 0.0353033f
C1398 VDD.n198 VSS 0.0248325f
C1399 VDD.t172 VSS 0.0164875f
C1400 VDD.t170 VSS 0.0164875f
C1401 VDD.n199 VSS 0.0353033f
C1402 VDD.n200 VSS 0.0248325f
C1403 VDD.t168 VSS 0.0164875f
C1404 VDD.t166 VSS 0.0164875f
C1405 VDD.n201 VSS 0.0353033f
C1406 VDD.n202 VSS 0.0248325f
C1407 VDD.t164 VSS 0.0164875f
C1408 VDD.t162 VSS 0.0164875f
C1409 VDD.n203 VSS 0.0353033f
C1410 VDD.n204 VSS 0.0248325f
C1411 VDD.t160 VSS 0.0164875f
C1412 VDD.t158 VSS 0.0164875f
C1413 VDD.n205 VSS 0.0353033f
C1414 VDD.n206 VSS 0.0248325f
C1415 VDD.t156 VSS 0.0164875f
C1416 VDD.t154 VSS 0.0164875f
C1417 VDD.n207 VSS 0.0353033f
C1418 VDD.t152 VSS 0.0164875f
C1419 VDD.t150 VSS 0.0164875f
C1420 VDD.n208 VSS 0.0353033f
C1421 VDD.n209 VSS 0.0248325f
C1422 VDD.t148 VSS 0.0164875f
C1423 VDD.t146 VSS 0.0164875f
C1424 VDD.n210 VSS 0.0353033f
C1425 VDD.n211 VSS 0.0248325f
C1426 VDD.t144 VSS 0.0164875f
C1427 VDD.t142 VSS 0.0164875f
C1428 VDD.n212 VSS 0.0353033f
C1429 VDD.n213 VSS 0.0248325f
C1430 VDD.t140 VSS 0.0164875f
C1431 VDD.t138 VSS 0.0164875f
C1432 VDD.n214 VSS 0.0353033f
C1433 VDD.n215 VSS 0.0248325f
C1434 VDD.t136 VSS 0.0164875f
C1435 VDD.t134 VSS 0.0164875f
C1436 VDD.n216 VSS 0.0353033f
C1437 VDD.n217 VSS 0.0248325f
C1438 VDD.n218 VSS 0.232553f
C1439 VDD.n219 VSS 0.0251299f
C1440 VDD.n220 VSS 0.0472483f
C1441 VDD.n221 VSS 0.0716632f
C1442 VDD.t118 VSS 0.752277f
C1443 VDD.n222 VSS 0.0476026f
C1444 VDD.n224 VSS 0.499821f
C1445 VDD.n225 VSS 0.0716632f
C1446 VDD.n227 VSS 0.499821f
C1447 VDD.n228 VSS 0.0457931f
C1448 VDD.n229 VSS 0.0569029f
C1449 VDD.t55 VSS 0.540223f
C1450 VDD.n231 VSS 0.3709f
C1451 VDD.n232 VSS 0.0569029f
C1452 VDD.n234 VSS 0.3709f
C1453 VDD.n235 VSS 0.295321f
C1454 VDD.n236 VSS 0.0620276f
C1455 VDD.n237 VSS 0.0523856f
C1456 VDD.n238 VSS 1.18614f
C1457 VDD.n239 VSS 1.15975f
C1458 VDD.n240 VSS 0.0207834f
C1459 VDD.n241 VSS 0.0277555f
C1460 VDD.n242 VSS 0.17193f
C1461 VDD.n243 VSS 0.227061f
C1462 VDD.n244 VSS 0.175783f
C1463 VDD.n245 VSS 0.227061f
C1464 VDD.n246 VSS 0.173056f
C1465 INP.t0 VSS 0.165716f
C1466 VBP.t21 VSS 0.0574109f
C1467 VBP.t20 VSS 0.0574109f
C1468 VBP.t19 VSS 0.0574109f
C1469 VBP.t18 VSS 0.0574109f
C1470 VBP.t17 VSS 0.0574109f
C1471 VBP.t16 VSS 0.0574109f
C1472 VBP.t15 VSS 0.0574109f
C1473 VBP.t14 VSS 0.0574109f
C1474 VBP.t13 VSS 0.0574109f
C1475 VBP.t12 VSS 0.0574109f
C1476 VBP.t11 VSS 0.0574109f
C1477 VBP.t10 VSS 0.0574109f
C1478 VBP.t9 VSS 0.0574109f
C1479 VBP.t8 VSS 0.0574109f
C1480 VBP.t7 VSS 0.0574109f
C1481 VBP.t6 VSS 0.0574109f
C1482 VBP.t5 VSS 0.0574109f
C1483 VBP.t4 VSS 0.0574109f
C1484 VBP.t3 VSS 0.0574109f
C1485 VBP.t2 VSS 0.0574109f
C1486 VBP.t1 VSS 0.0574109f
C1487 VBP.t0 VSS 0.0580798f
C1488 VBP.n0 VSS 0.0579284f
C1489 VBP.n1 VSS 0.0304499f
C1490 VBP.n2 VSS 0.0304499f
C1491 VBP.n3 VSS 0.0304499f
C1492 VBP.n4 VSS 0.0304499f
C1493 VBP.n5 VSS 0.0304499f
C1494 VBP.n6 VSS 0.0304499f
C1495 VBP.n7 VSS 0.0304499f
C1496 VBP.n8 VSS 0.0304499f
C1497 VBP.n9 VSS 0.0304499f
C1498 VBP.n10 VSS 0.0298426f
C1499 VBP.n11 VSS 0.0283429f
C1500 VBP.n12 VSS 0.0304499f
C1501 VBP.n13 VSS 0.0304499f
C1502 VBP.n14 VSS 0.0304499f
C1503 VBP.n15 VSS 0.0304499f
C1504 VBP.n16 VSS 0.0304499f
C1505 VBP.n17 VSS 0.0304499f
C1506 VBP.n18 VSS 0.0304499f
C1507 VBP.n19 VSS 0.0304499f
C1508 VBP.n20 VSS 0.0429033f
C1509 VBP.n21 VSS 0.155005f
C1510 INN.t0 VSS 0.157965f
C1511 VREF.t20 VSS 0.0627791f
C1512 VREF.t21 VSS 0.0627791f
C1513 VREF.t22 VSS 0.0627791f
C1514 VREF.t23 VSS 0.0627791f
C1515 VREF.t24 VSS 0.0627791f
C1516 VREF.t25 VSS 0.0627791f
C1517 VREF.t26 VSS 0.0627791f
C1518 VREF.t27 VSS 0.0627791f
C1519 VREF.t28 VSS 0.0627791f
C1520 VREF.t29 VSS 0.0627791f
C1521 VREF.t30 VSS 0.0627791f
C1522 VREF.t31 VSS 0.0627791f
C1523 VREF.t32 VSS 0.0627791f
C1524 VREF.t33 VSS 0.0627791f
C1525 VREF.t34 VSS 0.0627791f
C1526 VREF.t35 VSS 0.0627791f
C1527 VREF.t36 VSS 0.0627791f
C1528 VREF.t37 VSS 0.0627791f
C1529 VREF.t38 VSS 0.0627791f
C1530 VREF.t39 VSS 0.0627791f
C1531 VREF.t40 VSS 0.0627791f
C1532 VREF.t41 VSS 0.0627791f
C1533 VREF.t42 VSS 0.0627791f
C1534 VREF.t43 VSS 0.0630124f
C1535 VREF.n0 VSS 0.0773809f
C1536 VREF.n1 VSS 0.0405864f
C1537 VREF.n2 VSS 0.0405864f
C1538 VREF.n3 VSS 0.0405864f
C1539 VREF.n4 VSS 0.0405864f
C1540 VREF.n5 VSS 0.0405864f
C1541 VREF.n6 VSS 0.0405864f
C1542 VREF.n7 VSS 0.0405864f
C1543 VREF.n8 VSS 0.0405864f
C1544 VREF.n9 VSS 0.0405864f
C1545 VREF.n10 VSS 0.0405864f
C1546 VREF.n11 VSS 0.0387795f
C1547 VREF.n12 VSS 0.0376463f
C1548 VREF.n13 VSS 0.0405864f
C1549 VREF.n14 VSS 0.0405864f
C1550 VREF.n15 VSS 0.0405864f
C1551 VREF.n16 VSS 0.0405864f
C1552 VREF.n17 VSS 0.0405864f
C1553 VREF.n18 VSS 0.0405864f
C1554 VREF.n19 VSS 0.0405864f
C1555 VREF.n20 VSS 0.0405864f
C1556 VREF.n21 VSS 0.0405864f
C1557 VREF.n22 VSS 0.0634142f
C1558 VREF.t0 VSS 0.0786392f
C1559 VREF.t1 VSS 0.0786392f
C1560 VREF.t2 VSS 0.0786392f
C1561 VREF.t3 VSS 0.0786392f
C1562 VREF.t4 VSS 0.0786392f
C1563 VREF.t5 VSS 0.0786392f
C1564 VREF.t6 VSS 0.0786392f
C1565 VREF.t7 VSS 0.0790025f
C1566 VREF.n23 VSS 0.0899666f
C1567 VREF.n24 VSS 0.0472028f
C1568 VREF.n25 VSS 0.0472028f
C1569 VREF.n26 VSS 0.0439523f
C1570 VREF.n27 VSS 0.0451914f
C1571 VREF.n28 VSS 0.0472028f
C1572 VREF.n29 VSS 0.0671074f
C1573 VREF.n30 VSS 0.232066f
C1574 VREF.t63 VSS 0.0627791f
C1575 VREF.t62 VSS 0.0627791f
C1576 VREF.t61 VSS 0.0627791f
C1577 VREF.t60 VSS 0.0627791f
C1578 VREF.t59 VSS 0.0627791f
C1579 VREF.t58 VSS 0.0627791f
C1580 VREF.t57 VSS 0.0627791f
C1581 VREF.t56 VSS 0.0627791f
C1582 VREF.t55 VSS 0.0627791f
C1583 VREF.t54 VSS 0.0627791f
C1584 VREF.t53 VSS 0.0627791f
C1585 VREF.t52 VSS 0.0627791f
C1586 VREF.t51 VSS 0.0627791f
C1587 VREF.t50 VSS 0.0627791f
C1588 VREF.t49 VSS 0.0627791f
C1589 VREF.t48 VSS 0.0627791f
C1590 VREF.t47 VSS 0.0627791f
C1591 VREF.t46 VSS 0.0627791f
C1592 VREF.t45 VSS 0.0627791f
C1593 VREF.t44 VSS 0.0630124f
C1594 VREF.n31 VSS 0.0773809f
C1595 VREF.n32 VSS 0.0405864f
C1596 VREF.n33 VSS 0.0405864f
C1597 VREF.n34 VSS 0.0405864f
C1598 VREF.n35 VSS 0.0405864f
C1599 VREF.n36 VSS 0.0405864f
C1600 VREF.n37 VSS 0.0405864f
C1601 VREF.n38 VSS 0.0405864f
C1602 VREF.n39 VSS 0.0405864f
C1603 VREF.n40 VSS 0.0387554f
C1604 VREF.n41 VSS 0.0376703f
C1605 VREF.n42 VSS 0.0405864f
C1606 VREF.n43 VSS 0.0405864f
C1607 VREF.n44 VSS 0.0405864f
C1608 VREF.n45 VSS 0.0405864f
C1609 VREF.n46 VSS 0.0405864f
C1610 VREF.n47 VSS 0.0405864f
C1611 VREF.n48 VSS 0.0405864f
C1612 VREF.n49 VSS 0.0634142f
C1613 VREF.n50 VSS 0.300482f
C1614 VREF.t19 VSS 0.0786392f
C1615 VREF.t18 VSS 0.0786392f
C1616 VREF.t17 VSS 0.0786392f
C1617 VREF.t16 VSS 0.0786392f
C1618 VREF.t15 VSS 0.0786392f
C1619 VREF.t14 VSS 0.0786392f
C1620 VREF.t13 VSS 0.0786392f
C1621 VREF.t12 VSS 0.0786392f
C1622 VREF.t11 VSS 0.0786392f
C1623 VREF.t10 VSS 0.0786392f
C1624 VREF.t9 VSS 0.0786392f
C1625 VREF.t8 VSS 0.0790025f
C1626 VREF.n51 VSS 0.0899666f
C1627 VREF.n52 VSS 0.0472028f
C1628 VREF.n53 VSS 0.0472028f
C1629 VREF.n54 VSS 0.0472028f
C1630 VREF.n55 VSS 0.0472028f
C1631 VREF.n56 VSS 0.0439523f
C1632 VREF.n57 VSS 0.0451914f
C1633 VREF.n58 VSS 0.0472028f
C1634 VREF.n59 VSS 0.0472028f
C1635 VREF.n60 VSS 0.0472028f
C1636 VREF.n61 VSS 0.0671074f
C1637 VREF.n62 VSS 0.323009f
C1638 VB2.t0 VSS 0.128962f
C1639 VB2.t1 VSS 0.128962f
C1640 VB2.t2 VSS 0.128962f
C1641 VB2.t3 VSS 0.128962f
C1642 VB2.t4 VSS 0.128962f
C1643 VB2.t5 VSS 0.128962f
C1644 VB2.t6 VSS 0.129595f
C1645 VB2.n0 VSS 0.150791f
C1646 VB2.n1 VSS 0.0792256f
C1647 VB2.n2 VSS 0.0792256f
C1648 VB2.n3 VSS 0.0735739f
C1649 VB2.n4 VSS 0.0758021f
C1650 VB2.n5 VSS 0.129634f
C1651 VB2.t13 VSS 0.128962f
C1652 VB2.t12 VSS 0.128962f
C1653 VB2.t11 VSS 0.128962f
C1654 VB2.t10 VSS 0.128962f
C1655 VB2.t9 VSS 0.128962f
C1656 VB2.t8 VSS 0.128962f
C1657 VB2.t7 VSS 0.129595f
C1658 VB2.n6 VSS 0.150791f
C1659 VB2.n7 VSS 0.0792256f
C1660 VB2.n8 VSS 0.0792256f
C1661 VB2.n9 VSS 0.0735739f
C1662 VB2.n10 VSS 0.0758021f
C1663 VB2.n11 VSS 0.129634f
C1664 VB2.n12 VSS 0.773407f
C1665 VBN.t0 VSS 0.0599383f
C1666 VBN.t1 VSS 0.0599383f
C1667 VBN.t2 VSS 0.0599383f
C1668 VBN.t3 VSS 0.0599383f
C1669 VBN.t4 VSS 0.0599383f
C1670 VBN.t5 VSS 0.0599383f
C1671 VBN.t6 VSS 0.0599383f
C1672 VBN.t7 VSS 0.0599383f
C1673 VBN.t8 VSS 0.0599383f
C1674 VBN.t9 VSS 0.0599383f
C1675 VBN.t10 VSS 0.0599383f
C1676 VBN.t11 VSS 0.0614171f
C1677 VBN.n0 VSS 0.082587f
C1678 VBN.n1 VSS 0.0444846f
C1679 VBN.n2 VSS 0.0444846f
C1680 VBN.n3 VSS 0.0444846f
C1681 VBN.n4 VSS 0.0444846f
C1682 VBN.n5 VSS 0.042582f
C1683 VBN.n6 VSS 0.0406017f
C1684 VBN.n7 VSS 0.0444846f
C1685 VBN.n8 VSS 0.0444846f
C1686 VBN.n9 VSS 0.0444846f
C1687 VBN.n10 VSS 0.0690012f
C1688 VBN.t23 VSS 0.0599383f
C1689 VBN.t24 VSS 0.0599383f
C1690 VBN.t27 VSS 0.0599383f
C1691 VBN.t28 VSS 0.0599383f
C1692 VBN.t31 VSS 0.0599383f
C1693 VBN.t32 VSS 0.0599383f
C1694 VBN.t35 VSS 0.0599383f
C1695 VBN.t36 VSS 0.0599383f
C1696 VBN.t39 VSS 0.0599383f
C1697 VBN.t40 VSS 0.0599383f
C1698 VBN.t43 VSS 0.0599383f
C1699 VBN.t44 VSS 0.0614171f
C1700 VBN.n11 VSS 0.0941319f
C1701 VBN.n12 VSS 0.0560295f
C1702 VBN.n13 VSS 0.0560295f
C1703 VBN.n14 VSS 0.0560295f
C1704 VBN.n15 VSS 0.0560295f
C1705 VBN.n16 VSS 0.0512645f
C1706 VBN.n17 VSS 0.0550263f
C1707 VBN.n18 VSS 0.0560295f
C1708 VBN.n19 VSS 0.0560295f
C1709 VBN.n20 VSS 0.0560295f
C1710 VBN.n21 VSS 0.0785917f
C1711 VBN.n22 VSS 0.264547f
C1712 VBN.t21 VSS 0.0599383f
C1713 VBN.t20 VSS 0.0599383f
C1714 VBN.t19 VSS 0.0599383f
C1715 VBN.t18 VSS 0.0599383f
C1716 VBN.t17 VSS 0.0599383f
C1717 VBN.t16 VSS 0.0599383f
C1718 VBN.t15 VSS 0.0599383f
C1719 VBN.t14 VSS 0.0599383f
C1720 VBN.t13 VSS 0.0599383f
C1721 VBN.t12 VSS 0.0614171f
C1722 VBN.n23 VSS 0.0825784f
C1723 VBN.n24 VSS 0.0444846f
C1724 VBN.n25 VSS 0.0444846f
C1725 VBN.n26 VSS 0.0444846f
C1726 VBN.n27 VSS 0.042582f
C1727 VBN.n28 VSS 0.0406017f
C1728 VBN.n29 VSS 0.0444846f
C1729 VBN.n30 VSS 0.0444846f
C1730 VBN.n31 VSS 0.0690012f
C1731 VBN.n32 VSS 0.216101f
C1732 VBN.t45 VSS 0.0599383f
C1733 VBN.t42 VSS 0.0599383f
C1734 VBN.t41 VSS 0.0599383f
C1735 VBN.t38 VSS 0.0599383f
C1736 VBN.t37 VSS 0.0599383f
C1737 VBN.t34 VSS 0.0599383f
C1738 VBN.t33 VSS 0.0599383f
C1739 VBN.t30 VSS 0.0599383f
C1740 VBN.t29 VSS 0.0599383f
C1741 VBN.t26 VSS 0.0599383f
C1742 VBN.t25 VSS 0.0599383f
C1743 VBN.t22 VSS 0.0652654f
C1744 VBN.n33 VSS 0.101828f
C1745 VBN.n34 VSS 0.0560295f
C1746 VBN.n35 VSS 0.0560295f
C1747 VBN.n36 VSS 0.0560295f
C1748 VBN.n37 VSS 0.0560295f
C1749 VBN.n38 VSS 0.0425993f
C1750 VBN.n39 VSS 0.0521379f
C1751 VBN.n40 VSS 0.0560295f
C1752 VBN.n41 VSS 0.0560295f
C1753 VBN.n42 VSS 0.0560295f
C1754 VBN.n43 VSS 0.0805548f
C1755 VBN.n44 VSS 0.251263f
C1756 EN.t2 VSS 0.0919508f
C1757 EN.t1 VSS 0.0520089f
C1758 EN.n0 VSS 0.823782f
C1759 EN.t3 VSS 0.0919508f
C1760 EN.t0 VSS 0.0780894f
C1761 EN.n1 VSS 0.155943f
C1762 EN.n2 VSS 0.697586f
C1763 OUT.t9 VSS 0.0409531f
C1764 OUT.t7 VSS 0.0409531f
C1765 OUT.n0 VSS 0.0859333f
C1766 OUT.t0 VSS 0.0409531f
C1767 OUT.t8 VSS 0.0409531f
C1768 OUT.n1 VSS 0.0859333f
C1769 OUT.n2 VSS 0.0444057f
C1770 OUT.t1 VSS 0.0511927f
C1771 OUT.t3 VSS 0.0511927f
C1772 OUT.n3 VSS 0.109527f
C1773 OUT.t4 VSS 0.0511927f
C1774 OUT.t5 VSS 0.0511927f
C1775 OUT.n4 VSS 0.109527f
C1776 OUT.t6 VSS 0.0511927f
C1777 OUT.t2 VSS 0.0511927f
C1778 OUT.n5 VSS 0.109527f
C1779 OUT.n6 VSS 0.0609974f
C1780 OUT.n7 VSS 0.146979f
Crep0 VBP tp.0.n0 3.37779f
Crep1 gn.0.n0 tp.0.n0 13.4594f
Crep2 VDD tp.0.n0 11.3411f
Crep3 fa.0.n0 tp.0.n0 25.3704f
Crep4 gp.0.n0 tp.0.n0 12.8757f
Crep5 VB2 tp.0.n0 0.05309f
Crep6 VREF tp.0.n0 14.925f
Crep7 fb.0.n0 tp.0.n0 25.7437f
.ends lvds_lane
