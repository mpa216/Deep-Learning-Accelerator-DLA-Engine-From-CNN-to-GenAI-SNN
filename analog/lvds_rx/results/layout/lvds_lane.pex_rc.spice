* lvds_lane: parasitic R (extresist, tolerance 10) on all nets; C from the C-coupled extraction (check.rc_repair, T11: Magic 8.3.636 extresist counts every coupling twice)
* GENERATED by layout/macro/run_macro.py (T10) from a GDS with sha256 44d8eaaa1b5fef2401515b3783b3092630e478448fff74602c9fc000cf7570bc -- do not edit by hand.
* Ports in the order of subckt lvds_lane of netlist/lvds_rx_lvs_ref.spice (Magic's own order was: INP INN OUT EN VBN VB2 VREF VBP VDD VSS).
* NGSPICE file created from lvds_lane.ext - technology: gf180mcuD

.subckt lvds_lane VDD VSS INP INN EN VBN VBP VB2 VREF OUT
X0 VSS.t104 VBN.t35 fb.0.t6 VSS.t103 nfet_03v3 ad=0.65p pd=3.02u as=0.65p ps=3.02u w=2.5u l=1u
X1 tn.0.t26 gn.0.t8 ob.0.t13 VSS.t200 nfet_03v3 ad=1.235p pd=5.27u as=1.235p ps=5.27u w=4.75u l=0.5u
X2 d2a.0.t18 oa.0.t29 sa.0.t1 VSS.t249 nfet_03v3 ad=1.1362p pd=4.89u as=1.1362p ps=4.89u w=4.37u l=0.5u
X3 VDD.t175 VBP.t11 tp.0.t0 VDD.t174 pfet_03v3 ad=1.3p pd=5.52u as=1.3p ps=5.52u w=5u l=1u
X4 fb.0.t40 VREF.t60 tp.0.t0 tp.0.t0 pfet_03v3 ad=1.248p pd=5.32u as=1.248p ps=5.32u w=4.8u l=0.4u
X5 tn.0.t23 gp.0.t7 oa.0.t16 VSS.t193 nfet_03v3 ad=1.235p pd=5.27u as=1.235p ps=5.27u w=4.75u l=0.5u
X6 tp.0.t0 gn.0.t12 fb.0.t63 tp.0.t0 pfet_03v3 ad=1.248p pd=5.32u as=1.248p ps=5.32u w=4.8u l=0.4u
X7 fb.0.t3 VBN.t40 VSS.t112 VSS.t111 nfet_03v3 ad=0.65p pd=3.02u as=0.65p ps=3.02u w=2.5u l=1u
X8 fa.0.t12 VBN.t26 VSS.t126 VSS.t125 nfet_03v3 ad=0.65p pd=3.02u as=0.65p ps=3.02u w=2.5u l=1u
X9 tp.0.t0 VREF.t47 fb.0.t47 tp.0.t0 pfet_03v3 ad=1.248p pd=5.32u as=1.248p ps=5.32u w=4.8u l=0.4u
X10 tn.0.t8 VBN.t16 VSS.t142 VSS.t141 nfet_03v3 ad=0.65p pd=3.02u as=0.65p ps=3.02u w=2.5u l=1u
X11 d3.0.t7 d2b.0.t31 VDD.t109 VDD.t108 pfet_03v3 ad=0.481p pd=2.37u as=0.481p ps=2.37u w=1.85u l=0.28u
X12 VSS.t242 VSS.t243 VSS.t241 ppolyf_u_1k r_width=2u r_length=9.11u
X13 fa.0.t19 VB2.t9 oa.0.t2 VSS.t169 nfet_03v3 ad=1.1752p pd=5.04u as=1.1752p ps=5.04u w=4.52u l=0.5u
X14 VSS.t120 VBN.t29 fa.0.t11 VSS.t119 nfet_03v3 ad=0.65p pd=3.02u as=0.65p ps=3.02u w=2.5u l=1u
X15 ob.0.t4 VB2.t3 fb.0.t16 VSS.t175 nfet_03v3 ad=1.1752p pd=5.04u as=1.1752p ps=5.04u w=4.52u l=0.5u
X16 oa.0.t23 VREF.t6 tn.0.t45 VSS.t214 nfet_03v3 ad=1.235p pd=5.27u as=1.235p ps=5.27u w=4.75u l=0.5u
X17 fa.0.t21 VB2.t7 oa.0.t4 VSS.t171 nfet_03v3 ad=1.1752p pd=5.04u as=1.1752p ps=5.04u w=4.52u l=0.5u
X18 VSS.t92 VBN.t45 fa.0.t3 VSS.t91 nfet_03v3 ad=0.65p pd=3.02u as=0.65p ps=3.02u w=2.5u l=1u
X19 ob.0.t7 VB2.t5 fb.0.t14 VSS.t173 nfet_03v3 ad=1.1752p pd=5.04u as=1.1752p ps=5.04u w=4.52u l=0.5u
X20 VDD.t155 VBP.t21 tp.0.t0 VDD.t154 pfet_03v3 ad=1.3p pd=5.52u as=1.3p ps=5.52u w=5u l=1u
X21 ob.0.t0 VSS.t27 VSS.t29 VSS.t28 nfet_03v3 ad=1.1752p pd=5.04u as=1.9888p ps=9.92u w=4.52u l=0.5u
X22 VDD.t171 VBP.t13 tp.0.t0 VDD.t170 pfet_03v3 ad=1.3p pd=5.52u as=1.3p ps=5.52u w=5u l=1u
X23 tp.0.t0 VREF.t29 fa.0.t52 tp.0.t0 pfet_03v3 ad=1.248p pd=5.32u as=1.248p ps=5.32u w=4.8u l=0.4u
X24 tp.0.t0 VBP.t18 VDD.t161 VDD.t160 pfet_03v3 ad=1.3p pd=5.52u as=1.3p ps=5.52u w=5u l=1u
X25 fb.0.t11 VBN.t24 VSS.t122 VSS.t121 nfet_03v3 ad=0.65p pd=3.02u as=0.65p ps=3.02u w=2.5u l=1u
X26 tn.0.t35 VREF.t11 ob.0.t18 VSS.t209 nfet_03v3 ad=1.235p pd=5.27u as=1.235p ps=5.27u w=4.75u l=0.5u
X27 tp.0.t0 VBP.t2 VDD.t193 VDD.t192 pfet_03v3 ad=1.3p pd=5.52u as=1.3p ps=5.52u w=5u l=1u
X28 tp.0.t0 gp.0.t19 fa.0.t63 tp.0.t0 pfet_03v3 ad=1.248p pd=5.32u as=1.248p ps=5.32u w=4.8u l=0.4u
X29 VDD.t151 i1.0.t5 i2.0.t5 VDD.t150 pfet_03v3 ad=0.975p pd=4.27u as=0.975p ps=4.27u w=3.75u l=0.28u
X30 tn.0.t20 gp.0.t1 oa.0.t14 VSS.t190 nfet_03v3 ad=1.235p pd=5.27u as=1.235p ps=5.27u w=4.75u l=0.5u
X31 d2a.0.t13 d2b.0.t23 VDD.t72 VDD.t71 pfet_03v3 ad=0.481p pd=2.37u as=0.481p ps=2.37u w=1.85u l=0.28u
X32 fb.0.t54 VREF.t32 tp.0.t0 tp.0.t0 pfet_03v3 ad=1.248p pd=5.32u as=1.248p ps=5.32u w=4.8u l=0.4u
X33 VSS.t8 VSS.t6 ts.0.t1 VSS.t7 nfet_03v3 ad=1.1p pd=5.88u as=0.65p ps=3.02u w=2.5u l=1u
X34 VDD.t153 nd.0.t6 i1.0.t2 VDD.t152 pfet_03v3 ad=0.962p pd=4.22u as=0.962p ps=4.22u w=3.7u l=0.28u
X35 tp.0.t0 VREF.t61 fa.0.t36 tp.0.t0 pfet_03v3 ad=1.248p pd=5.32u as=1.248p ps=5.32u w=4.8u l=0.4u
X36 VSS.t196 VSS.t197 VSS.t195 ppolyf_u_1k r_width=5u r_length=1.64u
X37 tp.0.t0 VREF.t21 fa.0.t56 tp.0.t0 pfet_03v3 ad=1.248p pd=5.32u as=1.248p ps=5.32u w=4.8u l=0.4u
X38 i2.0.t1 VDD.t42 VDD.t44 VDD.t43 pfet_03v3 ad=0.975p pd=4.27u as=1.65p ps=8.38u w=3.75u l=0.28u
X39 tp.0.t0 VBP.t16 VDD.t165 VDD.t164 pfet_03v3 ad=1.3p pd=5.52u as=1.3p ps=5.52u w=5u l=1u
X40 tp.0.t0 gp.0.t27 fa.0.t31 tp.0.t0 pfet_03v3 ad=1.248p pd=5.32u as=1.248p ps=5.32u w=4.8u l=0.4u
X41 VSS.t248 i2.0.t11 OUT.t8 VSS.t247 nfet_03v3 ad=1.04p pd=4.52u as=1.04p ps=4.52u w=4u l=0.28u
X42 VDD.t29 VDD.t27 VDD.t29 VDD.t28 pfet_03v3 ad=0.962p pd=4.22u as=0 ps=0 w=3.7u l=0.28u
X43 VDD.t70 d2b.0.t22 d2a.0.t14 VDD.t69 pfet_03v3 ad=0.481p pd=2.37u as=0.481p ps=2.37u w=1.85u l=0.28u
X44 fa.0.t49 VREF.t34 tp.0.t0 tp.0.t0 pfet_03v3 ad=1.248p pd=5.32u as=1.248p ps=5.32u w=4.8u l=0.4u
X45 OUT.t5 i2.0.t8 VDD.t127 VDD.t126 pfet_03v3 ad=1.3p pd=5.52u as=1.3p ps=5.52u w=5u l=0.28u
X46 ob.0.t23 VREF.t0 tn.0.t30 VSS.t220 nfet_03v3 ad=2.09p pd=10.38u as=1.235p ps=5.27u w=4.75u l=0.5u
X47 VSS.t26 VSS.t24 fb.0.t0 VSS.t25 nfet_03v3 ad=1.9888p pd=9.92u as=1.1752p ps=5.04u w=4.52u l=0.5u
X48 tp.0.t0 gn.0.t26 fb.0.t30 tp.0.t0 pfet_03v3 ad=1.248p pd=5.32u as=1.248p ps=5.32u w=4.8u l=0.4u
X49 tp.0.t0 gn.0.t14 fb.0.t28 tp.0.t0 pfet_03v3 ad=1.248p pd=5.32u as=1.248p ps=5.32u w=4.8u l=0.4u
X50 VSS.t106 VBN.t31 fb.0.t8 VSS.t105 nfet_03v3 ad=0.65p pd=3.02u as=0.65p ps=3.02u w=2.5u l=1u
X51 tn.0.t18 gp.0.t5 oa.0.t12 VSS.t188 nfet_03v3 ad=1.235p pd=5.27u as=1.235p ps=5.27u w=4.75u l=0.5u
X52 ts.0.t7 VBN.t6 VSS.t76 VSS.t75 nfet_03v3 ad=0.65p pd=3.02u as=0.65p ps=3.02u w=2.5u l=1u
X53 OUT.t0 VSS.t66 VSS.t68 VSS.t67 nfet_03v3 ad=1.04p pd=4.52u as=1.76p ps=8.88u w=4u l=0.28u
X54 fa.0.t26 gp.0.t26 tp.0.t0 tp.0.t0 pfet_03v3 ad=1.248p pd=5.32u as=1.248p ps=5.32u w=4.8u l=0.4u
X55 VSS.t65 VSS.t63 VSS.t65 VSS.t64 nfet_03v3 ad=0.78p pd=3.52u as=0 ps=0 w=3u l=0.28u
X56 VDD.t129 i2.0.t9 OUT.t6 VDD.t128 pfet_03v3 ad=1.3p pd=5.52u as=1.3p ps=5.52u w=5u l=0.28u
X57 d2a.0.t11 d2b.0.t25 VDD.t76 VDD.t75 pfet_03v3 ad=0.481p pd=2.37u as=0.481p ps=2.37u w=1.85u l=0.28u
X58 fb.0.t27 gn.0.t19 tp.0.t0 tp.0.t0 pfet_03v3 ad=1.248p pd=5.32u as=1.248p ps=5.32u w=4.8u l=0.4u
X59 tn.0.t44 VREF.t9 oa.0.t22 VSS.t211 nfet_03v3 ad=1.235p pd=5.27u as=1.235p ps=5.27u w=4.75u l=0.5u
X60 nm.0.t0 d3.0.t11 nd.0.t3 VSS.t223 nfet_03v3 ad=0.52p pd=2.52u as=0.52p ps=2.52u w=2u l=0.28u
X61 VDD.t89 d2b.0.t5 d2b.0.t6 VDD.t88 pfet_03v3 ad=0.481p pd=2.37u as=0.481p ps=2.37u w=1.85u l=0.28u
X62 VDD.t79 d2b.0.t26 d3.0.t2 VDD.t78 pfet_03v3 ad=0.481p pd=2.37u as=0.481p ps=2.37u w=1.85u l=0.28u
X63 tn.0.t24 gn.0.t10 ob.0.t11 VSS.t198 nfet_03v3 ad=1.235p pd=5.27u as=1.235p ps=5.27u w=4.75u l=0.5u
X64 tn.0.t22 gn.0.t2 ob.0.t10 VSS.t192 nfet_03v3 ad=1.235p pd=5.27u as=1.235p ps=5.27u w=4.75u l=0.5u
X65 VSS.t162 VBN.t1 ts.0.t12 VSS.t161 nfet_03v3 ad=0.65p pd=3.02u as=0.65p ps=3.02u w=2.5u l=1u
X66 gp.0.t0 INP.t0 VDD.t54 ppolyf_u r_width=5u r_length=1.8u
X67 tn.0.t10 VBN.t14 VSS.t146 VSS.t145 nfet_03v3 ad=0.65p pd=3.02u as=0.65p ps=3.02u w=2.5u l=1u
X68 tn.0.t14 gp.0.t3 oa.0.t10 VSS.t183 nfet_03v3 ad=1.235p pd=5.27u as=1.235p ps=5.27u w=4.75u l=0.5u
X69 ob.0.t26 rlb_m1.0.t1 VSS.t235 ppolyf_u_1k r_width=2u r_length=9.11u
D0 gn.0.t33 VDD.t139 diode_pd2nw_03v3 pj=26u area=40p
X70 fa.0.t35 VREF.t62 tp.0.t0 tp.0.t0 pfet_03v3 ad=1.248p pd=5.32u as=1.248p ps=5.32u w=4.8u l=0.4u
X71 fa.0.t58 gp.0.t20 tp.0.t0 tp.0.t0 pfet_03v3 ad=1.248p pd=5.32u as=1.248p ps=5.32u w=4.8u l=0.4u
X72 fb.0.t60 VREF.t20 tp.0.t0 tp.0.t0 pfet_03v3 ad=2.112p pd=10.48u as=1.248p ps=5.32u w=4.8u l=0.4u
X73 ts.0.t5 VBN.t8 VSS.t88 VSS.t87 nfet_03v3 ad=0.65p pd=3.02u as=0.65p ps=3.02u w=2.5u l=1u
X74 VDD.t183 VBP.t7 tp.0.t0 VDD.t182 pfet_03v3 ad=1.3p pd=5.52u as=1.3p ps=5.52u w=5u l=1u
X75 fa.0.t27 gp.0.t28 tp.0.t0 tp.0.t0 pfet_03v3 ad=1.248p pd=5.32u as=1.248p ps=5.32u w=4.8u l=0.4u
X76 fb.0.t33 gn.0.t13 tp.0.t0 tp.0.t0 pfet_03v3 ad=1.248p pd=5.32u as=1.248p ps=5.32u w=4.8u l=0.4u
X77 VSS.t128 VBN.t23 fb.0.t12 VSS.t127 nfet_03v3 ad=0.65p pd=3.02u as=0.65p ps=3.02u w=2.5u l=1u
X78 n3a.0.t10 d2a.0.t26 VDD.t134 VDD.t133 pfet_03v3 ad=0.481p pd=2.37u as=0.481p ps=2.37u w=1.85u l=0.28u
D1 VSS.t244 gn.0.t34 diode_nd2ps_03v3 pj=26u area=40p
X79 VSS.t90 VBN.t11 ts.0.t2 VSS.t89 nfet_03v3 ad=0.65p pd=3.02u as=0.65p ps=3.02u w=2.5u l=1u
X80 d3.0.t3 d2b.0.t27 VDD.t81 VDD.t80 pfet_03v3 ad=0.481p pd=2.37u as=0.481p ps=2.37u w=1.85u l=0.28u
X81 fb.0.t52 VREF.t36 tp.0.t0 tp.0.t0 pfet_03v3 ad=1.248p pd=5.32u as=1.248p ps=5.32u w=4.8u l=0.4u
X82 VSS.t136 VBN.t19 tn.0.t5 VSS.t135 nfet_03v3 ad=0.65p pd=3.02u as=0.65p ps=3.02u w=2.5u l=1u
X83 VSS.t154 VBN.t3 ts.0.t10 VSS.t153 nfet_03v3 ad=0.65p pd=3.02u as=0.65p ps=3.02u w=2.5u l=1u
X84 tp.0.t0 VBP.t10 VDD.t177 VDD.t176 pfet_03v3 ad=1.3p pd=5.52u as=1.3p ps=5.52u w=5u l=1u
X85 tp.0.t0 VREF.t45 fa.0.t44 tp.0.t0 pfet_03v3 ad=1.248p pd=5.32u as=1.248p ps=5.32u w=4.8u l=0.4u
X86 fa.0.t55 VREF.t22 tp.0.t0 tp.0.t0 pfet_03v3 ad=1.248p pd=5.32u as=1.248p ps=5.32u w=4.8u l=0.4u
X87 VDD.t77 rla_m1.0.t0 VSS.t230 ppolyf_u_1k r_width=2u r_length=9.11u
X88 nd.0.t1 VDD.t33 VDD.t35 VDD.t34 pfet_03v3 ad=0.78p pd=3.52u as=1.32p ps=6.88u w=3u l=0.28u
X89 fb.0.t31 gn.0.t27 tp.0.t0 tp.0.t0 pfet_03v3 ad=1.248p pd=5.32u as=1.248p ps=5.32u w=4.8u l=0.4u
X90 fa.0.t23 gp.0.t14 tp.0.t0 tp.0.t0 pfet_03v3 ad=1.248p pd=5.32u as=1.248p ps=5.32u w=4.8u l=0.4u
X91 tn.0.t33 VREF.t15 ob.0.t16 VSS.t205 nfet_03v3 ad=1.235p pd=5.27u as=1.235p ps=5.27u w=4.75u l=0.5u
X92 tp.0.t0 gn.0.t32 fb.0.t62 tp.0.t0 pfet_03v3 ad=1.248p pd=5.32u as=1.248p ps=5.32u w=4.8u l=0.4u
X93 oa.0.t7 VB2.t10 fa.0.t18 VSS.t168 nfet_03v3 ad=1.1752p pd=5.04u as=1.1752p ps=5.04u w=4.52u l=0.5u
X94 VDD.t20 VDD.t18 VDD.t20 VDD.t19 pfet_03v3 ad=0.814p pd=4.58u as=0 ps=0 w=1.85u l=0.28u
X95 ts.0.t15 sb.0.t0 VSS.t234 ppolyf_u_1k r_width=5u r_length=1.64u
X96 VDD.t115 d2b.0.t20 d2a.0.t16 VDD.t114 pfet_03v3 ad=0.481p pd=2.37u as=0.481p ps=2.37u w=1.85u l=0.28u
X97 VDD.t94 d2a.0.t29 n3a.0.t5 VDD.t93 pfet_03v3 ad=0.481p pd=2.37u as=0.481p ps=2.37u w=1.85u l=0.28u
X98 VSS.t180 VSS.t181 VSS.t179 ppolyf_u_1k r_width=2u r_length=9.11u
X99 VDD.t8 VDD.t6 tp.0.t0 VDD.t7 pfet_03v3 ad=2.2p pd=10.88u as=1.3p ps=5.52u w=5u l=1u
X100 tp.0.t0 VBP.t14 VDD.t169 VDD.t168 pfet_03v3 ad=1.3p pd=5.52u as=1.3p ps=5.52u w=5u l=1u
X101 tp.0.t0 gp.0.t25 fa.0.t32 tp.0.t0 pfet_03v3 ad=1.248p pd=5.32u as=1.248p ps=5.32u w=4.8u l=0.4u
X102 fb.0.t61 gn.0.t15 tp.0.t0 tp.0.t0 pfet_03v3 ad=1.248p pd=5.32u as=1.248p ps=5.32u w=4.8u l=0.4u
X103 fa.0.t6 VBN.t38 VSS.t78 VSS.t77 nfet_03v3 ad=0.65p pd=3.02u as=0.65p ps=3.02u w=2.5u l=1u
X104 fb.0.t9 VBN.t28 VSS.t100 VSS.t99 nfet_03v3 ad=0.65p pd=3.02u as=0.65p ps=3.02u w=2.5u l=1u
X105 VDD.t107 d2b.0.t30 d3.0.t6 VDD.t106 pfet_03v3 ad=0.481p pd=2.37u as=0.481p ps=2.37u w=1.85u l=0.28u
X106 tp.0.t0 gp.0.t15 fa.0.t24 tp.0.t0 pfet_03v3 ad=1.248p pd=5.32u as=1.248p ps=5.32u w=4.8u l=0.4u
X107 VDD.t23 VDD.t21 VDD.t23 VDD.t22 pfet_03v3 ad=0.481p pd=2.37u as=0 ps=0 w=1.85u l=0.28u
X108 VSS.t110 VBN.t43 fb.0.t2 VSS.t109 nfet_03v3 ad=0.65p pd=3.02u as=0.65p ps=3.02u w=2.5u l=1u
X109 VDD.t159 VBP.t19 tp.0.t0 VDD.t158 pfet_03v3 ad=1.3p pd=5.52u as=1.3p ps=5.52u w=5u l=1u
X110 n3a.0.t6 d2a.0.t30 VDD.t96 VDD.t95 pfet_03v3 ad=0.481p pd=2.37u as=0.481p ps=2.37u w=1.85u l=0.28u
X111 fa.0.t43 VREF.t46 tp.0.t0 tp.0.t0 pfet_03v3 ad=1.248p pd=5.32u as=1.248p ps=5.32u w=4.8u l=0.4u
X112 tp.0.t0 VREF.t35 fb.0.t53 tp.0.t0 pfet_03v3 ad=1.248p pd=5.32u as=1.248p ps=5.32u w=4.8u l=0.4u
X113 VSS.t225 n3a.0.t3 n3a.0.t4 VSS.t224 nfet_03v3 ad=1.2116p pd=5.18u as=1.2116p ps=5.18u w=4.66u l=0.28u
X114 ts.0.t14 sa.0.t0 VSS.t194 ppolyf_u_1k r_width=5u r_length=1.64u
X115 fa.0.t37 VREF.t58 tp.0.t0 tp.0.t0 pfet_03v3 ad=1.248p pd=5.32u as=1.248p ps=5.32u w=4.8u l=0.4u
X116 ob.0.t25 gn.0.t7 tn.0.t48 VSS.t232 nfet_03v3 ad=1.235p pd=5.27u as=1.235p ps=5.27u w=4.75u l=0.5u
X117 d2b.0.t2 VDD.t30 VDD.t32 VDD.t31 pfet_03v3 ad=0.52p pd=2.52u as=0.88p ps=4.88u w=2u l=0.5u
X118 n3a.0.t1 VDD.t12 VDD.t14 VDD.t13 pfet_03v3 ad=0.481p pd=2.37u as=0.814p ps=4.58u w=1.85u l=0.28u
D2 VSS.t186 gp.0.t33 diode_nd2ps_03v3 pj=26u area=40p
X119 tp.0.t0 VBP.t4 VDD.t189 VDD.t188 pfet_03v3 ad=1.3p pd=5.52u as=1.3p ps=5.52u w=5u l=1u
X120 tp.0.t0 gp.0.t13 fa.0.t33 tp.0.t0 pfet_03v3 ad=1.248p pd=5.32u as=1.248p ps=5.32u w=4.8u l=0.4u
X121 VSS.t23 VSS.t21 fa.0.t2 VSS.t22 nfet_03v3 ad=1.1p pd=5.88u as=0.65p ps=3.02u w=2.5u l=1u
X122 fb.0.t48 VREF.t44 tp.0.t0 tp.0.t0 pfet_03v3 ad=1.248p pd=5.32u as=1.248p ps=5.32u w=4.8u l=0.4u
X123 tn.0.t31 VREF.t19 ob.0.t14 VSS.t201 nfet_03v3 ad=1.235p pd=5.27u as=2.09p ps=10.38u w=4.75u l=0.5u
X124 tn.0.t40 VREF.t13 oa.0.t20 VSS.t207 nfet_03v3 ad=1.235p pd=5.27u as=1.235p ps=5.27u w=4.75u l=0.5u
X125 VDD.t90 rlb_m1.0.t0 VSS.t233 ppolyf_u_1k r_width=2u r_length=9.11u
D3 gp.0.t34 VDD.t101 diode_pd2nw_03v3 pj=26u area=40p
X126 fa.0.t47 VREF.t38 tp.0.t0 tp.0.t0 pfet_03v3 ad=1.248p pd=5.32u as=1.248p ps=5.32u w=4.8u l=0.4u
X127 oa.0.t3 VB2.t8 fa.0.t20 VSS.t170 nfet_03v3 ad=1.1752p pd=5.04u as=1.1752p ps=5.04u w=4.52u l=0.5u
X128 VDD.t111 d2b.0.t32 d3.0.t8 VDD.t110 pfet_03v3 ad=0.481p pd=2.37u as=0.481p ps=2.37u w=1.85u l=0.28u
X129 VSS.t14 VSS.t12 fa.0.t0 VSS.t13 nfet_03v3 ad=1.9888p pd=9.92u as=1.1752p ps=5.04u w=4.52u l=0.5u
X130 tn.0.t50 gn.0.t4 ob.0.t28 VSS.t253 nfet_03v3 ad=1.235p pd=5.27u as=1.235p ps=5.27u w=4.75u l=0.5u
X131 tn.0.t27 VREF.t7 ob.0.t20 VSS.t213 nfet_03v3 ad=1.235p pd=5.27u as=1.235p ps=5.27u w=4.75u l=0.5u
X132 VDD.t105 d2a.0.t33 n3a.0.t9 VDD.t104 pfet_03v3 ad=0.481p pd=2.37u as=0.481p ps=2.37u w=1.85u l=0.28u
X133 VDD.t179 VBP.t9 tp.0.t0 VDD.t178 pfet_03v3 ad=1.3p pd=5.52u as=1.3p ps=5.52u w=5u l=1u
X134 tp.0.t0 VREF.t55 fb.0.t43 tp.0.t0 pfet_03v3 ad=1.248p pd=5.32u as=1.248p ps=5.32u w=4.8u l=0.4u
X135 fb.0.t13 VB2.t6 ob.0.t6 VSS.t172 nfet_03v3 ad=1.1752p pd=5.04u as=1.1752p ps=5.04u w=4.52u l=0.5u
X136 fa.0.t59 gp.0.t32 tp.0.t0 tp.0.t0 pfet_03v3 ad=1.248p pd=5.32u as=1.248p ps=5.32u w=4.8u l=0.4u
X137 tp.0.t0 gp.0.t31 fa.0.t30 tp.0.t0 pfet_03v3 ad=1.248p pd=5.32u as=1.248p ps=5.32u w=4.8u l=0.4u
X138 fb.0.t50 VREF.t40 tp.0.t0 tp.0.t0 pfet_03v3 ad=1.248p pd=5.32u as=1.248p ps=5.32u w=4.8u l=0.4u
X139 VSS.t140 VBN.t17 tn.0.t7 VSS.t139 nfet_03v3 ad=0.65p pd=3.02u as=0.65p ps=3.02u w=2.5u l=1u
X140 oa.0.t21 VREF.t10 tn.0.t43 VSS.t210 nfet_03v3 ad=1.235p pd=5.27u as=1.235p ps=5.27u w=4.75u l=0.5u
X141 VSS.t158 VBN.t5 ts.0.t8 VSS.t157 nfet_03v3 ad=0.65p pd=3.02u as=0.65p ps=3.02u w=2.5u l=1u
X142 fa.0.t8 VBN.t34 VSS.t82 VSS.t81 nfet_03v3 ad=0.65p pd=3.02u as=0.65p ps=3.02u w=2.5u l=1u
X143 OUT.t2 VDD.t48 VDD.t50 VDD.t49 pfet_03v3 ad=1.3p pd=5.52u as=2.2p ps=10.88u w=5u l=0.28u
X144 VDD.t143 EN.t2 d2b.0.t19 VDD.t142 pfet_03v3 ad=0.52p pd=2.52u as=0.52p ps=2.52u w=2u l=0.5u
X145 VDD.t74 d2b.0.t24 d2a.0.t12 VDD.t73 pfet_03v3 ad=0.481p pd=2.37u as=0.481p ps=2.37u w=1.85u l=0.28u
X146 VDD.t141 EN.t3 d2a.0.t17 VDD.t140 pfet_03v3 ad=0.52p pd=2.52u as=0.52p ps=2.52u w=2u l=0.5u
X147 tp.0.t0 gp.0.t23 fa.0.t57 tp.0.t0 pfet_03v3 ad=1.248p pd=5.32u as=1.248p ps=5.32u w=4.8u l=0.4u
X148 tn.0.t0 VSS.t30 VSS.t32 VSS.t31 nfet_03v3 ad=0.65p pd=3.02u as=1.1p ps=5.88u w=2.5u l=1u
X149 ts.0.t13 VBN.t0 VSS.t164 VSS.t163 nfet_03v3 ad=0.65p pd=3.02u as=0.65p ps=3.02u w=2.5u l=1u
X150 d2b.0.t16 ob.0.t29 sb.0.t1 VSS.t236 nfet_03v3 ad=1.1362p pd=4.89u as=1.1362p ps=4.89u w=4.37u l=0.5u
X151 tp.0.t0 VREF.t59 fb.0.t41 tp.0.t0 pfet_03v3 ad=1.248p pd=5.32u as=1.248p ps=5.32u w=4.8u l=0.4u
X152 tp.0.t0 gn.0.t20 fb.0.t23 tp.0.t0 pfet_03v3 ad=1.248p pd=5.32u as=1.248p ps=5.32u w=4.8u l=0.4u
X153 sa.0.t2 oa.0.t30 d2a.0.t19 VSS.t250 nfet_03v3 ad=1.1362p pd=4.89u as=1.1362p ps=4.89u w=4.37u l=0.5u
X154 VSS.t252 i1.0.t6 i2.0.t4 VSS.t251 nfet_03v3 ad=0.78p pd=3.52u as=0.78p ps=3.52u w=3u l=0.28u
X155 VSS.t255 nd.0.t7 i1.0.t3 VSS.t254 nfet_03v3 ad=0.39p pd=2.02u as=0.39p ps=2.02u w=1.5u l=0.28u
X156 VSS.t246 EN.t1 nm.0.t1 VSS.t245 nfet_03v3 ad=0.52p pd=2.52u as=0.52p ps=2.52u w=2u l=0.28u
X157 tp.0.t0 VREF.t23 fb.0.t59 tp.0.t0 pfet_03v3 ad=1.248p pd=5.32u as=1.248p ps=5.32u w=4.8u l=0.4u
X158 nd.0.t0 VSS.t45 VSS.t47 VSS.t46 nfet_03v3 ad=0.52p pd=2.52u as=0.88p ps=4.88u w=2u l=0.28u
X159 oa.0.t27 rla_m1.0.t1 VSS.t231 ppolyf_u_1k r_width=2u r_length=9.11u
X160 tp.0.t0 VREF.t37 fa.0.t48 tp.0.t0 pfet_03v3 ad=1.248p pd=5.32u as=1.248p ps=5.32u w=4.8u l=0.4u
X161 fb.0.t1 VBN.t44 VSS.t98 VSS.t97 nfet_03v3 ad=0.65p pd=3.02u as=0.65p ps=3.02u w=2.5u l=1u
X162 tn.0.t12 VBN.t12 VSS.t150 VSS.t149 nfet_03v3 ad=0.65p pd=3.02u as=0.65p ps=3.02u w=2.5u l=1u
X163 ts.0.t3 VBN.t10 VSS.t152 VSS.t151 nfet_03v3 ad=0.65p pd=3.02u as=0.65p ps=3.02u w=2.5u l=1u
X164 fb.0.t42 VREF.t56 tp.0.t0 tp.0.t0 pfet_03v3 ad=1.248p pd=5.32u as=1.248p ps=5.32u w=4.8u l=0.4u
X165 tp.0.t0 VREF.t25 fa.0.t54 tp.0.t0 pfet_03v3 ad=1.248p pd=5.32u as=1.248p ps=5.32u w=4.8u l=0.4u
X166 oa.0.t0 VSS.t15 VSS.t17 VSS.t16 nfet_03v3 ad=1.1752p pd=5.04u as=1.9888p ps=9.92u w=4.52u l=0.5u
X167 fb.0.t5 VBN.t36 VSS.t114 VSS.t113 nfet_03v3 ad=0.65p pd=3.02u as=0.65p ps=3.02u w=2.5u l=1u
X168 tn.0.t38 VREF.t17 oa.0.t18 VSS.t203 nfet_03v3 ad=1.235p pd=5.27u as=1.235p ps=5.27u w=4.75u l=0.5u
X169 tn.0.t42 VREF.t1 oa.0.t26 VSS.t219 nfet_03v3 ad=1.235p pd=5.27u as=1.235p ps=5.27u w=4.75u l=0.5u
X170 VDD.t53 VDD.t51 OUT.t3 VDD.t52 pfet_03v3 ad=2.2p pd=10.88u as=1.3p ps=5.52u w=5u l=0.28u
X171 i2.0.t0 VSS.t60 VSS.t62 VSS.t61 nfet_03v3 ad=0.78p pd=3.52u as=1.32p ps=6.88u w=3u l=0.28u
X172 VSS.t2 VSS.t0 VSS.t2 VSS.t1 nfet_03v3 ad=0.52p pd=2.52u as=0 ps=0 w=2u l=0.28u
X173 VDD.t11 VDD.t9 n3a.0.t2 VDD.t10 pfet_03v3 ad=0.814p pd=4.58u as=0.481p ps=2.37u w=1.85u l=0.28u
X174 tp.0.t0 VBP.t12 VDD.t173 VDD.t172 pfet_03v3 ad=1.3p pd=5.52u as=1.3p ps=5.52u w=5u l=1u
X175 tp.0.t0 gn.0.t22 fb.0.t25 tp.0.t0 pfet_03v3 ad=1.248p pd=5.32u as=1.248p ps=5.32u w=4.8u l=0.4u
X176 fa.0.t53 VREF.t26 tp.0.t0 tp.0.t0 pfet_03v3 ad=1.248p pd=5.32u as=1.248p ps=5.32u w=4.8u l=0.4u
X177 oa.0.t5 VB2.t12 fa.0.t16 VSS.t166 nfet_03v3 ad=1.1752p pd=5.04u as=1.1752p ps=5.04u w=4.52u l=0.5u
X178 fb.0.t19 VB2.t0 ob.0.t2 VSS.t178 nfet_03v3 ad=1.1752p pd=5.04u as=1.1752p ps=5.04u w=4.52u l=0.5u
X179 tn.0.t29 VREF.t3 ob.0.t22 VSS.t217 nfet_03v3 ad=1.235p pd=5.27u as=1.235p ps=5.27u w=4.75u l=0.5u
X180 i1.0.t0 VSS.t57 VSS.t59 VSS.t58 nfet_03v3 ad=0.39p pd=2.02u as=0.66p ps=3.88u w=1.5u l=0.28u
X181 VDD.t163 VBP.t17 tp.0.t0 VDD.t162 pfet_03v3 ad=1.3p pd=5.52u as=1.3p ps=5.52u w=5u l=1u
X182 VSS.t96 VBN.t41 fa.0.t5 VSS.t95 nfet_03v3 ad=0.65p pd=3.02u as=0.65p ps=3.02u w=2.5u l=1u
X183 VSS.t124 VBN.t25 fa.0.t13 VSS.t123 nfet_03v3 ad=0.65p pd=3.02u as=0.65p ps=3.02u w=2.5u l=1u
X184 fb.0.t17 VB2.t2 ob.0.t5 VSS.t176 nfet_03v3 ad=1.1752p pd=5.04u as=1.1752p ps=5.04u w=4.52u l=0.5u
X185 tn.0.t49 gn.0.t6 ob.0.t27 VSS.t240 nfet_03v3 ad=1.235p pd=5.27u as=1.235p ps=5.27u w=4.75u l=0.5u
X186 VDD.t191 VBP.t3 tp.0.t0 VDD.t190 pfet_03v3 ad=1.3p pd=5.52u as=1.3p ps=5.52u w=5u l=1u
X187 fb.0.t22 gn.0.t25 tp.0.t0 tp.0.t0 pfet_03v3 ad=1.248p pd=5.32u as=1.248p ps=5.32u w=4.8u l=0.4u
X188 tp.0.t0 VREF.t39 fb.0.t51 tp.0.t0 pfet_03v3 ad=1.248p pd=5.32u as=1.248p ps=5.32u w=4.8u l=0.4u
X189 VDD.t119 d3.0.t10 nd.0.t4 VDD.t118 pfet_03v3 ad=0.78p pd=3.52u as=0.78p ps=3.52u w=3u l=0.28u
X190 gn.0.t0 INN.t0 VDD.t130 ppolyf_u r_width=5u r_length=1.8u
X191 fa.0.t39 VREF.t54 tp.0.t0 tp.0.t0 pfet_03v3 ad=1.248p pd=5.32u as=1.248p ps=5.32u w=4.8u l=0.4u
X192 OUT.t9 i2.0.t6 VDD.t147 VDD.t146 pfet_03v3 ad=1.3p pd=5.52u as=1.3p ps=5.52u w=5u l=0.28u
X193 tp.0.t0 VBP.t6 VDD.t185 VDD.t184 pfet_03v3 ad=1.3p pd=5.52u as=1.3p ps=5.52u w=5u l=1u
X194 fb.0.t56 VREF.t28 tp.0.t0 tp.0.t0 pfet_03v3 ad=1.248p pd=5.32u as=1.248p ps=5.32u w=4.8u l=0.4u
X195 fa.0.t1 VSS.t18 VSS.t20 VSS.t19 nfet_03v3 ad=0.65p pd=3.02u as=1.1p ps=5.88u w=2.5u l=1u
X196 ob.0.t19 VREF.t8 tn.0.t36 VSS.t212 nfet_03v3 ad=1.235p pd=5.27u as=1.235p ps=5.27u w=4.75u l=0.5u
X197 tp.0.t0 VDD.t3 VDD.t5 VDD.t4 pfet_03v3 ad=1.3p pd=5.52u as=2.2p ps=10.88u w=5u l=1u
X198 fa.0.t64 gp.0.t24 tp.0.t0 tp.0.t0 pfet_03v3 ad=1.248p pd=5.32u as=1.248p ps=5.32u w=4.8u l=0.4u
X199 oa.0.t9 gp.0.t10 tn.0.t13 VSS.t182 nfet_03v3 ad=1.235p pd=5.27u as=1.235p ps=5.27u w=4.75u l=0.5u
X200 d2a.0.t3 d2a.0.t2 VDD.t103 VDD.t102 pfet_03v3 ad=0.481p pd=2.37u as=0.481p ps=2.37u w=1.85u l=0.28u
X201 fb.0.t26 gn.0.t17 tp.0.t0 tp.0.t0 pfet_03v3 ad=1.248p pd=5.32u as=1.248p ps=5.32u w=4.8u l=0.4u
X202 VSS.t108 VBN.t39 fb.0.t4 VSS.t107 nfet_03v3 ad=0.65p pd=3.02u as=0.65p ps=3.02u w=2.5u l=1u
X203 ob.0.t12 gn.0.t3 tn.0.t25 VSS.t199 nfet_03v3 ad=1.235p pd=5.27u as=1.235p ps=5.27u w=4.75u l=0.5u
X204 d2a.0.t15 d2b.0.t21 VDD.t117 VDD.t116 pfet_03v3 ad=0.481p pd=2.37u as=0.481p ps=2.37u w=1.85u l=0.28u
X205 d3.0.t5 d2b.0.t29 VDD.t85 VDD.t84 pfet_03v3 ad=0.481p pd=2.37u as=0.481p ps=2.37u w=1.85u l=0.28u
X206 oa.0.t13 gp.0.t4 tn.0.t19 VSS.t189 nfet_03v3 ad=1.235p pd=5.27u as=1.235p ps=5.27u w=4.75u l=0.5u
X207 nd.0.t5 EN.t0 VDD.t145 VDD.t144 pfet_03v3 ad=0.78p pd=3.52u as=0.78p ps=3.52u w=3u l=0.28u
X208 VDD.t195 VBP.t1 tp.0.t0 VDD.t194 pfet_03v3 ad=1.3p pd=5.52u as=1.3p ps=5.52u w=5u l=1u
X209 ob.0.t24 gn.0.t9 tn.0.t47 VSS.t226 nfet_03v3 ad=1.235p pd=5.27u as=1.235p ps=5.27u w=4.75u l=0.5u
X210 oa.0.t1 gp.0.t8 tn.0.t2 VSS.t72 nfet_03v3 ad=1.235p pd=5.27u as=1.235p ps=5.27u w=4.75u l=0.5u
X211 VDD.t68 d2a.0.t8 d2a.0.t9 VDD.t67 pfet_03v3 ad=0.481p pd=2.37u as=0.481p ps=2.37u w=1.85u l=0.28u
X212 VDD.t64 d2a.0.t20 d2b.0.t15 VDD.t63 pfet_03v3 ad=0.481p pd=2.37u as=0.481p ps=2.37u w=1.85u l=0.28u
X213 VDD.t83 d2b.0.t28 d3.0.t4 VDD.t82 pfet_03v3 ad=0.481p pd=2.37u as=0.481p ps=2.37u w=1.85u l=0.28u
X214 tp.0.t0 VREF.t57 fa.0.t38 tp.0.t0 pfet_03v3 ad=1.248p pd=5.32u as=1.248p ps=5.32u w=4.8u l=0.4u
X215 fb.0.t58 VREF.t24 tp.0.t0 tp.0.t0 pfet_03v3 ad=1.248p pd=5.32u as=1.248p ps=5.32u w=4.8u l=0.4u
X216 fb.0.t20 gn.0.t23 tp.0.t0 tp.0.t0 pfet_03v3 ad=1.248p pd=5.32u as=1.248p ps=5.32u w=4.8u l=0.4u
X217 d3.0.t1 n3a.0.t13 VSS.t222 VSS.t221 nfet_03v3 ad=1.2116p pd=5.18u as=1.2116p ps=5.18u w=4.66u l=0.28u
X218 sb.0.t2 ob.0.t30 d2b.0.t17 VSS.t237 nfet_03v3 ad=1.1362p pd=4.89u as=1.1362p ps=4.89u w=4.37u l=0.5u
X219 tn.0.t46 VREF.t5 oa.0.t24 VSS.t215 nfet_03v3 ad=1.235p pd=5.27u as=1.235p ps=5.27u w=4.75u l=0.5u
X220 d2a.0.t7 d2a.0.t6 VDD.t66 VDD.t65 pfet_03v3 ad=0.481p pd=2.37u as=0.481p ps=2.37u w=1.85u l=0.28u
X221 n3a.0.t0 VSS.t48 VSS.t50 VSS.t49 nfet_03v3 ad=1.2116p pd=5.18u as=2.0504p ps=10.2u w=4.66u l=0.28u
X222 fb.0.t15 VB2.t4 ob.0.t3 VSS.t174 nfet_03v3 ad=1.1752p pd=5.04u as=1.1752p ps=5.04u w=4.52u l=0.5u
X223 tn.0.t4 VBN.t20 VSS.t134 VSS.t133 nfet_03v3 ad=0.65p pd=3.02u as=0.65p ps=3.02u w=2.5u l=1u
X224 fb.0.t37 gn.0.t31 tp.0.t0 tp.0.t0 pfet_03v3 ad=1.248p pd=5.32u as=1.248p ps=5.32u w=4.8u l=0.4u
X225 fa.0.t60 gp.0.t22 tp.0.t0 tp.0.t0 pfet_03v3 ad=1.248p pd=5.32u as=1.248p ps=5.32u w=4.8u l=0.4u
X226 tp.0.t0 VREF.t41 fa.0.t46 tp.0.t0 pfet_03v3 ad=1.248p pd=5.32u as=1.248p ps=5.32u w=4.8u l=0.4u
X227 tp.0.t0 VREF.t27 fb.0.t57 tp.0.t0 pfet_03v3 ad=1.248p pd=5.32u as=1.248p ps=5.32u w=4.8u l=0.4u
X228 ts.0.t11 VBN.t2 VSS.t156 VSS.t155 nfet_03v3 ad=0.65p pd=3.02u as=0.65p ps=3.02u w=2.5u l=1u
X229 VSS.t148 VBN.t13 tn.0.t11 VSS.t147 nfet_03v3 ad=0.65p pd=3.02u as=0.65p ps=3.02u w=2.5u l=1u
X230 VSS.t228 VSS.t229 VSS.t227 ppolyf_u_1k r_width=5u r_length=1.64u
X231 tp.0.t0 gn.0.t24 fb.0.t21 tp.0.t0 pfet_03v3 ad=1.248p pd=5.32u as=1.248p ps=5.32u w=4.8u l=0.4u
X232 tp.0.t0 VBP.t8 VDD.t181 VDD.t180 pfet_03v3 ad=1.3p pd=5.52u as=1.3p ps=5.52u w=5u l=1u
X233 tp.0.t0 gn.0.t16 fb.0.t29 tp.0.t0 pfet_03v3 ad=1.248p pd=5.32u as=1.248p ps=5.32u w=4.8u l=0.4u
X234 fa.0.t10 VBN.t30 VSS.t118 VSS.t117 nfet_03v3 ad=0.65p pd=3.02u as=0.65p ps=3.02u w=2.5u l=1u
X235 ob.0.t17 VREF.t12 tn.0.t34 VSS.t208 nfet_03v3 ad=1.235p pd=5.27u as=1.235p ps=5.27u w=4.75u l=0.5u
X236 n3a.0.t8 d2a.0.t32 VDD.t100 VDD.t99 pfet_03v3 ad=0.481p pd=2.37u as=0.481p ps=2.37u w=1.85u l=0.28u
X237 ob.0.t8 gn.0.t1 tn.0.t16 VSS.t185 nfet_03v3 ad=1.235p pd=5.27u as=1.235p ps=5.27u w=4.75u l=0.5u
X238 d3.0.t9 d2b.0.t33 VDD.t113 VDD.t112 pfet_03v3 ad=0.481p pd=2.37u as=0.481p ps=2.37u w=1.85u l=0.28u
X239 fa.0.t62 gp.0.t30 tp.0.t0 tp.0.t0 pfet_03v3 ad=1.248p pd=5.32u as=1.248p ps=5.32u w=4.8u l=0.4u
X240 ts.0.t0 VSS.t9 VSS.t11 VSS.t10 nfet_03v3 ad=0.65p pd=3.02u as=1.1p ps=5.88u w=2.5u l=1u
X241 VSS.t84 VBN.t33 fa.0.t9 VSS.t83 nfet_03v3 ad=0.65p pd=3.02u as=0.65p ps=3.02u w=2.5u l=1u
X242 tn.0.t6 VBN.t18 VSS.t138 VSS.t137 nfet_03v3 ad=0.65p pd=3.02u as=0.65p ps=3.02u w=2.5u l=1u
X243 VDD.t2 VDD.t0 VDD.t2 VDD.t1 pfet_03v3 ad=0.52p pd=2.52u as=0 ps=0 w=2u l=0.5u
X244 tp.0.t0 gp.0.t17 fa.0.t25 tp.0.t0 pfet_03v3 ad=1.248p pd=5.32u as=1.248p ps=5.32u w=4.8u l=0.4u
X245 fb.0.t35 gn.0.t29 tp.0.t0 tp.0.t0 pfet_03v3 ad=1.248p pd=5.32u as=1.248p ps=5.32u w=4.8u l=0.4u
X246 VSS.t144 VBN.t15 tn.0.t9 VSS.t143 nfet_03v3 ad=0.65p pd=3.02u as=0.65p ps=3.02u w=2.5u l=1u
X247 tp.0.t0 gn.0.t28 fb.0.t32 tp.0.t0 pfet_03v3 ad=1.248p pd=5.32u as=1.248p ps=5.32u w=4.8u l=0.4u
X248 fa.0.t34 gp.0.t12 tp.0.t0 tp.0.t0 pfet_03v3 ad=1.248p pd=5.32u as=1.248p ps=5.32u w=4.8u l=0.4u
X249 VSS.t74 VBN.t7 ts.0.t6 VSS.t73 nfet_03v3 ad=0.65p pd=3.02u as=0.65p ps=3.02u w=2.5u l=1u
X250 VDD.t47 VDD.t45 i2.0.t2 VDD.t46 pfet_03v3 ad=1.65p pd=8.38u as=0.975p ps=4.27u w=3.75u l=0.28u
X251 d2b.0.t18 d2a.0.t25 VDD.t132 VDD.t131 pfet_03v3 ad=0.481p pd=2.37u as=0.481p ps=2.37u w=1.85u l=0.28u
X252 fa.0.t14 VBN.t22 VSS.t132 VSS.t131 nfet_03v3 ad=0.65p pd=3.02u as=0.65p ps=3.02u w=2.5u l=1u
X253 tp.0.t0 VBP.t0 VDD.t197 VDD.t196 pfet_03v3 ad=1.3p pd=5.52u as=1.3p ps=5.52u w=5u l=1u
X254 VSS.t56 VSS.t54 VSS.t56 VSS.t55 nfet_03v3 ad=0.39p pd=2.02u as=0 ps=0 w=1.5u l=0.28u
X255 VSS.t80 VBN.t37 fa.0.t7 VSS.t79 nfet_03v3 ad=0.65p pd=3.02u as=0.65p ps=3.02u w=2.5u l=1u
X256 ob.0.t9 gn.0.t5 tn.0.t17 VSS.t187 nfet_03v3 ad=1.235p pd=5.27u as=1.235p ps=5.27u w=4.75u l=0.5u
X257 i2.0.t3 i1.0.t4 VDD.t149 VDD.t148 pfet_03v3 ad=0.975p pd=4.27u as=0.975p ps=4.27u w=3.75u l=0.28u
X258 tp.0.t0 VREF.t53 fa.0.t40 tp.0.t0 pfet_03v3 ad=1.248p pd=5.32u as=1.248p ps=5.32u w=4.8u l=0.4u
X259 fb.0.t24 gn.0.t21 tp.0.t0 tp.0.t0 pfet_03v3 ad=1.248p pd=5.32u as=1.248p ps=5.32u w=4.8u l=0.4u
X260 fa.0.t61 gp.0.t16 tp.0.t0 tp.0.t0 pfet_03v3 ad=1.248p pd=5.32u as=1.248p ps=5.32u w=4.8u l=0.4u
X261 oa.0.t15 gp.0.t6 tn.0.t21 VSS.t191 nfet_03v3 ad=1.235p pd=5.27u as=1.235p ps=5.27u w=4.75u l=0.5u
X262 VDD.t62 d2a.0.t24 d2b.0.t14 VDD.t61 pfet_03v3 ad=0.481p pd=2.37u as=0.481p ps=2.37u w=1.85u l=0.28u
X263 i1.0.t1 VDD.t36 VDD.t38 VDD.t37 pfet_03v3 ad=0.962p pd=4.22u as=1.628p ps=8.28u w=3.7u l=0.28u
X264 tp.0.t0 gn.0.t30 fb.0.t36 tp.0.t0 pfet_03v3 ad=1.248p pd=5.32u as=1.248p ps=5.32u w=4.8u l=0.4u
X265 fa.0.t28 gp.0.t18 tp.0.t0 tp.0.t0 pfet_03v3 ad=1.248p pd=5.32u as=1.248p ps=5.32u w=4.8u l=0.4u
X266 fa.0.t4 VBN.t42 VSS.t94 VSS.t93 nfet_03v3 ad=0.65p pd=3.02u as=0.65p ps=3.02u w=2.5u l=1u
X267 tp.0.t0 VREF.t43 fb.0.t49 tp.0.t0 pfet_03v3 ad=1.248p pd=5.32u as=1.248p ps=5.32u w=4.8u l=0.4u
X268 oa.0.t11 gp.0.t2 tn.0.t15 VSS.t184 nfet_03v3 ad=1.235p pd=5.27u as=1.235p ps=5.27u w=4.75u l=0.5u
X269 fa.0.t41 VREF.t50 tp.0.t0 tp.0.t0 pfet_03v3 ad=1.248p pd=5.32u as=1.248p ps=5.32u w=4.8u l=0.4u
X270 OUT.t7 i2.0.t10 VSS.t239 VSS.t238 nfet_03v3 ad=1.04p pd=4.52u as=1.04p ps=4.52u w=4u l=0.28u
X271 VDD.t167 VBP.t15 tp.0.t0 VDD.t166 pfet_03v3 ad=1.3p pd=5.52u as=1.3p ps=5.52u w=5u l=1u
X272 VSS.t102 VBN.t27 fb.0.t10 VSS.t101 nfet_03v3 ad=0.65p pd=3.02u as=0.65p ps=3.02u w=2.5u l=1u
X273 VDD.t187 VBP.t5 tp.0.t0 VDD.t186 pfet_03v3 ad=1.3p pd=5.52u as=1.3p ps=5.52u w=5u l=1u
X274 tp.0.t0 gp.0.t29 fa.0.t22 tp.0.t0 pfet_03v3 ad=1.248p pd=5.32u as=1.248p ps=5.32u w=4.8u l=0.4u
X275 VDD.t125 i2.0.t7 OUT.t4 VDD.t124 pfet_03v3 ad=1.3p pd=5.52u as=1.3p ps=5.52u w=5u l=0.28u
X276 tp.0.t0 gp.0.t11 fa.0.t29 tp.0.t0 pfet_03v3 ad=1.248p pd=5.32u as=1.248p ps=5.32u w=4.8u l=0.4u
X277 VDD.t92 d2a.0.t4 d2a.0.t5 VDD.t91 pfet_03v3 ad=0.481p pd=2.37u as=0.481p ps=2.37u w=1.85u l=0.28u
X278 fb.0.t46 VREF.t48 tp.0.t0 tp.0.t0 pfet_03v3 ad=1.248p pd=5.32u as=1.248p ps=5.32u w=4.8u l=0.4u
X279 tp.0.t0 VBP.t20 VDD.t157 VDD.t156 pfet_03v3 ad=1.3p pd=5.52u as=1.3p ps=5.52u w=5u l=1u
X280 fb.0.t7 VBN.t32 VSS.t116 VSS.t115 nfet_03v3 ad=0.65p pd=3.02u as=0.65p ps=3.02u w=2.5u l=1u
X281 VSS.t71 VSS.t69 OUT.t1 VSS.t70 nfet_03v3 ad=1.76p pd=8.88u as=1.04p ps=4.52u w=4u l=0.28u
X282 VDD.t41 VDD.t39 nd.0.t2 VDD.t40 pfet_03v3 ad=1.32p pd=6.88u as=0.78p ps=3.52u w=3u l=0.28u
X283 oa.0.t17 VREF.t18 tn.0.t37 VSS.t202 nfet_03v3 ad=1.235p pd=5.27u as=1.235p ps=5.27u w=4.75u l=0.5u
X284 fa.0.t15 VB2.t13 oa.0.t8 VSS.t165 nfet_03v3 ad=1.1752p pd=5.04u as=1.1752p ps=5.04u w=4.52u l=0.5u
X285 ob.0.t15 VREF.t16 tn.0.t32 VSS.t204 nfet_03v3 ad=1.235p pd=5.27u as=1.235p ps=5.27u w=4.75u l=0.5u
X286 d2b.0.t0 VSS.t33 VSS.t35 VSS.t34 nfet_03v3 ad=1.1362p pd=4.89u as=1.9228p ps=9.62u w=4.37u l=0.5u
X287 tp.0.t0 gp.0.t21 fa.0.t65 tp.0.t0 pfet_03v3 ad=1.248p pd=5.32u as=1.248p ps=5.32u w=4.8u l=0.4u
X288 fa.0.t17 VB2.t11 oa.0.t6 VSS.t167 nfet_03v3 ad=1.1752p pd=5.04u as=1.1752p ps=5.04u w=4.52u l=0.5u
X289 oa.0.t19 VREF.t14 tn.0.t39 VSS.t206 nfet_03v3 ad=1.235p pd=5.27u as=1.235p ps=5.27u w=4.75u l=0.5u
X290 oa.0.t25 VREF.t2 tn.0.t41 VSS.t218 nfet_03v3 ad=1.235p pd=5.27u as=1.235p ps=5.27u w=4.75u l=0.5u
X291 d2b.0.t13 d2a.0.t23 VDD.t60 VDD.t59 pfet_03v3 ad=0.481p pd=2.37u as=0.481p ps=2.37u w=1.85u l=0.28u
X292 d2b.0.t4 d2b.0.t3 VDD.t87 VDD.t86 pfet_03v3 ad=0.481p pd=2.37u as=0.481p ps=2.37u w=1.85u l=0.28u
X293 VSS.t41 VSS.t39 d2a.0.t1 VSS.t40 nfet_03v3 ad=1.9228p pd=9.62u as=1.1362p ps=4.89u w=4.37u l=0.5u
X294 ob.0.t1 VB2.t1 fb.0.t18 VSS.t177 nfet_03v3 ad=1.1752p pd=5.04u as=1.1752p ps=5.04u w=4.52u l=0.5u
X295 ob.0.t21 VREF.t4 tn.0.t28 VSS.t216 nfet_03v3 ad=1.235p pd=5.27u as=1.235p ps=5.27u w=4.75u l=0.5u
X296 d2b.0.t11 d2a.0.t21 VDD.t56 VDD.t55 pfet_03v3 ad=0.481p pd=2.37u as=0.481p ps=2.37u w=1.85u l=0.28u
X297 n3a.0.t12 d2a.0.t28 VDD.t138 VDD.t137 pfet_03v3 ad=0.481p pd=2.37u as=0.481p ps=2.37u w=1.85u l=0.28u
X298 fa.0.t45 VREF.t42 tp.0.t0 tp.0.t0 pfet_03v3 ad=1.248p pd=5.32u as=1.248p ps=5.32u w=4.8u l=0.4u
X299 fb.0.t44 VREF.t52 tp.0.t0 tp.0.t0 pfet_03v3 ad=1.248p pd=5.32u as=1.248p ps=5.32u w=4.8u l=0.4u
X300 VSS.t86 VBN.t9 ts.0.t4 VSS.t85 nfet_03v3 ad=0.65p pd=3.02u as=0.65p ps=3.02u w=2.5u l=1u
X301 VSS.t53 VSS.t51 d3.0.t0 VSS.t52 nfet_03v3 ad=2.0504p pd=10.2u as=1.2116p ps=5.18u w=4.66u l=0.28u
X302 tp.0.t0 VREF.t51 fb.0.t45 tp.0.t0 pfet_03v3 ad=1.248p pd=5.32u as=1.248p ps=5.32u w=4.8u l=0.4u
X303 tp.0.t0 VREF.t31 fb.0.t55 tp.0.t0 pfet_03v3 ad=1.248p pd=5.32u as=1.248p ps=5.32u w=4.8u l=0.4u
X304 fa.0.t51 VREF.t30 tp.0.t0 tp.0.t0 pfet_03v3 ad=1.248p pd=5.32u as=1.248p ps=5.32u w=4.8u l=0.4u
X305 VSS.t130 VBN.t21 tn.0.t3 VSS.t129 nfet_03v3 ad=0.65p pd=3.02u as=0.65p ps=3.02u w=2.5u l=1u
X306 VDD.t123 d2b.0.t9 d2b.0.t10 VDD.t122 pfet_03v3 ad=0.481p pd=2.37u as=0.481p ps=2.37u w=1.85u l=0.28u
X307 tp.0.t0 gn.0.t18 fb.0.t38 tp.0.t0 pfet_03v3 ad=1.248p pd=5.32u as=1.248p ps=5.32u w=4.8u l=0.4u
X308 VDD.t26 VDD.t24 VDD.t26 VDD.t25 pfet_03v3 ad=0.52p pd=2.52u as=0 ps=0 w=2u l=0.5u
X309 VDD.t58 d2a.0.t22 d2b.0.t12 VDD.t57 pfet_03v3 ad=0.481p pd=2.37u as=0.481p ps=2.37u w=1.85u l=0.28u
X310 VDD.t136 d2a.0.t27 n3a.0.t11 VDD.t135 pfet_03v3 ad=0.481p pd=2.37u as=0.481p ps=2.37u w=1.85u l=0.28u
X311 tp.0.t0 VREF.t63 fb.0.t39 tp.0.t0 pfet_03v3 ad=1.248p pd=5.32u as=2.112p ps=10.48u w=4.8u l=0.4u
X312 fb.0.t34 gn.0.t11 tp.0.t0 tp.0.t0 pfet_03v3 ad=1.248p pd=5.32u as=1.248p ps=5.32u w=4.8u l=0.4u
X313 tn.0.t51 gp.0.t9 oa.0.t28 VSS.t256 nfet_03v3 ad=1.235p pd=5.27u as=1.235p ps=5.27u w=4.75u l=0.5u
X314 d2a.0.t10 VDD.t15 VDD.t17 VDD.t16 pfet_03v3 ad=0.52p pd=2.52u as=0.88p ps=4.88u w=2u l=0.5u
X315 ts.0.t9 VBN.t4 VSS.t160 VSS.t159 nfet_03v3 ad=0.65p pd=3.02u as=0.65p ps=3.02u w=2.5u l=1u
X316 VSS.t44 VSS.t42 d2b.0.t1 VSS.t43 nfet_03v3 ad=1.9228p pd=9.62u as=1.1362p ps=4.89u w=4.37u l=0.5u
X317 tp.0.t0 VREF.t49 fa.0.t42 tp.0.t0 pfet_03v3 ad=1.248p pd=5.32u as=1.248p ps=5.32u w=4.8u l=0.4u
X318 tp.0.t0 VREF.t33 fa.0.t50 tp.0.t0 pfet_03v3 ad=1.248p pd=5.32u as=1.248p ps=5.32u w=4.8u l=0.4u
X319 VSS.t5 VSS.t3 tn.0.t1 VSS.t4 nfet_03v3 ad=1.1p pd=5.88u as=0.65p ps=3.02u w=2.5u l=1u
X320 d2a.0.t0 VSS.t36 VSS.t38 VSS.t37 nfet_03v3 ad=1.1362p pd=4.89u as=1.9228p ps=9.62u w=4.37u l=0.5u
X321 d2b.0.t8 d2b.0.t7 VDD.t121 VDD.t120 pfet_03v3 ad=0.481p pd=2.37u as=0.481p ps=2.37u w=1.85u l=0.28u
X322 VDD.t98 d2a.0.t31 n3a.0.t7 VDD.t97 pfet_03v3 ad=0.481p pd=2.37u as=0.481p ps=2.37u w=1.85u l=0.28u
R0 OUT.n6 OUT 9.0005
R1 OUT.n2 OUT 9.0005
R2 OUT.n7 OUT 5.04371
R3 OUT OUT.n7 2.23121
R4 OUT.n7 OUT 1.78121
R5 OUT OUT.n6 0.93425
R6 OUT OUT.n1 0.879957
R7 OUT OUT.n0 0.879957
R8 OUT OUT.n2 0.698
R9 OUT OUT.n5 0.612457
R10 OUT OUT.n4 0.612457
R11 OUT OUT.n3 0.612457
R12 OUT.n6 OUT 0.476214
R13 OUT.n1 OUT.t8 0.41
R14 OUT.n1 OUT.t0 0.41
R15 OUT.n0 OUT.t1 0.41
R16 OUT.n0 OUT.t7 0.41
R17 OUT.n5 OUT.t6 0.3645
R18 OUT.n5 OUT.t2 0.3645
R19 OUT.n4 OUT.t4 0.3645
R20 OUT.n4 OUT.t5 0.3645
R21 OUT.n3 OUT.t3 0.3645
R22 OUT.n3 OUT.t9 0.3645
R23 OUT.n2 OUT 0.238357
R24 EN EN.t0 54.0878
R25 EN EN.t1 40.9915
R26 EN EN.t3 27.4653
R27 EN EN.t2 27.4653
R28 EN.n0 EN 10.1384
R29 EN EN.n2 8.30621
R30 EN.n0 EN 6.05621
R31 EN.n1 EN 5.94371
R32 EN.n2 EN 5.71871
R33 EN.n1 EN.n0 3.78693
R34 EN.n2 EN.n1 0.411929
R35 VBN.n33 VBN.t22 17.1092
R36 VBN.n23 VBN.t12 15.9196
R37 VBN.n11 VBN.t44 15.9196
R38 VBN.n0 VBN.t11 15.9196
R39 VBN.n22 VBN 15.3551
R40 VBN.n31 VBN.t21 15.3248
R41 VBN.n30 VBN.t20 15.3248
R42 VBN.n29 VBN.t19 15.3248
R43 VBN.n28 VBN.t18 15.3248
R44 VBN.n27 VBN.t17 15.3248
R45 VBN.n26 VBN.t16 15.3248
R46 VBN.n25 VBN.t15 15.3248
R47 VBN.n24 VBN.t14 15.3248
R48 VBN.n23 VBN.t13 15.3248
R49 VBN.n43 VBN.t45 15.3248
R50 VBN.n42 VBN.t42 15.3248
R51 VBN.n41 VBN.t41 15.3248
R52 VBN.n40 VBN.t38 15.3248
R53 VBN.n39 VBN.t37 15.3248
R54 VBN.n38 VBN.t34 15.3248
R55 VBN.n37 VBN.t33 15.3248
R56 VBN.n36 VBN.t30 15.3248
R57 VBN.n35 VBN.t29 15.3248
R58 VBN.n34 VBN.t26 15.3248
R59 VBN.n33 VBN.t25 15.3248
R60 VBN.n21 VBN.t23 15.3248
R61 VBN.n20 VBN.t24 15.3248
R62 VBN.n19 VBN.t27 15.3248
R63 VBN.n18 VBN.t28 15.3248
R64 VBN.n17 VBN.t31 15.3248
R65 VBN.n16 VBN.t32 15.3248
R66 VBN.n15 VBN.t35 15.3248
R67 VBN.n14 VBN.t36 15.3248
R68 VBN.n13 VBN.t39 15.3248
R69 VBN.n12 VBN.t40 15.3248
R70 VBN.n11 VBN.t43 15.3248
R71 VBN.n0 VBN.t10 15.3248
R72 VBN.n1 VBN.t9 15.3248
R73 VBN.n2 VBN.t8 15.3248
R74 VBN.n3 VBN.t7 15.3248
R75 VBN.n4 VBN.t6 15.3248
R76 VBN.n5 VBN.t5 15.3248
R77 VBN.n6 VBN.t4 15.3248
R78 VBN.n7 VBN.t3 15.3248
R79 VBN.n8 VBN.t2 15.3248
R80 VBN.n9 VBN.t1 15.3248
R81 VBN.n10 VBN.t0 15.3248
R82 VBN VBN.n21 10.9238
R83 VBN VBN.n31 10.329
R84 VBN VBN.n43 10.329
R85 VBN VBN.n10 10.329
R86 VBN.n44 VBN.n32 8.96193
R87 VBN VBN.n22 8.08121
R88 VBN VBN.n44 8.08121
R89 VBN.n32 VBN 5.63836
R90 VBN.n32 VBN 5.49371
R91 VBN.n44 VBN 5.49371
R92 VBN.n22 VBN 4.81871
R93 VBN.n35 VBN.n34 1.78485
R94 VBN.n37 VBN.n36 1.78485
R95 VBN.n41 VBN.n40 1.78485
R96 VBN.n43 VBN.n42 1.78485
R97 VBN.n20 VBN.n19 1.78485
R98 VBN.n18 VBN.n17 1.78485
R99 VBN.n16 VBN.n15 1.78485
R100 VBN.n14 VBN.n13 1.78485
R101 VBN.n12 VBN.n11 1.78485
R102 VBN.n39 VBN 1.38376
R103 VBN.n24 VBN.n23 0.595283
R104 VBN.n25 VBN.n24 0.595283
R105 VBN.n26 VBN.n25 0.595283
R106 VBN.n27 VBN.n26 0.595283
R107 VBN.n29 VBN.n28 0.595283
R108 VBN.n30 VBN.n29 0.595283
R109 VBN.n31 VBN.n30 0.595283
R110 VBN.n34 VBN.n33 0.595283
R111 VBN.n36 VBN.n35 0.595283
R112 VBN.n38 VBN.n37 0.595283
R113 VBN.n40 VBN.n39 0.595283
R114 VBN.n42 VBN.n41 0.595283
R115 VBN.n21 VBN.n20 0.595283
R116 VBN.n19 VBN.n18 0.595283
R117 VBN.n15 VBN.n14 0.595283
R118 VBN.n13 VBN.n12 0.595283
R119 VBN.n10 VBN.n9 0.595283
R120 VBN.n9 VBN.n8 0.595283
R121 VBN.n8 VBN.n7 0.595283
R122 VBN.n7 VBN.n6 0.595283
R123 VBN.n5 VBN.n4 0.595283
R124 VBN.n4 VBN.n3 0.595283
R125 VBN.n3 VBN.n2 0.595283
R126 VBN.n2 VBN.n1 0.595283
R127 VBN.n1 VBN.n0 0.595283
R128 VBN.n17 VBN 0.491587
R129 VBN VBN.n38 0.401587
R130 VBN VBN.n27 0.39963
R131 VBN VBN.n5 0.39963
R132 VBN.n28 VBN 0.196152
R133 VBN.n6 VBN 0.196152
R134 VBN VBN.n16 0.104196
R135 VB2.n6 VB2.t7 45.65
R136 VB2.n0 VB2.t6 45.65
R137 VB2.n11 VB2.t13 45.2508
R138 VB2.n10 VB2.t12 45.2508
R139 VB2.n9 VB2.t11 45.2508
R140 VB2.n8 VB2.t10 45.2508
R141 VB2.n7 VB2.t9 45.2508
R142 VB2.n6 VB2.t8 45.2508
R143 VB2.n0 VB2.t5 45.2508
R144 VB2.n1 VB2.t4 45.2508
R145 VB2.n2 VB2.t3 45.2508
R146 VB2.n3 VB2.t2 45.2508
R147 VB2.n4 VB2.t1 45.2508
R148 VB2.n5 VB2.t0 45.2508
R149 VB2 VB2.n12 13.7062
R150 VB2 VB2.n11 10.0355
R151 VB2 VB2.n5 10.0355
R152 VB2.n12 VB2 9.01336
R153 VB2.n12 VB2 4.81871
R154 VB2.n7 VB2.n6 0.39963
R155 VB2.n8 VB2.n7 0.39963
R156 VB2.n9 VB2.n8 0.39963
R157 VB2.n11 VB2.n10 0.39963
R158 VB2.n5 VB2.n4 0.39963
R159 VB2.n3 VB2.n2 0.39963
R160 VB2.n2 VB2.n1 0.39963
R161 VB2.n1 VB2.n0 0.39963
R162 VB2.n10 VB2 0.248978
R163 VB2.n4 VB2 0.248978
R164 VB2 VB2.n9 0.151152
R165 VB2 VB2.n3 0.151152
R166 VREF.n31 VREF.t44 57.4425
R167 VREF.n0 VREF.t43 57.4425
R168 VREF.n49 VREF.t63 57.0825
R169 VREF.n48 VREF.t62 57.0825
R170 VREF.n47 VREF.t61 57.0825
R171 VREF.n46 VREF.t60 57.0825
R172 VREF.n45 VREF.t59 57.0825
R173 VREF.n44 VREF.t58 57.0825
R174 VREF.n43 VREF.t57 57.0825
R175 VREF.n42 VREF.t56 57.0825
R176 VREF.n41 VREF.t55 57.0825
R177 VREF.n40 VREF.t54 57.0825
R178 VREF.n39 VREF.t53 57.0825
R179 VREF.n38 VREF.t52 57.0825
R180 VREF.n37 VREF.t51 57.0825
R181 VREF.n36 VREF.t50 57.0825
R182 VREF.n35 VREF.t49 57.0825
R183 VREF.n34 VREF.t48 57.0825
R184 VREF.n33 VREF.t47 57.0825
R185 VREF.n32 VREF.t46 57.0825
R186 VREF.n31 VREF.t45 57.0825
R187 VREF.n22 VREF.t20 57.0825
R188 VREF.n21 VREF.t21 57.0825
R189 VREF.n20 VREF.t22 57.0825
R190 VREF.n19 VREF.t23 57.0825
R191 VREF.n18 VREF.t24 57.0825
R192 VREF.n17 VREF.t25 57.0825
R193 VREF.n16 VREF.t26 57.0825
R194 VREF.n15 VREF.t27 57.0825
R195 VREF.n14 VREF.t28 57.0825
R196 VREF.n13 VREF.t29 57.0825
R197 VREF.n12 VREF.t30 57.0825
R198 VREF.n11 VREF.t31 57.0825
R199 VREF.n10 VREF.t32 57.0825
R200 VREF.n9 VREF.t33 57.0825
R201 VREF.n8 VREF.t34 57.0825
R202 VREF.n7 VREF.t35 57.0825
R203 VREF.n6 VREF.t36 57.0825
R204 VREF.n5 VREF.t37 57.0825
R205 VREF.n4 VREF.t38 57.0825
R206 VREF.n3 VREF.t39 57.0825
R207 VREF.n2 VREF.t40 57.0825
R208 VREF.n1 VREF.t41 57.0825
R209 VREF.n0 VREF.t42 57.0825
R210 VREF.n51 VREF.t8 47.329
R211 VREF.n23 VREF.t7 47.329
R212 VREF.n61 VREF.t19 46.9298
R213 VREF.n60 VREF.t18 46.9298
R214 VREF.n59 VREF.t17 46.9298
R215 VREF.n58 VREF.t16 46.9298
R216 VREF.n57 VREF.t15 46.9298
R217 VREF.n56 VREF.t14 46.9298
R218 VREF.n55 VREF.t13 46.9298
R219 VREF.n54 VREF.t12 46.9298
R220 VREF.n53 VREF.t11 46.9298
R221 VREF.n52 VREF.t10 46.9298
R222 VREF.n51 VREF.t9 46.9298
R223 VREF.n29 VREF.t0 46.9298
R224 VREF.n28 VREF.t1 46.9298
R225 VREF.n27 VREF.t2 46.9298
R226 VREF.n26 VREF.t3 46.9298
R227 VREF.n25 VREF.t4 46.9298
R228 VREF.n24 VREF.t5 46.9298
R229 VREF.n23 VREF.t6 46.9298
R230 VREF.n30 VREF 11.0801
R231 VREF VREF.n49 9.73811
R232 VREF VREF.n22 9.73811
R233 VREF VREF.n61 9.63637
R234 VREF VREF.n29 9.63637
R235 VREF.n30 VREF 8.86871
R236 VREF.n50 VREF 7.88836
R237 VREF.n62 VREF 7.85621
R238 VREF VREF.n30 7.85621
R239 VREF VREF.n62 7.85621
R240 VREF.n62 VREF.n50 6.93693
R241 VREF.n50 VREF 5.83121
R242 VREF.n52 VREF.n51 0.39963
R243 VREF.n53 VREF.n52 0.39963
R244 VREF.n54 VREF.n53 0.39963
R245 VREF.n55 VREF.n54 0.39963
R246 VREF.n56 VREF.n55 0.39963
R247 VREF.n58 VREF.n57 0.39963
R248 VREF.n59 VREF.n58 0.39963
R249 VREF.n60 VREF.n59 0.39963
R250 VREF.n61 VREF.n60 0.39963
R251 VREF.n29 VREF.n28 0.39963
R252 VREF.n28 VREF.n27 0.39963
R253 VREF.n26 VREF.n25 0.39963
R254 VREF.n25 VREF.n24 0.39963
R255 VREF.n24 VREF.n23 0.39963
R256 VREF.n32 VREF.n31 0.3605
R257 VREF.n33 VREF.n32 0.3605
R258 VREF.n34 VREF.n33 0.3605
R259 VREF.n35 VREF.n34 0.3605
R260 VREF.n36 VREF.n35 0.3605
R261 VREF.n37 VREF.n36 0.3605
R262 VREF.n38 VREF.n37 0.3605
R263 VREF.n39 VREF.n38 0.3605
R264 VREF.n40 VREF.n39 0.3605
R265 VREF.n42 VREF.n41 0.3605
R266 VREF.n43 VREF.n42 0.3605
R267 VREF.n44 VREF.n43 0.3605
R268 VREF.n45 VREF.n44 0.3605
R269 VREF.n46 VREF.n45 0.3605
R270 VREF.n47 VREF.n46 0.3605
R271 VREF.n48 VREF.n47 0.3605
R272 VREF.n49 VREF.n48 0.3605
R273 VREF.n22 VREF.n21 0.3605
R274 VREF.n21 VREF.n20 0.3605
R275 VREF.n20 VREF.n19 0.3605
R276 VREF.n19 VREF.n18 0.3605
R277 VREF.n18 VREF.n17 0.3605
R278 VREF.n17 VREF.n16 0.3605
R279 VREF.n16 VREF.n15 0.3605
R280 VREF.n15 VREF.n14 0.3605
R281 VREF.n14 VREF.n13 0.3605
R282 VREF.n13 VREF.n12 0.3605
R283 VREF.n11 VREF.n10 0.3605
R284 VREF.n10 VREF.n9 0.3605
R285 VREF.n9 VREF.n8 0.3605
R286 VREF.n8 VREF.n7 0.3605
R287 VREF.n7 VREF.n6 0.3605
R288 VREF.n6 VREF.n5 0.3605
R289 VREF.n5 VREF.n4 0.3605
R290 VREF.n4 VREF.n3 0.3605
R291 VREF.n3 VREF.n2 0.3605
R292 VREF.n2 VREF.n1 0.3605
R293 VREF.n1 VREF.n0 0.3605
R294 VREF.n57 VREF 0.247022
R295 VREF.n27 VREF 0.247022
R296 VREF VREF.n11 0.223543
R297 VREF VREF.n40 0.221587
R298 VREF VREF.n56 0.153109
R299 VREF VREF.n26 0.153109
R300 VREF.n41 VREF 0.139413
R301 VREF.n12 VREF 0.137457
R302 INN INN.t0 1.2823
R303 VBP.n0 VBP.t0 25.0446
R304 VBP.n20 VBP.t21 24.4498
R305 VBP.n19 VBP.t20 24.4498
R306 VBP.n18 VBP.t19 24.4498
R307 VBP.n17 VBP.t18 24.4498
R308 VBP.n16 VBP.t17 24.4498
R309 VBP.n15 VBP.t16 24.4498
R310 VBP.n14 VBP.t15 24.4498
R311 VBP.n13 VBP.t14 24.4498
R312 VBP.n12 VBP.t13 24.4498
R313 VBP.n11 VBP.t12 24.4498
R314 VBP.n10 VBP.t11 24.4498
R315 VBP.n9 VBP.t10 24.4498
R316 VBP.n8 VBP.t9 24.4498
R317 VBP.n7 VBP.t8 24.4498
R318 VBP.n6 VBP.t7 24.4498
R319 VBP.n5 VBP.t6 24.4498
R320 VBP.n4 VBP.t5 24.4498
R321 VBP.n3 VBP.t4 24.4498
R322 VBP.n2 VBP.t3 24.4498
R323 VBP.n1 VBP.t2 24.4498
R324 VBP.n0 VBP.t1 24.4498
R325 VBP.n21 VBP 15.5384
R326 VBP VBP.n20 10.4503
R327 VBP VBP.n21 7.18121
R328 VBP.n21 VBP 4.70621
R329 VBP.n1 VBP.n0 0.595283
R330 VBP.n2 VBP.n1 0.595283
R331 VBP.n3 VBP.n2 0.595283
R332 VBP.n4 VBP.n3 0.595283
R333 VBP.n5 VBP.n4 0.595283
R334 VBP.n6 VBP.n5 0.595283
R335 VBP.n7 VBP.n6 0.595283
R336 VBP.n8 VBP.n7 0.595283
R337 VBP.n9 VBP.n8 0.595283
R338 VBP.n10 VBP.n9 0.595283
R339 VBP.n12 VBP.n11 0.595283
R340 VBP.n13 VBP.n12 0.595283
R341 VBP.n14 VBP.n13 0.595283
R342 VBP.n15 VBP.n14 0.595283
R343 VBP.n16 VBP.n15 0.595283
R344 VBP.n17 VBP.n16 0.595283
R345 VBP.n18 VBP.n17 0.595283
R346 VBP.n19 VBP.n18 0.595283
R347 VBP.n20 VBP.n19 0.595283
R348 VBP VBP.n10 0.462239
R349 VBP.n11 VBP 0.133543
R350 INP INP.t0 1.2823
R351 VDD.n111 VDD.t1 490.897
R352 VDD.t16 VDD.n110 490.897
R353 VDD.t25 VDD.n33 490.897
R354 VDD.t31 VDD.n34 490.897
R355 VDD.n76 VDD.t10 484.788
R356 VDD.t13 VDD.n70 484.788
R357 VDD.t22 VDD.n118 484.788
R358 VDD.t19 VDD.n119 484.788
R359 VDD.n251 VDD.n4 434.175
R360 VDD.n249 VDD.n4 434.175
R361 VDD.n251 VDD.n5 434.175
R362 VDD.n249 VDD.n5 434.175
R363 VDD.n103 VDD.t40 406.473
R364 VDD.t34 VDD.n101 406.473
R365 VDD.n49 VDD.t28 370.091
R366 VDD.t37 VDD.n48 370.091
R367 VDD.n157 VDD.t46 367.702
R368 VDD.t43 VDD.n155 367.702
R369 VDD.t7 VDD.n4 356.781
R370 VDD.t4 VDD.n5 356.781
R371 VDD.t52 VDD.n23 317.307
R372 VDD.t49 VDD.n24 317.307
R373 VDD.n144 VDD.n118 241.413
R374 VDD.n146 VDD.n118 241.413
R375 VDD.n144 VDD.n119 241.413
R376 VDD.n146 VDD.n119 241.413
R377 VDD.n73 VDD.n70 213.413
R378 VDD.n74 VDD.n70 213.413
R379 VDD.n76 VDD.n74 213.413
R380 VDD.n76 VDD.n73 213.413
R381 VDD.t1 VDD.t140 166.667
R382 VDD.t140 VDD.t16 166.667
R383 VDD.t142 VDD.t25 166.667
R384 VDD.t142 VDD.t31 166.667
R385 VDD.t196 VDD.t7 166.667
R386 VDD.t194 VDD.t196 166.667
R387 VDD.t192 VDD.t194 166.667
R388 VDD.t190 VDD.t192 166.667
R389 VDD.t188 VDD.t190 166.667
R390 VDD.t186 VDD.t188 166.667
R391 VDD.t184 VDD.t186 166.667
R392 VDD.t182 VDD.t184 166.667
R393 VDD.t180 VDD.t182 166.667
R394 VDD.t178 VDD.t180 166.667
R395 VDD.t176 VDD.t178 166.667
R396 VDD.t174 VDD.t172 166.667
R397 VDD.t172 VDD.t170 166.667
R398 VDD.t170 VDD.t168 166.667
R399 VDD.t168 VDD.t166 166.667
R400 VDD.t166 VDD.t164 166.667
R401 VDD.t164 VDD.t162 166.667
R402 VDD.t162 VDD.t160 166.667
R403 VDD.t160 VDD.t158 166.667
R404 VDD.t158 VDD.t156 166.667
R405 VDD.t156 VDD.t154 166.667
R406 VDD.t154 VDD.t4 166.667
R407 VDD.n178 VDD.n24 156.976
R408 VDD.n176 VDD.n24 156.976
R409 VDD.n176 VDD.n23 156.976
R410 VDD.n178 VDD.n23 156.976
R411 VDD.t10 VDD.t133 134.004
R412 VDD.t133 VDD.t78 134.004
R413 VDD.t78 VDD.t80 134.004
R414 VDD.t80 VDD.t135 134.004
R415 VDD.t135 VDD.t137 134.004
R416 VDD.t137 VDD.t82 134.004
R417 VDD.t82 VDD.t84 134.004
R418 VDD.t84 VDD.t93 134.004
R419 VDD.t95 VDD.t106 134.004
R420 VDD.t106 VDD.t108 134.004
R421 VDD.t108 VDD.t97 134.004
R422 VDD.t97 VDD.t99 134.004
R423 VDD.t99 VDD.t110 134.004
R424 VDD.t110 VDD.t112 134.004
R425 VDD.t112 VDD.t104 134.004
R426 VDD.t104 VDD.t13 134.004
R427 VDD.t67 VDD.t22 134.004
R428 VDD.t65 VDD.t67 134.004
R429 VDD.t122 VDD.t65 134.004
R430 VDD.t120 VDD.t122 134.004
R431 VDD.t114 VDD.t120 134.004
R432 VDD.t116 VDD.t114 134.004
R433 VDD.t63 VDD.t116 134.004
R434 VDD.t55 VDD.t63 134.004
R435 VDD.t57 VDD.t55 134.004
R436 VDD.t59 VDD.t57 134.004
R437 VDD.t69 VDD.t71 134.004
R438 VDD.t71 VDD.t61 134.004
R439 VDD.t61 VDD.t131 134.004
R440 VDD.t131 VDD.t73 134.004
R441 VDD.t73 VDD.t75 134.004
R442 VDD.t75 VDD.t88 134.004
R443 VDD.t88 VDD.t86 134.004
R444 VDD.t86 VDD.t91 134.004
R445 VDD.t91 VDD.t102 134.004
R446 VDD.t102 VDD.t19 134.004
R447 VDD.n157 VDD.n152 132.038
R448 VDD.n157 VDD.n154 132.038
R449 VDD.n155 VDD.n152 132.038
R450 VDD.n155 VDD.n154 132.038
R451 VDD.n103 VDD.n66 125.475
R452 VDD.n103 VDD.n67 125.475
R453 VDD.n101 VDD.n66 125.475
R454 VDD.n101 VDD.n67 125.475
R455 VDD.n49 VDD.n45 124.6
R456 VDD.n49 VDD.n47 124.6
R457 VDD.n48 VDD.n45 124.6
R458 VDD.n48 VDD.n47 124.6
R459 VDD.n233 VDD.n227 120.862
R460 VDD.n231 VDD.n230 120.862
R461 VDD.n196 VDD.n190 120.862
R462 VDD.n193 VDD.n191 120.862
R463 VDD.n111 VDD.n59 115.501
R464 VDD.n111 VDD.n60 115.501
R465 VDD.n110 VDD.n59 115.501
R466 VDD.n110 VDD.n60 115.501
R467 VDD.n168 VDD.n33 115.501
R468 VDD.n169 VDD.n33 115.501
R469 VDD.n168 VDD.n34 115.501
R470 VDD.n169 VDD.n34 115.501
R471 VDD.t40 VDD.t144 112.361
R472 VDD.t118 VDD.t34 112.361
R473 VDD.n240 VDD.n235 106.576
R474 VDD.n238 VDD.n237 106.576
R475 VDD.n13 VDD.n8 106.576
R476 VDD.n10 VDD.n9 106.576
R477 VDD.n230 VDD.n229 102.594
R478 VDD.n233 VDD.n232 102.594
R479 VDD.n194 VDD.n190 102.594
R480 VDD.n195 VDD.n191 102.594
R481 VDD.t28 VDD.t152 102.302
R482 VDD.t152 VDD.t37 102.302
R483 VDD.t46 VDD.t148 101.653
R484 VDD.t150 VDD.t43 101.653
R485 VDD.n237 VDD.n236 91.2621
R486 VDD.n240 VDD.n239 91.2621
R487 VDD.n11 VDD.n8 91.2621
R488 VDD.n12 VDD.n9 91.2621
R489 VDD.t146 VDD.t52 87.7198
R490 VDD.t124 VDD.t146 87.7198
R491 VDD.t126 VDD.t128 87.7198
R492 VDD.t128 VDD.t49 87.7198
R493 VDD.n250 VDD.t176 83.3338
R494 VDD.n250 VDD.t174 83.3338
R495 VDD.n25 VDD.t51 80.6719
R496 VDD.n175 VDD.t48 80.6719
R497 VDD.t93 VDD.n75 67.0022
R498 VDD.n75 VDD.t95 67.0022
R499 VDD.n145 VDD.t59 67.0022
R500 VDD.n145 VDD.t69 67.0022
R501 VDD.n153 VDD.t42 64.3772
R502 VDD.n151 VDD.t45 64.3772
R503 VDD.n46 VDD.t36 63.7254
R504 VDD.n44 VDD.t27 63.7254
R505 VDD.t144 VDD.n102 56.1803
R506 VDD.n102 VDD.t118 56.1803
R507 VDD.n100 VDD.t33 54.6004
R508 VDD.n65 VDD.t39 54.6004
R509 VDD.t148 VDD.n156 50.8264
R510 VDD.n156 VDD.t150 50.8264
R511 VDD.n177 VDD.t124 43.8601
R512 VDD.n177 VDD.t126 43.8601
R513 VDD.n71 VDD.t9 39.6094
R514 VDD.n94 VDD.t12 39.6094
R515 VDD.n120 VDD.t21 39.6094
R516 VDD.n142 VDD.t18 39.6094
R517 VDD.n58 VDD.t0 27.9583
R518 VDD.n109 VDD.t15 27.9583
R519 VDD.n31 VDD.t24 27.9583
R520 VDD.n166 VDD.t30 27.9583
R521 VDD.n248 VDD.t3 25.6511
R522 VDD.n6 VDD.t6 25.6511
R523 VDD.n242 VDD 11.093
R524 VDD.n187 VDD 11.093
R525 VDD.n243 VDD 10.5659
R526 VDD.n198 VDD 10.5659
R527 VDD.n78 VDD 9.47621
R528 VDD.n27 VDD 9.47621
R529 VDD.n37 VDD 9.28978
R530 VDD.n122 VDD 9.21907
R531 VDD VDD.n141 9.21907
R532 VDD.n78 VDD 9.0005
R533 VDD.n80 VDD 9.0005
R534 VDD.n82 VDD 9.0005
R535 VDD.n84 VDD 9.0005
R536 VDD.n86 VDD 9.0005
R537 VDD.n88 VDD 9.0005
R538 VDD.n90 VDD 9.0005
R539 VDD.n92 VDD 9.0005
R540 VDD VDD.n93 9.0005
R541 VDD VDD.n57 9.0005
R542 VDD.n114 VDD 9.0005
R543 VDD.n141 VDD 9.0005
R544 VDD.n139 VDD 9.0005
R545 VDD.n137 VDD 9.0005
R546 VDD.n135 VDD 9.0005
R547 VDD.n133 VDD 9.0005
R548 VDD.n130 VDD 9.0005
R549 VDD.n128 VDD 9.0005
R550 VDD.n126 VDD 9.0005
R551 VDD.n124 VDD 9.0005
R552 VDD.n122 VDD 9.0005
R553 VDD.n37 VDD 9.0005
R554 VDD VDD.n165 9.0005
R555 VDD.n105 VDD 9.0005
R556 VDD.n52 VDD 9.0005
R557 VDD VDD.n42 9.0005
R558 VDD.n159 VDD 9.0005
R559 VDD.n29 VDD 9.0005
R560 VDD.n27 VDD 9.0005
R561 VDD VDD.n173 9.0005
R562 VDD.n204 VDD 9.0005
R563 VDD.n206 VDD 9.0005
R564 VDD.n208 VDD 9.0005
R565 VDD.n210 VDD 9.0005
R566 VDD.n212 VDD 9.0005
R567 VDD.n215 VDD 9.0005
R568 VDD.n217 VDD 9.0005
R569 VDD.n219 VDD 9.0005
R570 VDD.n221 VDD 9.0005
R571 VDD.n223 VDD 9.0005
R572 VDD VDD.n246 9.0005
R573 VDD.n202 VDD 9.0005
R574 VDD VDD.n14 5.76371
R575 VDD.n15 VDD 5.76371
R576 VDD VDD.n172 5.60621
R577 VDD.n106 VDD 5.49371
R578 VDD VDD.n41 5.49371
R579 VDD VDD.n30 5.49371
R580 VDD VDD.n6 5.358
R581 VDD VDD.n248 5.358
R582 VDD.n16 VDD 5.3105
R583 VDD.n115 VDD 5.26871
R584 VDD VDD.n164 5.26871
R585 VDD VDD.n245 5.26871
R586 VDD VDD.n200 5.26871
R587 VDD.n96 VDD 5.24657
R588 VDD VDD.n97 5.13693
R589 VDD VDD.n63 5.13693
R590 VDD.n55 VDD 5.13693
R591 VDD VDD.n40 5.13693
R592 VDD.n163 VDD 5.13693
R593 VDD VDD.n149 5.13693
R594 VDD VDD.n20 5.13693
R595 VDD.n180 VDD 5.13693
R596 VDD.n96 VDD 4.93121
R597 VDD VDD.n69 4.93121
R598 VDD VDD.n107 4.93121
R599 VDD VDD.n56 4.93121
R600 VDD VDD.n116 4.93121
R601 VDD.n148 VDD 4.93121
R602 VDD.n38 VDD 4.93121
R603 VDD.n171 VDD 4.93121
R604 VDD VDD.n224 4.85086
R605 VDD VDD.n241 4.85086
R606 VDD.n242 VDD 4.85086
R607 VDD VDD.n243 4.85086
R608 VDD.n244 VDD 4.85086
R609 VDD VDD.n1 4.85086
R610 VDD VDD.n0 4.85086
R611 VDD VDD.n7 4.85086
R612 VDD.n199 VDD 4.85086
R613 VDD VDD.n198 4.85086
R614 VDD.n187 VDD 4.85086
R615 VDD VDD.n186 4.85086
R616 VDD.n252 VDD.n2 4.718
R617 VDD.n252 VDD.n3 4.718
R618 VDD.n186 VDD 4.70528
R619 VDD VDD.n95 4.5005
R620 VDD.n72 VDD 4.5005
R621 VDD.n108 VDD 4.5005
R622 VDD.n62 VDD 4.5005
R623 VDD.n117 VDD 4.5005
R624 VDD VDD.n147 4.5005
R625 VDD VDD.n32 4.5005
R626 VDD VDD.n170 4.5005
R627 VDD.n68 VDD 4.5005
R628 VDD.n98 VDD 4.5005
R629 VDD.n43 VDD 4.5005
R630 VDD VDD.n54 4.5005
R631 VDD.n150 VDD 4.5005
R632 VDD VDD.n162 4.5005
R633 VDD.n22 VDD 4.5005
R634 VDD VDD.n179 4.5005
R635 VDD.n14 VDD 4.5005
R636 VDD.n15 VDD 4.5005
R637 VDD.n185 VDD.n17 4.5005
R638 VDD.n183 VDD.n19 4.5005
R639 VDD.n2 VDD 4.5005
R640 VDD VDD.n252 4.5005
R641 VDD.n3 VDD 4.5005
R642 VDD.n181 VDD.n180 4.25633
R643 VDD VDD.t77 3.57
R644 VDD VDD.t90 3.57
R645 VDD VDD.n120 2.998
R646 VDD.n234 VDD.n226 2.6483
R647 VDD.n228 VDD.n226 2.6483
R648 VDD.n228 VDD.n225 2.6483
R649 VDD.n197 VDD.n189 2.6483
R650 VDD.n192 VDD.n189 2.6483
R651 VDD.n192 VDD.n188 2.6483
R652 VDD VDD.n71 2.598
R653 VDD.t23 VDD 2.50146
R654 VDD VDD.t20 2.50146
R655 VDD VDD.n234 2.4449
R656 VDD VDD.n188 2.4449
R657 VDD.n147 VDD 2.363
R658 VDD VDD.n117 2.363
R659 VDD.n17 VDD.n16 2.3396
R660 VDD VDD.t2 2.30246
R661 VDD VDD.t17 2.30246
R662 VDD.t26 VDD 2.30246
R663 VDD VDD.t32 2.30246
R664 VDD VDD.t11 2.28428
R665 VDD VDD.t14 2.28428
R666 VDD.n182 VDD.n181 2.24472
R667 VDD.n184 VDD.n183 2.23795
R668 VDD.n18 VDD.n17 2.23795
R669 VDD.n95 VDD 1.963
R670 VDD.n72 VDD 1.963
R671 VDD.n112 VDD 1.5705
R672 VDD VDD.n35 1.5705
R673 VDD VDD.t35 1.56579
R674 VDD VDD.t41 1.56579
R675 VDD VDD.n140 1.51767
R676 VDD VDD.n138 1.51767
R677 VDD VDD.n136 1.51767
R678 VDD VDD.n134 1.51767
R679 VDD VDD.n132 1.51767
R680 VDD VDD.n131 1.51767
R681 VDD VDD.n129 1.51767
R682 VDD VDD.n127 1.51767
R683 VDD VDD.n125 1.51767
R684 VDD VDD.n123 1.51767
R685 VDD VDD.n121 1.51767
R686 VDD VDD.n175 1.398
R687 VDD VDD.n25 1.398
R688 VDD.n113 VDD 1.39246
R689 VDD VDD.n36 1.39246
R690 VDD.n179 VDD.n21 1.3905
R691 VDD.n201 VDD.n2 1.3905
R692 VDD VDD.t38 1.32721
R693 VDD.t29 VDD 1.32721
R694 VDD VDD.n77 1.3005
R695 VDD VDD.n79 1.3005
R696 VDD VDD.n81 1.3005
R697 VDD VDD.n83 1.3005
R698 VDD VDD.n85 1.3005
R699 VDD VDD.n87 1.3005
R700 VDD VDD.n89 1.3005
R701 VDD VDD.n91 1.3005
R702 VDD.n158 VDD.n150 1.23425
R703 VDD.n50 VDD.n43 1.228
R704 VDD VDD.t44 1.22779
R705 VDD VDD.t47 1.22779
R706 VDD.n200 VDD.n199 1.21514
R707 VDD.n245 VDD.n244 1.21514
R708 VDD.n100 VDD 1.198
R709 VDD VDD.n151 1.198
R710 VDD VDD.n153 1.198
R711 VDD VDD.n242 1.13836
R712 VDD.n243 VDD 1.13836
R713 VDD.n198 VDD 1.13836
R714 VDD VDD.n187 1.13836
R715 VDD VDD.n44 1.098
R716 VDD VDD.n46 1.098
R717 VDD.n174 VDD 1.0905
R718 VDD.n247 VDD 1.0905
R719 VDD VDD.n72 1.07675
R720 VDD.n77 VDD.t134 0.984284
R721 VDD.n77 VDD.t79 0.984284
R722 VDD.n79 VDD.t81 0.984284
R723 VDD.n79 VDD.t136 0.984284
R724 VDD.n81 VDD.t138 0.984284
R725 VDD.n81 VDD.t83 0.984284
R726 VDD.n83 VDD.t85 0.984284
R727 VDD.n83 VDD.t94 0.984284
R728 VDD.n85 VDD.t96 0.984284
R729 VDD.n85 VDD.t107 0.984284
R730 VDD.n87 VDD.t109 0.984284
R731 VDD.n87 VDD.t98 0.984284
R732 VDD.n89 VDD.t100 0.984284
R733 VDD.n89 VDD.t111 0.984284
R734 VDD.n91 VDD.t113 0.984284
R735 VDD.n91 VDD.t105 0.984284
R736 VDD.n140 VDD.t103 0.984284
R737 VDD.n140 VDD.t20 0.984284
R738 VDD.n138 VDD.t87 0.984284
R739 VDD.n138 VDD.t92 0.984284
R740 VDD.n136 VDD.t76 0.984284
R741 VDD.n136 VDD.t89 0.984284
R742 VDD.n134 VDD.t132 0.984284
R743 VDD.n134 VDD.t74 0.984284
R744 VDD.n132 VDD.t72 0.984284
R745 VDD.n132 VDD.t62 0.984284
R746 VDD.n131 VDD.t60 0.984284
R747 VDD.n131 VDD.t70 0.984284
R748 VDD.n129 VDD.t56 0.984284
R749 VDD.n129 VDD.t58 0.984284
R750 VDD.n127 VDD.t117 0.984284
R751 VDD.n127 VDD.t64 0.984284
R752 VDD.n125 VDD.t121 0.984284
R753 VDD.n125 VDD.t115 0.984284
R754 VDD.n123 VDD.t66 0.984284
R755 VDD.n123 VDD.t123 0.984284
R756 VDD.n121 VDD.t23 0.984284
R757 VDD.n121 VDD.t68 0.984284
R758 VDD VDD.t53 0.976457
R759 VDD VDD.t50 0.976457
R760 VDD VDD.t5 0.976457
R761 VDD VDD.t8 0.976457
R762 VDD VDD.n64 0.959123
R763 VDD.n246 VDD.n223 0.939071
R764 VDD.n223 VDD.n221 0.939071
R765 VDD.n221 VDD.n219 0.939071
R766 VDD.n219 VDD.n217 0.939071
R767 VDD.n217 VDD.n215 0.939071
R768 VDD.n215 VDD 0.939071
R769 VDD VDD.n212 0.939071
R770 VDD.n212 VDD.n210 0.939071
R771 VDD.n210 VDD.n208 0.939071
R772 VDD.n208 VDD.n206 0.939071
R773 VDD.n206 VDD.n204 0.939071
R774 VDD.n204 VDD.n202 0.939071
R775 VDD VDD.n161 0.93425
R776 VDD VDD.n53 0.928
R777 VDD.n147 VDD.n39 0.91675
R778 VDD.t2 VDD.n113 0.9105
R779 VDD.n113 VDD.t141 0.9105
R780 VDD.n36 VDD.t26 0.9105
R781 VDD.n36 VDD.t143 0.9105
R782 VDD VDD.n185 0.893
R783 VDD.n175 VDD 0.8455
R784 VDD.n25 VDD 0.8455
R785 VDD VDD.n6 0.8455
R786 VDD.n248 VDD 0.8455
R787 VDD.n99 VDD 0.8405
R788 VDD VDD.n51 0.835314
R789 VDD VDD.n112 0.826152
R790 VDD.n61 VDD 0.826152
R791 VDD VDD.n39 0.826152
R792 VDD.n143 VDD 0.826152
R793 VDD VDD.n35 0.826152
R794 VDD.n167 VDD 0.826152
R795 VDD VDD.n104 0.826152
R796 VDD.n99 VDD 0.826152
R797 VDD VDD.n50 0.826152
R798 VDD.n53 VDD 0.826152
R799 VDD VDD.n158 0.826152
R800 VDD.n161 VDD 0.826152
R801 VDD VDD.n21 0.826152
R802 VDD.n174 VDD 0.826152
R803 VDD VDD.n201 0.826152
R804 VDD.n247 VDD 0.826152
R805 VDD.n14 VDD 0.8105
R806 VDD VDD.n15 0.8105
R807 VDD VDD.n240 0.788
R808 VDD.n237 VDD 0.788
R809 VDD.n8 VDD 0.788
R810 VDD.n9 VDD 0.788
R811 VDD.n179 VDD 0.763
R812 VDD VDD.n22 0.763
R813 VDD VDD.n160 0.742457
R814 VDD.n61 VDD 0.7155
R815 VDD VDD.n167 0.7155
R816 VDD VDD.n70 0.7005
R817 VDD VDD.n76 0.7005
R818 VDD.n110 VDD 0.7005
R819 VDD VDD.n111 0.7005
R820 VDD VDD.n119 0.7005
R821 VDD VDD.n118 0.7005
R822 VDD VDD.n34 0.7005
R823 VDD VDD.n33 0.7005
R824 VDD VDD.n151 0.68925
R825 VDD.n153 VDD 0.68925
R826 VDD VDD.n44 0.683
R827 VDD.n46 VDD 0.683
R828 VDD VDD.n0 0.68126
R829 VDD VDD.n1 0.68126
R830 VDD.n95 VDD.n94 0.6255
R831 VDD.n109 VDD.n108 0.6255
R832 VDD.n62 VDD.n58 0.6255
R833 VDD.n142 VDD.n117 0.6255
R834 VDD.n166 VDD.n32 0.6255
R835 VDD.n170 VDD.n31 0.6255
R836 VDD.n68 VDD.n65 0.6255
R837 VDD VDD.n28 0.612457
R838 VDD VDD.n26 0.612457
R839 VDD VDD.n203 0.612457
R840 VDD VDD.n205 0.612457
R841 VDD VDD.n207 0.612457
R842 VDD VDD.n209 0.612457
R843 VDD VDD.n211 0.612457
R844 VDD VDD.n213 0.612457
R845 VDD VDD.n214 0.612457
R846 VDD VDD.n216 0.612457
R847 VDD VDD.n218 0.612457
R848 VDD VDD.n220 0.612457
R849 VDD VDD.n222 0.612457
R850 VDD.n64 VDD.t145 0.607167
R851 VDD.n64 VDD.t119 0.607167
R852 VDD VDD.n100 0.5955
R853 VDD.n173 VDD 0.580679
R854 VDD.n246 VDD 0.575857
R855 VDD.n202 VDD 0.575857
R856 VDD VDD.n103 0.573227
R857 VDD.n101 VDD 0.573227
R858 VDD.n234 VDD.n233 0.573227
R859 VDD.n230 VDD.n228 0.573227
R860 VDD.n190 VDD.n189 0.573227
R861 VDD.n191 VDD.n188 0.573227
R862 VDD VDD.n68 0.563
R863 VDD.n98 VDD 0.563
R864 VDD.n150 VDD 0.563
R865 VDD.n162 VDD 0.563
R866 VDD.n42 VDD 0.548536
R867 VDD VDD.n62 0.5455
R868 VDD.n108 VDD 0.5455
R869 VDD.n170 VDD 0.5455
R870 VDD VDD.n32 0.5455
R871 VDD.n159 VDD 0.542107
R872 VDD VDD.n105 0.538893
R873 VDD.n93 VDD 0.530857
R874 VDD VDD.n114 0.530857
R875 VDD.n165 VDD 0.530857
R876 VDD VDD.n49 0.5255
R877 VDD.n48 VDD 0.5255
R878 VDD.n104 VDD.n65 0.5155
R879 VDD.n97 VDD.n96 0.51134
R880 VDD.n172 VDD.n171 0.50774
R881 VDD.n51 VDD.t29 0.492392
R882 VDD.n51 VDD.t153 0.492392
R883 VDD.n160 VDD.t149 0.485833
R884 VDD.n160 VDD.t151 0.485833
R885 VDD VDD.n157 0.485115
R886 VDD.n155 VDD 0.485115
R887 VDD.n93 VDD.n92 0.476214
R888 VDD.n92 VDD.n90 0.476214
R889 VDD.n90 VDD.n88 0.476214
R890 VDD.n88 VDD.n86 0.476214
R891 VDD.n84 VDD.n82 0.476214
R892 VDD.n82 VDD.n80 0.476214
R893 VDD.n80 VDD.n78 0.476214
R894 VDD.n124 VDD.n122 0.476214
R895 VDD.n126 VDD.n124 0.476214
R896 VDD.n128 VDD.n126 0.476214
R897 VDD.n130 VDD.n128 0.476214
R898 VDD VDD.n130 0.476214
R899 VDD.n133 VDD 0.476214
R900 VDD.n135 VDD.n133 0.476214
R901 VDD.n137 VDD.n135 0.476214
R902 VDD.n139 VDD.n137 0.476214
R903 VDD.n141 VDD.n139 0.476214
R904 VDD.n105 VDD 0.476214
R905 VDD VDD.n159 0.476214
R906 VDD.n173 VDD.n29 0.476214
R907 VDD.n165 VDD 0.473
R908 VDD VDD.n109 0.4705
R909 VDD VDD.n58 0.4705
R910 VDD VDD.n166 0.4705
R911 VDD VDD.n31 0.4705
R912 VDD.n43 VDD 0.463
R913 VDD.n54 VDD 0.463
R914 VDD.n94 VDD 0.45175
R915 VDD VDD.n71 0.45175
R916 VDD.n120 VDD 0.45175
R917 VDD VDD.n24 0.4205
R918 VDD VDD.n23 0.4205
R919 VDD VDD.n4 0.4205
R920 VDD VDD.n5 0.4205
R921 VDD.n47 VDD 0.39425
R922 VDD.t152 VDD.n47 0.39425
R923 VDD.n45 VDD 0.39425
R924 VDD.t152 VDD.n45 0.39425
R925 VDD.n238 VDD 0.39425
R926 VDD.n235 VDD 0.39425
R927 VDD VDD.n13 0.39425
R928 VDD.n10 VDD 0.39425
R929 VDD.n231 VDD.n226 0.371088
R930 VDD.n227 VDD.n225 0.371088
R931 VDD.n197 VDD.n196 0.371088
R932 VDD.n193 VDD.n192 0.371088
R933 VDD.n28 VDD.t127 0.3645
R934 VDD.n28 VDD.t129 0.3645
R935 VDD.n26 VDD.t147 0.3645
R936 VDD.n26 VDD.t125 0.3645
R937 VDD.n203 VDD.t197 0.3645
R938 VDD.n203 VDD.t195 0.3645
R939 VDD.n205 VDD.t193 0.3645
R940 VDD.n205 VDD.t191 0.3645
R941 VDD.n207 VDD.t189 0.3645
R942 VDD.n207 VDD.t187 0.3645
R943 VDD.n209 VDD.t185 0.3645
R944 VDD.n209 VDD.t183 0.3645
R945 VDD.n211 VDD.t181 0.3645
R946 VDD.n211 VDD.t179 0.3645
R947 VDD.n213 VDD.t177 0.3645
R948 VDD.n213 VDD.t175 0.3645
R949 VDD.n214 VDD.t173 0.3645
R950 VDD.n214 VDD.t171 0.3645
R951 VDD.n216 VDD.t169 0.3645
R952 VDD.n216 VDD.t167 0.3645
R953 VDD.n218 VDD.t165 0.3645
R954 VDD.n218 VDD.t163 0.3645
R955 VDD.n220 VDD.t161 0.3645
R956 VDD.n220 VDD.t159 0.3645
R957 VDD.n222 VDD.t157 0.3645
R958 VDD.n222 VDD.t155 0.3645
R959 VDD VDD.n60 0.3505
R960 VDD.t140 VDD.n60 0.3505
R961 VDD.n59 VDD 0.3505
R962 VDD.t140 VDD.n59 0.3505
R963 VDD VDD.n169 0.3505
R964 VDD.n169 VDD.t142 0.3505
R965 VDD.n168 VDD 0.3505
R966 VDD.t142 VDD.n168 0.3505
R967 VDD.n67 VDD 0.3505
R968 VDD.n102 VDD.n67 0.3505
R969 VDD VDD.n66 0.3505
R970 VDD.n102 VDD.n66 0.3505
R971 VDD.n154 VDD 0.3505
R972 VDD.n156 VDD.n154 0.3505
R973 VDD.n152 VDD 0.3505
R974 VDD.n156 VDD.n152 0.3505
R975 VDD.n148 VDD 0.34142
R976 VDD.n239 VDD.t54 0.338172
R977 VDD.n236 VDD.t54 0.338172
R978 VDD.n12 VDD.t130 0.338172
R979 VDD.t130 VDD.n11 0.338172
R980 VDD.n232 VDD.t101 0.315577
R981 VDD.n229 VDD.t101 0.315577
R982 VDD.n195 VDD.t139 0.315577
R983 VDD.t139 VDD.n194 0.315577
R984 VDD VDD.n178 0.3005
R985 VDD.n178 VDD.n177 0.3005
R986 VDD.n176 VDD 0.3005
R987 VDD.n177 VDD.n176 0.3005
R988 VDD.n143 VDD.n142 0.29175
R989 VDD VDD.n98 0.2905
R990 VDD.n54 VDD 0.2905
R991 VDD.n162 VDD 0.2905
R992 VDD VDD.n22 0.2905
R993 VDD VDD.n3 0.2905
R994 VDD.n114 VDD.n57 0.289786
R995 VDD.n116 VDD.n115 0.23918
R996 VDD.n86 VDD 0.238357
R997 VDD VDD.n84 0.238357
R998 VDD VDD.n27 0.238357
R999 VDD.n29 VDD 0.238357
R1000 VDD.n180 VDD.n20 0.22154
R1001 VDD.n52 VDD.n42 0.219071
R1002 VDD.n241 VDD 0.20354
R1003 VDD.n163 VDD.n148 0.18446
R1004 VDD.n16 VDD 0.176
R1005 VDD VDD.n143 0.1605
R1006 VDD VDD.n39 0.1605
R1007 VDD.n107 VDD.n56 0.1589
R1008 VDD.n74 VDD 0.1505
R1009 VDD.n75 VDD.n74 0.1505
R1010 VDD.n73 VDD 0.1505
R1011 VDD.n75 VDD.n73 0.1505
R1012 VDD VDD.n225 0.1499
R1013 VDD VDD.n197 0.1499
R1014 VDD VDD.n57 0.145143
R1015 VDD VDD.n37 0.145143
R1016 VDD.n55 VDD.n40 0.13514
R1017 VDD.n186 VDD.n7 0.13226
R1018 VDD.n199 VDD.n7 0.13226
R1019 VDD.n244 VDD.n224 0.13226
R1020 VDD.n241 VDD.n224 0.13226
R1021 VDD.n107 VDD.n106 0.12974
R1022 VDD VDD.n146 0.129071
R1023 VDD.n146 VDD.n145 0.129071
R1024 VDD.n144 VDD 0.129071
R1025 VDD.n145 VDD.n144 0.129071
R1026 VDD VDD.n52 0.109786
R1027 VDD.n69 VDD.n63 0.10814
R1028 VDD.n172 VDD.n20 0.10202
R1029 VDD.n41 VDD 0.1013
R1030 VDD.n200 VDD.n0 0.10094
R1031 VDD.n245 VDD.n1 0.10094
R1032 VDD.n41 VDD.n40 0.09482
R1033 VDD.n149 VDD.n30 0.09338
R1034 VDD.n106 VDD.n63 0.09266
R1035 VDD.n164 VDD.n38 0.09086
R1036 VDD.n115 VDD.n56 0.09086
R1037 VDD VDD.n61 0.0805
R1038 VDD.n112 VDD 0.0805
R1039 VDD.n167 VDD 0.0805
R1040 VDD.n35 VDD 0.0805
R1041 VDD.n104 VDD 0.0805
R1042 VDD VDD.n99 0.0805
R1043 VDD.n50 VDD 0.0805
R1044 VDD.n53 VDD 0.0805
R1045 VDD.n158 VDD 0.0805
R1046 VDD.n161 VDD 0.0805
R1047 VDD VDD.n174 0.0805
R1048 VDD VDD.n21 0.0805
R1049 VDD.n201 VDD 0.0805
R1050 VDD VDD.n247 0.0805
R1051 VDD.n249 VDD 0.0712865
R1052 VDD.n250 VDD.n249 0.0712865
R1053 VDD.n252 VDD.n251 0.0712865
R1054 VDD.n251 VDD.n250 0.0712865
R1055 VDD.n236 VDD.n235 0.0573702
R1056 VDD.n239 VDD.n238 0.0573702
R1057 VDD.n13 VDD.n12 0.0573702
R1058 VDD.n11 VDD.n10 0.0573702
R1059 VDD.n229 VDD.n227 0.0568398
R1060 VDD.n232 VDD.n231 0.0568398
R1061 VDD.n196 VDD.n195 0.0568398
R1062 VDD.n194 VDD.n193 0.0568398
R1063 VDD.n97 VDD.n69 0.0563
R1064 VDD.n164 VDD.n163 0.05522
R1065 VDD.n184 VDD.n18 0.0536955
R1066 VDD.n181 VDD.n19 0.053
R1067 VDD.n171 VDD.n30 0.04766
R1068 VDD.n185 VDD.n184 0.0270978
R1069 VDD.n19 VDD.n18 0.0270978
R1070 VDD.n149 VDD.n38 0.01886
R1071 VDD.n182 VDD.n17 0.0135648
R1072 VDD.n183 VDD.n182 0.0135648
R1073 VDD.n116 VDD.n55 0.01166
R1074 VSS.n350 VSS.n349 452135
R1075 VSS.n193 VSS.n7 308160
R1076 VSS.n194 VSS.n193 308160
R1077 VSS.n349 VSS.t52 206375
R1078 VSS.n61 VSS.n59 29246
R1079 VSS.n256 VSS.n250 29246
R1080 VSS.n256 VSS.n255 24989.3
R1081 VSS.n258 VSS.n64 13337
R1082 VSS.n62 VSS.n10 10836.2
R1083 VSS.n251 VSS.n249 10836.2
R1084 VSS.n196 VSS.n95 9607.97
R1085 VSS.n197 VSS.n196 8515.35
R1086 VSS.n63 VSS.n62 8018.86
R1087 VSS.t251 VSS.n7 7221.36
R1088 VSS.n206 VSS.n205 5814.65
R1089 VSS.n254 VSS.n251 4933.79
R1090 VSS.n9 VSS.n8 4805.01
R1091 VSS.t251 VSS.n194 3668.85
R1092 VSS.t254 VSS.n350 3265.51
R1093 VSS.n350 VSS.n9 3195.7
R1094 VSS.n194 VSS.n95 2792.36
R1095 VSS.n222 VSS.n221 2755.03
R1096 VSS.t254 VSS.n7 1985.68
R1097 VSS.n298 VSS.n297 1812.23
R1098 VSS.n62 VSS.n59 1792.36
R1099 VSS.n251 VSS.n250 1792.36
R1100 VSS.n257 VSS.n256 1444.14
R1101 VSS.n220 VSS.n95 1419.91
R1102 VSS.n302 VSS.t52 1404.87
R1103 VSS.n63 VSS.n61 1359.35
R1104 VSS.n298 VSS.n39 1124.51
R1105 VSS.n61 VSS.n10 1099.61
R1106 VSS.n256 VSS.n249 1099.61
R1107 VSS.n286 VSS.n9 635.87
R1108 VSS.t186 VSS.n64 613.646
R1109 VSS.t244 VSS.n258 613.646
R1110 VSS.t64 VSS.n197 573.529
R1111 VSS.t61 VSS.n206 573.529
R1112 VSS.n205 VSS.t55 573.529
R1113 VSS.n8 VSS.t58 573.529
R1114 VSS.n195 VSS.t67 573.529
R1115 VSS.n311 VSS.n29 515.958
R1116 VSS.n311 VSS.n30 515.958
R1117 VSS.n185 VSS.n30 515.958
R1118 VSS.n185 VSS.n29 515.958
R1119 VSS.n192 VSS.n26 481.639
R1120 VSS.n105 VSS.n26 481.639
R1121 VSS.n108 VSS.n105 481.639
R1122 VSS.n192 VSS.n108 481.639
R1123 VSS.n286 VSS.t1 364.565
R1124 VSS.n297 VSS.t46 364.565
R1125 VSS.t186 VSS.n63 346.967
R1126 VSS.n171 VSS.n107 346.598
R1127 VSS.n171 VSS.n106 346.598
R1128 VSS.n161 VSS.n106 346.598
R1129 VSS.n161 VSS.n107 346.598
R1130 VSS.n241 VSS.n77 313.736
R1131 VSS.n241 VSS.n78 313.736
R1132 VSS.n247 VSS.n78 313.736
R1133 VSS.n247 VSS.n77 313.736
R1134 VSS.n257 VSS.n75 313.308
R1135 VSS.n238 VSS.n84 304.307
R1136 VSS.n238 VSS.n85 304.307
R1137 VSS.n235 VSS.n85 304.307
R1138 VSS.n235 VSS.n84 304.307
R1139 VSS.n348 VSS.n10 299.687
R1140 VSS.n221 VSS.n94 298.853
R1141 VSS.n347 VSS.n11 274.75
R1142 VSS.n347 VSS.n12 274.75
R1143 VSS.n344 VSS.n12 274.75
R1144 VSS.n344 VSS.n11 274.75
R1145 VSS.t49 VSS.n298 273.49
R1146 VSS.n255 VSS.n254 273.365
R1147 VSS.t244 VSS.n257 264.726
R1148 VSS.n300 VSS.t221 212.419
R1149 VSS.n300 VSS.t224 212.419
R1150 VSS.n342 VSS.n20 206.306
R1151 VSS.n20 VSS.n16 206.306
R1152 VSS.n17 VSS.n16 206.306
R1153 VSS.n342 VSS.n17 206.306
R1154 VSS.n227 VSS.n93 206.306
R1155 VSS.n228 VSS.n93 206.306
R1156 VSS.n228 VSS.n92 206.306
R1157 VSS.n227 VSS.n92 206.306
R1158 VSS.t251 VSS.t64 177.839
R1159 VSS.t251 VSS.t61 177.839
R1160 VSS.t254 VSS.t55 177.839
R1161 VSS.t254 VSS.t58 177.839
R1162 VSS.t70 VSS.t238 177.839
R1163 VSS.t67 VSS.t247 177.839
R1164 VSS.n220 VSS.t70 165.613
R1165 VSS.n152 VSS.n83 160.79
R1166 VSS.n309 VSS.n15 160.79
R1167 VSS.n308 VSS.n31 155.264
R1168 VSS.n308 VSS.n32 155.264
R1169 VSS.n168 VSS.n32 155.264
R1170 VSS.n168 VSS.n31 155.264
R1171 VSS.n181 VSS.n155 155.264
R1172 VSS.n155 VSS.n153 155.264
R1173 VSS.n154 VSS.n153 155.264
R1174 VSS.n181 VSS.n154 155.264
R1175 VSS.n302 VSS.n38 149.529
R1176 VSS.n39 VSS.n38 149.529
R1177 VSS.n301 VSS.n39 149.529
R1178 VSS.n302 VSS.n301 149.529
R1179 VSS.t31 VSS.n348 147.957
R1180 VSS.n96 VSS.n94 143.112
R1181 VSS.n218 VSS.n94 143.112
R1182 VSS.n97 VSS.n96 143.112
R1183 VSS.n218 VSS.n97 143.112
R1184 VSS.n248 VSS.n76 142.673
R1185 VSS.n196 VSS.n195 135.602
R1186 VSS.n260 VSS.n74 134.29
R1187 VSS.n261 VSS.n74 134.29
R1188 VSS.n261 VSS.n73 134.29
R1189 VSS.n260 VSS.n73 134.29
R1190 VSS.n269 VSS.n65 134.29
R1191 VSS.n269 VSS.n66 134.29
R1192 VSS.n68 VSS.n65 134.29
R1193 VSS.n204 VSS.n104 125.612
R1194 VSS.n207 VSS.n104 125.612
R1195 VSS.n207 VSS.n103 125.612
R1196 VSS.n204 VSS.n103 125.612
R1197 VSS.n296 VSS.n40 123.668
R1198 VSS.n296 VSS.n41 123.668
R1199 VSS.n287 VSS.n41 123.668
R1200 VSS.n287 VSS.n40 123.668
R1201 VSS.n184 VSS.n152 119.019
R1202 VSS.n310 VSS.n309 119.019
R1203 VSS.t1 VSS.t245 113.043
R1204 VSS.t223 VSS.t46 113.043
R1205 VSS.n6 VSS.n5 111.028
R1206 VSS.n351 VSS.n5 111.028
R1207 VSS.n351 VSS.n4 111.028
R1208 VSS.n6 VSS.n4 111.028
R1209 VSS.t7 VSS.t195 105.431
R1210 VSS.t28 VSS.n239 103.168
R1211 VSS.n343 VSS.t13 103.168
R1212 VSS.n221 VSS.n220 98.7677
R1213 VSS.t238 VSS.n219 88.9198
R1214 VSS.n219 VSS.t247 88.9198
R1215 VSS.t163 VSS.t7 76.4948
R1216 VSS.t161 VSS.t163 76.4948
R1217 VSS.t153 VSS.t155 76.4948
R1218 VSS.t157 VSS.t159 76.4948
R1219 VSS.t73 VSS.t75 76.4948
R1220 VSS.t137 VSS.t135 76.4948
R1221 VSS.t135 VSS.t133 76.4948
R1222 VSS.t133 VSS.t129 76.4948
R1223 VSS.n37 VSS.t51 76.1184
R1224 VSS.n52 VSS.t48 76.1184
R1225 VSS.n349 VSS.t129 67.6879
R1226 VSS.n211 VSS.t69 67.5149
R1227 VSS.n99 VSS.t66 67.5149
R1228 VSS.n223 VSS.t153 60.3907
R1229 VSS.n255 VSS.n75 57.3669
R1230 VSS.t245 VSS.n285 56.5222
R1231 VSS.n285 VSS.t223 56.5222
R1232 VSS.n101 VSS.t63 54.4791
R1233 VSS.n202 VSS.t60 54.4791
R1234 VSS.t178 VSS.t25 51.3322
R1235 VSS.t175 VSS.t176 51.3322
R1236 VSS.t173 VSS.t172 51.3322
R1237 VSS.t218 VSS.t219 51.3322
R1238 VSS.t215 VSS.t216 51.3322
R1239 VSS.t185 VSS.t213 51.3322
R1240 VSS.t184 VSS.t192 51.3322
R1241 VSS.t183 VSS.t189 51.3322
R1242 VSS.t187 VSS.t188 51.3322
R1243 VSS.t200 VSS.t72 51.3322
R1244 VSS.t182 VSS.t256 51.3322
R1245 VSS.t211 VSS.t212 51.3322
R1246 VSS.t209 VSS.t208 51.3322
R1247 VSS.t206 VSS.t205 51.3322
R1248 VSS.t203 VSS.t202 51.3322
R1249 VSS.t171 VSS.t170 51.3322
R1250 VSS.t168 VSS.t167 51.3322
R1251 VSS.t16 VSS.t165 51.3322
R1252 VSS.t234 VSS.n222 47.3062
R1253 VSS.n320 VSS.t12 46.233
R1254 VSS.n341 VSS.t15 46.233
R1255 VSS.n90 VSS.t24 46.233
R1256 VSS.n226 VSS.t27 46.233
R1257 VSS.n167 VSS.t39 45.138
R1258 VSS.n307 VSS.t36 45.138
R1259 VSS.n156 VSS.t42 45.138
R1260 VSS.n180 VSS.t33 45.138
R1261 VSS.t13 VSS.t4 44.7899
R1262 VSS.t151 VSS.t174 43.7834
R1263 VSS.t169 VSS.t147 43.7834
R1264 VSS.t177 VSS.t87 42.7769
R1265 VSS.t123 VSS.t214 42.7769
R1266 VSS.t93 VSS.t207 42.7769
R1267 VSS.t143 VSS.t166 42.7769
R1268 VSS.t195 VSS.n76 42.5253
R1269 VSS.n19 VSS.t139 42.2736
R1270 VSS.n283 VSS.t0 41.4434
R1271 VSS.n295 VSS.t45 41.4434
R1272 VSS.t199 VSS.t119 40.7639
R1273 VSS.t198 VSS.t77 40.7639
R1274 VSS.t253 VSS.t105 39.7574
R1275 VSS.t226 VSS.t113 39.7574
R1276 VSS.t191 VSS.t83 38.7509
R1277 VSS.t193 VSS.t81 38.7509
R1278 VSS.n18 VSS.t141 38.2476
R1279 VSS.t139 VSS.n18 38.2476
R1280 VSS.t221 VSS.t52 36.7756
R1281 VSS.t224 VSS.t49 36.7756
R1282 VSS.n183 VSS.t236 35.4798
R1283 VSS.t250 VSS.n164 35.4798
R1284 VSS.t34 VSS.t220 34.9765
R1285 VSS.t40 VSS.t201 34.9765
R1286 VSS.n2 VSS.t54 34.9256
R1287 VSS.n46 VSS.t57 34.9256
R1288 VSS.t190 VSS.t125 34.7249
R1289 VSS.t210 VSS.t95 34.7249
R1290 VSS.n224 VSS.t157 34.2216
R1291 VSS.n19 VSS.t137 34.2216
R1292 VSS.t85 VSS.t177 33.7184
R1293 VSS.t214 VSS.t121 33.7184
R1294 VSS.t207 VSS.t109 33.7184
R1295 VSS.t166 VSS.t145 33.7184
R1296 VSS.t115 VSS.t235 32.9635
R1297 VSS.t103 VSS.t233 32.9635
R1298 VSS.t174 VSS.t89 32.7119
R1299 VSS.t217 VSS.t131 32.7119
R1300 VSS.t204 VSS.t91 32.7119
R1301 VSS.t149 VSS.t169 32.7119
R1302 VSS.n239 VSS.n83 32.2086
R1303 VSS.n343 VSS.n15 32.2086
R1304 VSS.n240 VSS.t10 28.9375
R1305 VSS.t127 VSS.n159 27.4277
R1306 VSS.t97 VSS.n169 27.4277
R1307 VSS.t194 VSS.n225 26.4212
R1308 VSS.t236 VSS.n182 25.6663
R1309 VSS.n182 VSS.t237 25.6663
R1310 VSS.n193 VSS.t240 25.6663
R1311 VSS.n193 VSS.t232 25.6663
R1312 VSS.t249 VSS.n165 25.6663
R1313 VSS.n165 VSS.t250 25.6663
R1314 VSS.t241 VSS.t199 23.905
R1315 VSS.t179 VSS.t198 23.905
R1316 VSS.n10 VSS.t52 22.8985
R1317 VSS.t117 VSS.t230 22.3952
R1318 VSS.t79 VSS.t231 22.3952
R1319 VSS.n160 VSS.t101 21.3887
R1320 VSS.n170 VSS.t111 21.3887
R1321 VSS.t155 VSS.t234 20.3822
R1322 VSS.n160 VSS.t190 20.3822
R1323 VSS.n170 VSS.t210 20.3822
R1324 VSS.t221 VSS.n299 20.1306
R1325 VSS.n299 VSS.t224 20.1306
R1326 VSS.t89 VSS.t173 18.6208
R1327 VSS.t131 VSS.t218 18.6208
R1328 VSS.t91 VSS.t203 18.6208
R1329 VSS.t170 VSS.t149 18.6208
R1330 VSS.t176 VSS.t85 17.6143
R1331 VSS.t121 VSS.t215 17.6143
R1332 VSS.t109 VSS.t206 17.6143
R1333 VSS.t145 VSS.t167 17.6143
R1334 VSS.t25 VSS.t73 16.6078
R1335 VSS.t125 VSS.t185 16.6078
R1336 VSS.t95 VSS.t209 16.6078
R1337 VSS.t141 VSS.t16 16.6078
R1338 VSS.n191 VSS.t21 16.4048
R1339 VSS.n317 VSS.t18 16.4048
R1340 VSS.n346 VSS.t30 16.4048
R1341 VSS.n345 VSS.t3 16.4048
R1342 VSS.n237 VSS.t9 16.4048
R1343 VSS.n236 VSS.t6 16.4048
R1344 VSS.n184 VSS.t43 16.3562
R1345 VSS.t220 VSS.t237 16.3562
R1346 VSS.n159 VSS.t217 16.3562
R1347 VSS.n169 VSS.t204 16.3562
R1348 VSS.t201 VSS.t249 16.3562
R1349 VSS.n310 VSS.t37 16.3562
R1350 VSS.t159 VSS.n223 16.1046
R1351 VSS.n240 VSS.t28 15.8529
R1352 VSS.t43 VSS.n183 15.8529
R1353 VSS.n164 VSS.t37 15.8529
R1354 VSS.t192 VSS.t99 15.6013
R1355 VSS.t212 VSS.t107 15.6013
R1356 VSS.t189 VSS.t117 14.5948
R1357 VSS.t256 VSS.t79 14.5948
R1358 VSS.t230 VSS.t253 14.3432
R1359 VSS.t231 VSS.t226 14.3432
R1360 VSS.t188 VSS.t115 13.5883
R1361 VSS.t72 VSS.t103 13.5883
R1362 VSS.t83 VSS.t240 12.5818
R1363 VSS.t81 VSS.t232 12.5818
R1364 VSS.t75 VSS.t194 11.8269
R1365 VSS.t99 VSS.t241 11.8269
R1366 VSS.t107 VSS.t179 11.8269
R1367 VSS.t105 VSS.t187 11.5753
R1368 VSS.t113 VSS.t200 11.5753
R1369 VSS.t119 VSS.t183 10.5688
R1370 VSS.t77 VSS.t182 10.5688
R1371 VSS VSS.n266 10.5016
R1372 VSS.n263 VSS 10.5
R1373 VSS VSS.n270 9.89259
R1374 VSS.n253 VSS 9.89208
R1375 VSS.t22 VSS.t34 9.81391
R1376 VSS.t19 VSS.t40 9.81391
R1377 VSS.t101 VSS.t184 9.56228
R1378 VSS.t111 VSS.t211 9.56228
R1379 VSS VSS.n44 9.21907
R1380 VSS.n290 VSS 9.21907
R1381 VSS.n200 VSS 9.21907
R1382 VSS.n214 VSS 9.0005
R1383 VSS.n44 VSS 9.0005
R1384 VSS.n48 VSS 9.0005
R1385 VSS.n290 VSS 9.0005
R1386 VSS.n291 VSS 9.0005
R1387 VSS.n147 VSS 9.0005
R1388 VSS.n145 VSS 9.0005
R1389 VSS.n143 VSS 9.0005
R1390 VSS.n141 VSS 9.0005
R1391 VSS.n139 VSS 9.0005
R1392 VSS.n137 VSS 9.0005
R1393 VSS.n135 VSS 9.0005
R1394 VSS.n133 VSS 9.0005
R1395 VSS.n131 VSS 9.0005
R1396 VSS.n129 VSS 9.0005
R1397 VSS.n127 VSS 9.0005
R1398 VSS.n25 VSS 9.0005
R1399 VSS.n318 VSS 9.0005
R1400 VSS.n148 VSS 9.0005
R1401 VSS.n326 VSS 9.0005
R1402 VSS.n328 VSS 9.0005
R1403 VSS.n331 VSS 9.0005
R1404 VSS.n333 VSS 9.0005
R1405 VSS.n334 VSS 9.0005
R1406 VSS.n324 VSS 9.0005
R1407 VSS.n113 VSS 9.0005
R1408 VSS.n115 VSS 9.0005
R1409 VSS.n117 VSS 9.0005
R1410 VSS.n119 VSS 9.0005
R1411 VSS.n121 VSS 9.0005
R1412 VSS.n123 VSS 9.0005
R1413 VSS.n124 VSS 9.0005
R1414 VSS.n111 VSS 9.0005
R1415 VSS.n303 VSS 9.0005
R1416 VSS.n200 VSS 9.0005
R1417 VSS VSS.n201 9.0005
R1418 VSS.n222 VSS.t161 8.80741
R1419 VSS.n349 VSS.t31 8.80741
R1420 VSS.t87 VSS.t178 8.55578
R1421 VSS.t213 VSS.t123 8.55578
R1422 VSS.t208 VSS.t93 8.55578
R1423 VSS.t165 VSS.t143 8.55578
R1424 VSS.t216 VSS.t127 7.54928
R1425 VSS.t205 VSS.t97 7.54928
R1426 VSS.t147 VSS.t168 7.54928
R1427 VSS.t172 VSS.t10 6.54277
R1428 VSS.t219 VSS.t22 6.54277
R1429 VSS.t202 VSS.t19 6.54277
R1430 VSS.t4 VSS.t171 6.54277
R1431 VSS VSS.n191 5.6605
R1432 VSS.n304 VSS 5.49371
R1433 VSS.n232 VSS 5.47841
R1434 VSS.n215 VSS 5.38121
R1435 VSS.n335 VSS 5.38121
R1436 VSS VSS.n323 5.38121
R1437 VSS.n125 VSS 5.38121
R1438 VSS VSS.n0 5.38121
R1439 VSS VSS.n245 5.33567
R1440 VSS.n49 VSS 5.26871
R1441 VSS.n292 VSS 5.26871
R1442 VSS.n319 VSS 5.26871
R1443 VSS.n149 VSS 5.26871
R1444 VSS VSS.n70 5.11507
R1445 VSS.n216 VSS 5.07233
R1446 VSS.n338 VSS 5.06461
R1447 VSS VSS.n21 5.06461
R1448 VSS VSS.n23 5.06461
R1449 VSS.n314 VSS 5.06461
R1450 VSS.n188 VSS 5.06461
R1451 VSS VSS.n150 5.06461
R1452 VSS.n89 VSS 5.06461
R1453 VSS.n231 VSS 5.06461
R1454 VSS VSS.n232 5.06461
R1455 VSS VSS.n339 5.04371
R1456 VSS.n322 VSS 5.04371
R1457 VSS.n110 VSS 5.04371
R1458 VSS.n230 VSS 5.04371
R1459 VSS.n264 VSS 5.01157
R1460 VSS VSS.n263 5.01157
R1461 VSS VSS.n70 5.01157
R1462 VSS.n272 VSS 5.01157
R1463 VSS VSS.n271 5.01157
R1464 VSS VSS.n58 5.01157
R1465 VSS VSS.n265 5.01157
R1466 VSS.n266 VSS 5.01157
R1467 VSS.n252 VSS 5.01157
R1468 VSS.n54 VSS 4.96657
R1469 VSS VSS.n34 4.96657
R1470 VSS VSS.n216 4.93121
R1471 VSS.n353 VSS 4.93121
R1472 VSS VSS.n1 4.93121
R1473 VSS VSS.n50 4.93121
R1474 VSS VSS.n293 4.93121
R1475 VSS VSS.n315 4.93121
R1476 VSS.n28 VSS 4.93121
R1477 VSS.n151 VSS 4.93121
R1478 VSS VSS.n189 4.93121
R1479 VSS VSS.n305 4.93121
R1480 VSS VSS.n33 4.93121
R1481 VSS VSS.n172 4.93121
R1482 VSS.n177 VSS 4.93121
R1483 VSS VSS.n178 4.93121
R1484 VSS.n158 VSS 4.93121
R1485 VSS VSS.n81 4.93121
R1486 VSS.n245 VSS 4.93121
R1487 VSS.n209 VSS 4.93121
R1488 VSS VSS.n100 4.93121
R1489 VSS.t235 VSS.t191 4.78139
R1490 VSS.t233 VSS.t193 4.78139
R1491 VSS.n3 VSS 4.5005
R1492 VSS VSS.n352 4.5005
R1493 VSS.n294 VSS 4.5005
R1494 VSS.n284 VSS 4.5005
R1495 VSS.n340 VSS 4.5005
R1496 VSS VSS.n321 4.5005
R1497 VSS VSS.n109 4.5005
R1498 VSS VSS.n27 4.5005
R1499 VSS.n316 VSS 4.5005
R1500 VSS.n190 VSS 4.5005
R1501 VSS VSS.n91 4.5005
R1502 VSS VSS.n229 4.5005
R1503 VSS.n336 VSS 4.5005
R1504 VSS VSS.n337 4.5005
R1505 VSS VSS.n187 4.5005
R1506 VSS VSS.n313 4.5005
R1507 VSS.n312 VSS 4.5005
R1508 VSS.n186 VSS 4.5005
R1509 VSS.n233 VSS 4.5005
R1510 VSS VSS.n87 4.5005
R1511 VSS VSS.n88 4.5005
R1512 VSS.n275 VSS.n274 4.5005
R1513 VSS.n56 VSS.n22 4.5005
R1514 VSS.n306 VSS 4.5005
R1515 VSS.n166 VSS 4.5005
R1516 VSS.n173 VSS 4.5005
R1517 VSS VSS.n176 4.5005
R1518 VSS.n179 VSS 4.5005
R1519 VSS VSS.n157 4.5005
R1520 VSS VSS.n244 4.5005
R1521 VSS.n242 VSS 4.5005
R1522 VSS.n246 VSS 4.5005
R1523 VSS VSS.n53 4.5005
R1524 VSS.n36 VSS 4.5005
R1525 VSS.n278 VSS.n51 4.5005
R1526 VSS.n282 VSS.n51 4.5005
R1527 VSS.n102 VSS 4.5005
R1528 VSS VSS.n208 4.5005
R1529 VSS.n217 VSS 4.5005
R1530 VSS VSS.n98 4.5005
R1531 VSS.t175 VSS.t227 4.27814
R1532 VSS.n174 VSS.t181 4.2135
R1533 VSS.n175 VSS.t243 4.2135
R1534 VSS.n163 VSS.t180 4.10325
R1535 VSS.n162 VSS.t242 4.10325
R1536 VSS.n249 VSS.n248 4.02651
R1537 VSS.n225 VSS.n224 4.02651
R1538 VSS.n274 VSS.n272 3.51359
R1539 VSS.n187 VSS.n186 3.4505
R1540 VSS.n313 VSS.n312 3.4505
R1541 VSS VSS.n236 3.3805
R1542 VSS.n237 VSS 3.3805
R1543 VSS.n190 VSS.n109 3.34425
R1544 VSS.n316 VSS.n27 3.34425
R1545 VSS.n75 VSS.n73 3.33211
R1546 VSS VSS.t56 3.28446
R1547 VSS VSS.t59 3.28446
R1548 VSS.t227 VSS.t151 3.27164
R1549 VSS VSS.n282 3.0319
R1550 VSS VSS.n345 3.0005
R1551 VSS.n346 VSS 3.0005
R1552 VSS.n301 VSS.n300 2.97545
R1553 VSS.n233 VSS.n87 2.7405
R1554 VSS.n88 VSS.n87 2.7405
R1555 VSS.n259 VSS.n72 2.6483
R1556 VSS.n262 VSS.n72 2.6483
R1557 VSS.n259 VSS.n71 2.6483
R1558 VSS.n268 VSS.n267 2.6483
R1559 VSS.n268 VSS.n67 2.6483
R1560 VSS.n69 VSS.n67 2.6483
R1561 VSS.t2 VSS 2.61167
R1562 VSS VSS.t47 2.61167
R1563 VSS.n270 VSS.t186 2.49329
R1564 VSS.n254 VSS.n253 2.49281
R1565 VSS VSS.n71 2.4449
R1566 VSS.n267 VSS 2.4449
R1567 VSS.n162 VSS 2.3755
R1568 VSS VSS.n336 2.3655
R1569 VSS.n337 VSS 2.3655
R1570 VSS.n173 VSS 2.33287
R1571 VSS.n176 VSS 2.33287
R1572 VSS.n270 VSS.n59 2.30519
R1573 VSS.n253 VSS.n250 2.3047
R1574 VSS VSS.n79 2.29425
R1575 VSS.n82 VSS 2.29425
R1576 VSS.n244 VSS.n80 2.28925
R1577 VSS.n244 VSS.n243 2.28925
R1578 VSS.n277 VSS.n276 2.24472
R1579 VSS.n273 VSS.n22 2.23795
R1580 VSS.n275 VSS.n57 2.23795
R1581 VSS.n279 VSS.n55 2.23795
R1582 VSS.n280 VSS.n51 2.23795
R1583 VSS.n281 VSS.n55 2.23795
R1584 VSS VSS.n43 2.19246
R1585 VSS.n175 VSS 2.02912
R1586 VSS VSS.n174 2.02912
R1587 VSS VSS.t32 2.00766
R1588 VSS VSS.t5 2.00766
R1589 VSS VSS.t11 2.00766
R1590 VSS VSS.t8 2.00766
R1591 VSS VSS.n162 1.98175
R1592 VSS.n163 VSS 1.98175
R1593 VSS.n82 VSS.t228 1.9593
R1594 VSS.n79 VSS.t196 1.9593
R1595 VSS VSS.t23 1.9157
R1596 VSS VSS.t20 1.9157
R1597 VSS VSS.t38 1.85794
R1598 VSS VSS.t41 1.85794
R1599 VSS VSS.t35 1.85794
R1600 VSS VSS.t44 1.85794
R1601 VSS VSS.t17 1.8455
R1602 VSS VSS.t14 1.8455
R1603 VSS VSS.t29 1.8455
R1604 VSS VSS.t26 1.8455
R1605 VSS.n80 VSS.t197 1.8018
R1606 VSS.n243 VSS.t229 1.8018
R1607 VSS VSS.n289 1.79267
R1608 VSS VSS.n212 1.7605
R1609 VSS.n187 VSS 1.7255
R1610 VSS.n313 VSS 1.7255
R1611 VSS.t65 VSS 1.68846
R1612 VSS VSS.t62 1.68846
R1613 VSS.n109 VSS 1.67175
R1614 VSS VSS.n27 1.67175
R1615 VSS VSS.n79 1.6405
R1616 VSS.n265 VSS 1.56398
R1617 VSS VSS.n264 1.5638
R1618 VSS VSS.n198 1.5355
R1619 VSS VSS.n277 1.523
R1620 VSS.n186 VSS 1.43925
R1621 VSS VSS.n36 1.428
R1622 VSS VSS.n325 1.35246
R1623 VSS VSS.n327 1.35246
R1624 VSS VSS.n329 1.35246
R1625 VSS VSS.n330 1.35246
R1626 VSS VSS.n332 1.35246
R1627 VSS VSS.n112 1.35246
R1628 VSS VSS.n114 1.35246
R1629 VSS VSS.n116 1.35246
R1630 VSS VSS.n118 1.35246
R1631 VSS VSS.n120 1.35246
R1632 VSS VSS.n122 1.35246
R1633 VSS VSS.n45 1.348
R1634 VSS.n278 VSS 1.313
R1635 VSS VSS.t71 1.28946
R1636 VSS VSS.t68 1.28946
R1637 VSS VSS.n146 1.2605
R1638 VSS VSS.n144 1.2605
R1639 VSS VSS.n142 1.2605
R1640 VSS VSS.n140 1.2605
R1641 VSS VSS.n138 1.2605
R1642 VSS VSS.n136 1.2605
R1643 VSS VSS.n134 1.2605
R1644 VSS VSS.n132 1.2605
R1645 VSS VSS.n130 1.2605
R1646 VSS VSS.n128 1.2605
R1647 VSS VSS.n126 1.2605
R1648 VSS VSS.n24 1.2605
R1649 VSS.n271 VSS 1.24121
R1650 VSS VSS.n252 1.24121
R1651 VSS.n321 VSS 1.233
R1652 VSS.n340 VSS 1.233
R1653 VSS.n229 VSS 1.233
R1654 VSS VSS.n91 1.233
R1655 VSS.n242 VSS 1.2205
R1656 VSS VSS.n246 1.2205
R1657 VSS VSS.n190 1.158
R1658 VSS VSS.n199 1.14246
R1659 VSS.n305 VSS.n304 1.1336
R1660 VSS.n283 VSS 1.1205
R1661 VSS VSS.n37 1.1205
R1662 VSS.n52 VSS 1.1205
R1663 VSS VSS.n284 1.0955
R1664 VSS.n43 VSS.t56 1.0925
R1665 VSS.n43 VSS.t255 1.0925
R1666 VSS.n336 VSS.n14 1.078
R1667 VSS.n234 VSS.n233 1.078
R1668 VSS VSS.t53 1.052
R1669 VSS VSS.t50 1.052
R1670 VSS.n213 VSS 0.9655
R1671 VSS.n318 VSS.n25 0.939071
R1672 VSS.n127 VSS.n25 0.939071
R1673 VSS.n129 VSS.n127 0.939071
R1674 VSS.n131 VSS.n129 0.939071
R1675 VSS.n133 VSS.n131 0.939071
R1676 VSS.n135 VSS.n133 0.939071
R1677 VSS.n139 VSS.n137 0.939071
R1678 VSS.n141 VSS.n139 0.939071
R1679 VSS.n143 VSS.n141 0.939071
R1680 VSS.n145 VSS.n143 0.939071
R1681 VSS.n147 VSS.n145 0.939071
R1682 VSS.n148 VSS.n147 0.939071
R1683 VSS.n334 VSS.n333 0.939071
R1684 VSS.n333 VSS.n331 0.939071
R1685 VSS.n331 VSS 0.939071
R1686 VSS VSS.n328 0.939071
R1687 VSS.n328 VSS.n326 0.939071
R1688 VSS.n326 VSS.n324 0.939071
R1689 VSS.n124 VSS.n123 0.939071
R1690 VSS.n123 VSS.n121 0.939071
R1691 VSS.n121 VSS.n119 0.939071
R1692 VSS.n117 VSS.n115 0.939071
R1693 VSS.n115 VSS.n113 0.939071
R1694 VSS.n113 VSS.n111 0.939071
R1695 VSS.n263 VSS 0.887643
R1696 VSS.n252 VSS 0.886036
R1697 VSS.n266 VSS 0.886036
R1698 VSS.n271 VSS 0.886036
R1699 VSS VSS.n210 0.879957
R1700 VSS VSS.n203 0.8405
R1701 VSS.n289 VSS.t2 0.8195
R1702 VSS.n289 VSS.t246 0.8195
R1703 VSS VSS.n52 0.803
R1704 VSS VSS.n37 0.803
R1705 VSS VSS.n341 0.7855
R1706 VSS.n320 VSS 0.7855
R1707 VSS VSS.n226 0.7855
R1708 VSS VSS.n90 0.7855
R1709 VSS VSS.n13 0.778
R1710 VSS VSS.n86 0.778
R1711 VSS VSS.n307 0.76675
R1712 VSS VSS.n167 0.76675
R1713 VSS VSS.n180 0.76675
R1714 VSS.n156 VSS 0.76675
R1715 VSS VSS.n99 0.7205
R1716 VSS VSS.n211 0.7205
R1717 VSS VSS.n82 0.7105
R1718 VSS.n212 VSS 0.704848
R1719 VSS VSS.n213 0.704848
R1720 VSS.n45 VSS 0.704848
R1721 VSS VSS.n47 0.704848
R1722 VSS VSS.n288 0.704848
R1723 VSS VSS.n42 0.704848
R1724 VSS VSS.n14 0.704848
R1725 VSS VSS.n13 0.704848
R1726 VSS.n234 VSS 0.704848
R1727 VSS VSS.n86 0.704848
R1728 VSS VSS.n198 0.704848
R1729 VSS.n203 VSS 0.704848
R1730 VSS VSS.n35 0.7005
R1731 VSS.n292 VSS 0.6989
R1732 VSS.n215 VSS.n209 0.68666
R1733 VSS.n50 VSS.n49 0.68594
R1734 VSS.n146 VSS.t132 0.6557
R1735 VSS.n146 VSS.t128 0.6557
R1736 VSS.n144 VSS.t122 0.6557
R1737 VSS.n144 VSS.t124 0.6557
R1738 VSS.n142 VSS.t126 0.6557
R1739 VSS.n142 VSS.t102 0.6557
R1740 VSS.n140 VSS.t100 0.6557
R1741 VSS.n140 VSS.t120 0.6557
R1742 VSS.n138 VSS.t118 0.6557
R1743 VSS.n138 VSS.t106 0.6557
R1744 VSS.n136 VSS.t116 0.6557
R1745 VSS.n136 VSS.t84 0.6557
R1746 VSS.n134 VSS.t82 0.6557
R1747 VSS.n134 VSS.t104 0.6557
R1748 VSS.n132 VSS.t114 0.6557
R1749 VSS.n132 VSS.t80 0.6557
R1750 VSS.n130 VSS.t78 0.6557
R1751 VSS.n130 VSS.t108 0.6557
R1752 VSS.n128 VSS.t112 0.6557
R1753 VSS.n128 VSS.t96 0.6557
R1754 VSS.n126 VSS.t94 0.6557
R1755 VSS.n126 VSS.t110 0.6557
R1756 VSS.n24 VSS.t98 0.6557
R1757 VSS.n24 VSS.t92 0.6557
R1758 VSS.n325 VSS.t150 0.6557
R1759 VSS.n325 VSS.t148 0.6557
R1760 VSS.n327 VSS.t146 0.6557
R1761 VSS.n327 VSS.t144 0.6557
R1762 VSS.n329 VSS.t142 0.6557
R1763 VSS.n329 VSS.t140 0.6557
R1764 VSS.n330 VSS.t138 0.6557
R1765 VSS.n330 VSS.t136 0.6557
R1766 VSS.n332 VSS.t134 0.6557
R1767 VSS.n332 VSS.t130 0.6557
R1768 VSS.n112 VSS.t164 0.6557
R1769 VSS.n112 VSS.t162 0.6557
R1770 VSS.n114 VSS.t156 0.6557
R1771 VSS.n114 VSS.t154 0.6557
R1772 VSS.n116 VSS.t160 0.6557
R1773 VSS.n116 VSS.t158 0.6557
R1774 VSS.n118 VSS.t76 0.6557
R1775 VSS.n118 VSS.t74 0.6557
R1776 VSS.n120 VSS.t88 0.6557
R1777 VSS.n120 VSS.t86 0.6557
R1778 VSS.n122 VSS.t152 0.6557
R1779 VSS.n122 VSS.t90 0.6557
R1780 VSS.n47 VSS 0.653
R1781 VSS VSS.n4 0.6505
R1782 VSS.n205 VSS.n4 0.6505
R1783 VSS VSS.n5 0.6505
R1784 VSS.n8 VSS.n5 0.6505
R1785 VSS VSS.n42 0.6355
R1786 VSS VSS.n353 0.6341
R1787 VSS.n46 VSS.n3 0.6255
R1788 VSS.n352 VSS.n2 0.6255
R1789 VSS.n295 VSS.n294 0.6255
R1790 VSS.n341 VSS.n340 0.6255
R1791 VSS.n321 VSS.n320 0.6255
R1792 VSS.n317 VSS.n316 0.6255
R1793 VSS.n226 VSS.n91 0.6255
R1794 VSS.n229 VSS.n90 0.6255
R1795 VSS.n307 VSS.n306 0.6255
R1796 VSS.n167 VSS.n166 0.6255
R1797 VSS.n180 VSS.n179 0.6255
R1798 VSS.n157 VSS.n156 0.6255
R1799 VSS.n202 VSS.n102 0.6255
R1800 VSS.n208 VSS.n101 0.6255
R1801 VSS.n217 VSS.n99 0.6255
R1802 VSS.n211 VSS.n98 0.6255
R1803 VSS.n335 VSS.n22 0.6251
R1804 VSS.n166 VSS 0.5955
R1805 VSS.n306 VSS 0.5955
R1806 VSS.n157 VSS 0.5955
R1807 VSS.n179 VSS 0.5955
R1808 VSS VSS.n202 0.5955
R1809 VSS VSS.n101 0.5955
R1810 VSS VSS.n287 0.578278
R1811 VSS.n287 VSS.n286 0.578278
R1812 VSS.n296 VSS 0.578278
R1813 VSS.n297 VSS.n296 0.578278
R1814 VSS VSS.n318 0.556571
R1815 VSS VSS.n148 0.556571
R1816 VSS VSS.n291 0.550143
R1817 VSS VSS.n334 0.550143
R1818 VSS.n199 VSS.t65 0.5465
R1819 VSS.n199 VSS.t252 0.5465
R1820 VSS VSS.n317 0.533
R1821 VSS.n191 VSS 0.533
R1822 VSS.n345 VSS 0.533
R1823 VSS VSS.n346 0.533
R1824 VSS.n236 VSS 0.533
R1825 VSS VSS.n237 0.533
R1826 VSS VSS.n235 0.5205
R1827 VSS.n235 VSS.n76 0.5205
R1828 VSS.n238 VSS 0.5205
R1829 VSS.n239 VSS.n238 0.5205
R1830 VSS VSS.n344 0.5205
R1831 VSS.n344 VSS.n343 0.5205
R1832 VSS.n347 VSS 0.5205
R1833 VSS.n348 VSS.n347 0.5205
R1834 VSS VSS.n108 0.5205
R1835 VSS.n183 VSS.n108 0.5205
R1836 VSS VSS.n26 0.5205
R1837 VSS.n164 VSS.n26 0.5205
R1838 VSS.n111 VSS 0.511571
R1839 VSS.n291 VSS 0.4955
R1840 VSS.n324 VSS 0.4955
R1841 VSS VSS.n124 0.4955
R1842 VSS.n294 VSS 0.4855
R1843 VSS.n284 VSS 0.4855
R1844 VSS.n53 VSS 0.4855
R1845 VSS VSS.n36 0.4855
R1846 VSS VSS.n98 0.4855
R1847 VSS VSS.n217 0.4855
R1848 VSS.n214 VSS 0.476214
R1849 VSS.n303 VSS 0.476214
R1850 VSS.n189 VSS.n188 0.4757
R1851 VSS.n315 VSS.n314 0.4757
R1852 VSS.n267 VSS.n66 0.473227
R1853 VSS.n67 VSS.n65 0.473227
R1854 VSS.n65 VSS.n64 0.473227
R1855 VSS.n74 VSS.n72 0.473227
R1856 VSS.n258 VSS.n74 0.473227
R1857 VSS.n73 VSS.n71 0.473227
R1858 VSS VSS.n103 0.473227
R1859 VSS.n197 VSS.n103 0.473227
R1860 VSS VSS.n104 0.473227
R1861 VSS.n206 VSS.n104 0.473227
R1862 VSS.n247 VSS 0.473227
R1863 VSS.n248 VSS.n247 0.473227
R1864 VSS VSS.n241 0.473227
R1865 VSS.n241 VSS.n240 0.473227
R1866 VSS.n66 VSS.n60 0.471002
R1867 VSS VSS.n295 0.4705
R1868 VSS VSS.n135 0.469786
R1869 VSS.n137 VSS 0.469786
R1870 VSS.n119 VSS 0.469786
R1871 VSS VSS.n117 0.469786
R1872 VSS VSS.n303 0.468179
R1873 VSS VSS.n48 0.460143
R1874 VSS VSS.n214 0.456929
R1875 VSS.n201 VSS 0.4505
R1876 VSS.n246 VSS.n80 0.4105
R1877 VSS.n243 VSS.n242 0.4105
R1878 VSS.n210 VSS.t239 0.41
R1879 VSS.n210 VSS.t248 0.41
R1880 VSS VSS.n46 0.408
R1881 VSS VSS.n2 0.408
R1882 VSS.n245 VSS.n81 0.40496
R1883 VSS VSS.n97 0.4005
R1884 VSS.n195 VSS.n97 0.4005
R1885 VSS VSS.n94 0.4005
R1886 VSS.n232 VSS.n231 0.3965
R1887 VSS VSS.n3 0.3855
R1888 VSS.n352 VSS 0.3855
R1889 VSS VSS.n102 0.3855
R1890 VSS.n208 VSS 0.3855
R1891 VSS VSS.n154 0.371929
R1892 VSS.n154 VSS.n152 0.371929
R1893 VSS VSS.n155 0.371929
R1894 VSS.n159 VSS.n155 0.371929
R1895 VSS.n168 VSS 0.371929
R1896 VSS.n169 VSS.n168 0.371929
R1897 VSS.n308 VSS 0.371929
R1898 VSS.n309 VSS.n308 0.371929
R1899 VSS VSS.n92 0.371929
R1900 VSS.n224 VSS.n92 0.371929
R1901 VSS VSS.n93 0.371929
R1902 VSS.n93 VSS.n83 0.371929
R1903 VSS VSS.n17 0.371929
R1904 VSS.n17 VSS.n15 0.371929
R1905 VSS VSS.n20 0.371929
R1906 VSS.n20 VSS.n19 0.371929
R1907 VSS.n48 VSS 0.366929
R1908 VSS.n201 VSS 0.366929
R1909 VSS.n158 VSS.n81 0.35474
R1910 VSS.n178 VSS.n177 0.35474
R1911 VSS.n172 VSS.n33 0.35474
R1912 VSS.n35 VSS.t222 0.352002
R1913 VSS.n35 VSS.t225 0.352002
R1914 VSS.n339 VSS.n338 0.3497
R1915 VSS VSS.n302 0.347167
R1916 VSS VSS.n39 0.347167
R1917 VSS.n204 VSS 0.347167
R1918 VSS.t251 VSS.n204 0.347167
R1919 VSS VSS.n207 0.347167
R1920 VSS.n207 VSS.t251 0.347167
R1921 VSS VSS.n6 0.347167
R1922 VSS.t254 VSS.n6 0.347167
R1923 VSS VSS.n351 0.347167
R1924 VSS.n351 VSS.t254 0.347167
R1925 VSS VSS.n185 0.347167
R1926 VSS.n185 VSS.n184 0.347167
R1927 VSS VSS.n311 0.347167
R1928 VSS.n311 VSS.n310 0.347167
R1929 VSS VSS.n163 0.3355
R1930 VSS.n230 VSS.n89 0.33386
R1931 VSS.n339 VSS.n21 0.33386
R1932 VSS.n55 VSS.n54 0.3209
R1933 VSS.n288 VSS.n283 0.3105
R1934 VSS.n269 VSS.n268 0.306382
R1935 VSS.t186 VSS.n269 0.306382
R1936 VSS.n69 VSS.n68 0.306382
R1937 VSS.n260 VSS.n259 0.306382
R1938 VSS.t244 VSS.n260 0.306382
R1939 VSS.n262 VSS.n261 0.306382
R1940 VSS.n261 VSS.t244 0.306382
R1941 VSS.n301 VSS 0.306382
R1942 VSS VSS.n40 0.306382
R1943 VSS.n285 VSS.n40 0.306382
R1944 VSS VSS.n41 0.306382
R1945 VSS.n285 VSS.n41 0.306382
R1946 VSS VSS.n38 0.306382
R1947 VSS.n299 VSS.n38 0.306382
R1948 VSS.n218 VSS 0.306382
R1949 VSS.n219 VSS.n218 0.306382
R1950 VSS VSS.n96 0.306382
R1951 VSS.n219 VSS.n96 0.306382
R1952 VSS.n177 VSS 0.30596
R1953 VSS.n172 VSS 0.30596
R1954 VSS.n68 VSS.n60 0.305119
R1955 VSS.n337 VSS 0.2905
R1956 VSS.n312 VSS 0.2905
R1957 VSS.n88 VSS 0.2905
R1958 VSS.n53 VSS 0.2905
R1959 VSS.n181 VSS 0.289389
R1960 VSS.n182 VSS.n181 0.289389
R1961 VSS VSS.n153 0.289389
R1962 VSS.n182 VSS.n153 0.289389
R1963 VSS VSS.n31 0.289389
R1964 VSS.n165 VSS.n31 0.289389
R1965 VSS VSS.n32 0.289389
R1966 VSS.n165 VSS.n32 0.289389
R1967 VSS.n151 VSS 0.24188
R1968 VSS VSS.n28 0.24188
R1969 VSS VSS.n290 0.238357
R1970 VSS.n227 VSS 0.17981
R1971 VSS.t175 VSS.n227 0.17981
R1972 VSS VSS.n228 0.17981
R1973 VSS.n228 VSS.t175 0.17981
R1974 VSS.n342 VSS 0.17981
R1975 VSS.t168 VSS.n342 0.17981
R1976 VSS VSS.n16 0.17981
R1977 VSS.t168 VSS.n16 0.17981
R1978 VSS.n149 VSS.n125 0.1769
R1979 VSS.n323 VSS.n319 0.1769
R1980 VSS VSS.n161 0.173833
R1981 VSS.n161 VSS.n160 0.173833
R1982 VSS VSS.n171 0.173833
R1983 VSS.n171 VSS.n170 0.173833
R1984 VSS.n178 VSS.n158 0.1733
R1985 VSS.n305 VSS.n33 0.1733
R1986 VSS VSS.n42 0.1605
R1987 VSS.n288 VSS 0.1605
R1988 VSS VSS.n262 0.1499
R1989 VSS VSS.n69 0.1499
R1990 VSS.n54 VSS.n34 0.14162
R1991 VSS.n293 VSS.n50 0.14162
R1992 VSS VSS.n107 0.118682
R1993 VSS.n193 VSS.n107 0.118682
R1994 VSS VSS.n106 0.118682
R1995 VSS.n193 VSS.n106 0.118682
R1996 VSS.n209 VSS.n100 0.11282
R1997 VSS.n353 VSS.n1 0.11282
R1998 VSS.n44 VSS 0.109786
R1999 VSS VSS.n200 0.109786
R2000 VSS VSS.n11 0.106622
R2001 VSS.n18 VSS.n11 0.106622
R2002 VSS VSS.n12 0.106622
R2003 VSS.n18 VSS.n12 0.106622
R2004 VSS.n338 VSS.n335 0.10634
R2005 VSS.n293 VSS.n292 0.10634
R2006 VSS.n264 VSS.n70 0.10418
R2007 VSS.n265 VSS.n58 0.104
R2008 VSS.n272 VSS.n58 0.104
R2009 VSS.n87 VSS.n84 0.0950455
R2010 VSS.n225 VSS.n84 0.0950455
R2011 VSS VSS.n85 0.0950455
R2012 VSS.n225 VSS.n85 0.0950455
R2013 VSS VSS.n77 0.0933571
R2014 VSS.n223 VSS.n77 0.0933571
R2015 VSS.n244 VSS.n78 0.0933571
R2016 VSS.n223 VSS.n78 0.0933571
R2017 VSS.n304 VSS.n34 0.08798
R2018 VSS.n49 VSS.n1 0.08618
R2019 VSS.n174 VSS.n173 0.0857632
R2020 VSS.n176 VSS.n175 0.0857632
R2021 VSS.n216 VSS.n215 0.08546
R2022 VSS.n150 VSS.n149 0.08474
R2023 VSS.n319 VSS.n23 0.08474
R2024 VSS.n100 VSS.n0 0.08402
R2025 VSS.n47 VSS 0.0805
R2026 VSS.n45 VSS 0.0805
R2027 VSS VSS.n14 0.0805
R2028 VSS VSS.n13 0.0805
R2029 VSS VSS.n234 0.0805
R2030 VSS VSS.n86 0.0805
R2031 VSS.n203 VSS 0.0805
R2032 VSS.n198 VSS 0.0805
R2033 VSS.n213 VSS 0.0805
R2034 VSS.n212 VSS 0.0805
R2035 VSS.n125 VSS.n110 0.07106
R2036 VSS.n323 VSS.n322 0.07106
R2037 VSS.n231 VSS.n230 0.06314
R2038 VSS.n192 VSS 0.0558191
R2039 VSS.n193 VSS.n192 0.0558191
R2040 VSS VSS.n105 0.0558191
R2041 VSS.n193 VSS.n105 0.0558191
R2042 VSS.n29 VSS 0.0541082
R2043 VSS.n193 VSS.n29 0.0541082
R2044 VSS.n30 VSS 0.0541082
R2045 VSS.n193 VSS.n30 0.0541082
R2046 VSS.n280 VSS.n279 0.0536955
R2047 VSS.n281 VSS.n280 0.0536955
R2048 VSS.n273 VSS.n57 0.0536955
R2049 VSS.n277 VSS.n56 0.053
R2050 VSS.n274 VSS.n273 0.0270978
R2051 VSS.n57 VSS.n56 0.0270978
R2052 VSS.n279 VSS.n278 0.0270978
R2053 VSS.n282 VSS.n281 0.0270978
R2054 VSS.n55 VSS.n51 0.0257
R2055 VSS VSS.n0 0.0257
R2056 VSS.n110 VSS.n89 0.02354
R2057 VSS.n189 VSS.n150 0.02354
R2058 VSS.n315 VSS.n23 0.02354
R2059 VSS.n322 VSS.n21 0.02354
R2060 VSS.n276 VSS.n275 0.0135648
R2061 VSS.n276 VSS.n22 0.0135648
R2062 VSS.n188 VSS.n151 0.00824
R2063 VSS.n314 VSS.n28 0.00824
R2064 VSS.t186 VSS.n60 0.00207056
R2065 i2.0.n0 i2.0.t3 0.485833
R2066 i2.0.n0 i2.0.t2 0.485833
R2067 i2.0 i2.0.n0 0.742457
R2068 i2.0.n2 i2.0 0.238357
R2069 i2.0 i2.0.n2 0.68675
R2070 i2.0 i2.0.n3 0.032
R2071 i2.0.n3 i2.0 0.331571
R2072 i2.0 i2.0.n5 0.768714
R2073 i2.0.n5 i2.0 0.148357
R2074 i2.0 i2.0.n9 0.329196
R2075 i2.0.t10 i2.0.n9 66.8888
R2076 i2.0.t11 i2.0.n9 66.5757
R2077 i2.0.n5 i2.0 4.59371
R2078 i2.0 i2.0.n6 0.0787609
R2079 i2.0.n6 i2.0.n7 0.313543
R2080 i2.0.n7 i2.0.n8 0.313543
R2081 i2.0.t6 i2.0.n8 79.9245
R2082 i2.0.t7 i2.0.n8 79.6114
R2083 i2.0.t8 i2.0.n7 79.6114
R2084 i2.0.t9 i2.0.n6 79.6114
R2085 i2.0 i2.0.n3 5.68336
R2086 i2.0 i2.0.n4 1.14246
R2087 i2.0.t0 i2.0.n4 0.5465
R2088 i2.0.n4 i2.0.t4 0.5465
R2089 i2.0 i2.0.n2 9.0005
R2090 i2.0 i2.0.n1 0.742457
R2091 i2.0.t1 i2.0.n1 0.485833
R2092 i2.0.n1 i2.0.t5 0.485833
R2093 i1.0.t0 i1.0.n0 1.0925
R2094 i1.0.n0 i1.0.t3 1.0925
R2095 i1.0 i1.0.n0 2.19246
R2096 i1.0 i1.0.n1 0.19175
R2097 i1.0.n1 i1.0 0.156393
R2098 i1.0 i1.0.n5 0.835314
R2099 i1.0.t1 i1.0.n5 0.492392
R2100 i1.0.n5 i1.0.t2 0.492392
R2101 i1.0 i1.0.n1 4.59371
R2102 i1.0 i1.0.n2 0.656214
R2103 i1.0.n2 i1.0 0.100143
R2104 i1.0.t6 i1.0 54.0252
R2105 i1.0.n2 i1.0 4.59371
R2106 i1.0 i1.0.n3 0.425345
R2107 i1.0.n3 i1.0 1.91999
R2108 i1.0 i1.0.n4 0.391804
R2109 i1.0.t4 i1.0.n4 63.6298
R2110 i1.0.t5 i1.0.n4 63.3168
R2111 i1.0.n3 i1.0 4.59082
R2112 nm.0 nm.0.n0 1.5755
R2113 nm.0.t0 nm.0.n0 0.8195
R2114 nm.0.n0 nm.0.t1 0.8195
R2115 nd.0.n0 nd.0.t5 0.607167
R2116 nd.0.n0 nd.0.t2 0.607167
R2117 nd.0 nd.0.n0 0.959123
R2118 nd.0.n2 nd.0 0.238357
R2119 nd.0 nd.0.n2 0.689964
R2120 nd.0.n3 nd.0 4.5005
R2121 nd.0.n3 nd.0 0.0905
R2122 nd.0 nd.0.n3 6.47407
R2123 nd.0 nd.0.n5 1.78121
R2124 nd.0.n5 nd.0 0.0937143
R2125 nd.0.t6 nd.0 63.2128
R2126 nd.0.n5 nd.0 4.70621
R2127 nd.0.t7 nd.0 34.4736
R2128 nd.0 nd.0.n4 1.79267
R2129 nd.0.t0 nd.0.n4 0.8195
R2130 nd.0.n4 nd.0.t3 0.8195
R2131 nd.0 nd.0.n2 9.0005
R2132 nd.0 nd.0.n1 0.959123
R2133 nd.0.t1 nd.0.n1 0.607167
R2134 nd.0.n1 nd.0.t4 0.607167
R2135 d3.0.n0 d3.0.t3 0.984284
R2136 d3.0.n0 d3.0.t2 0.984284
R2137 d3.0 d3.0.n0 1.51767
R2138 d3.0 d3.0.n2 9.9905
R2139 d3.0 d3.0.n2 0.4955
R2140 d3.0.n4 d3.0 0.4955
R2141 d3.0.n6 d3.0.n4 0.9905
R2142 d3.0 d3.0.n6 1.36657
R2143 d3.0.n7 d3.0 4.5005
R2144 d3.0 d3.0.n7 0.312125
R2145 d3.0.n7 d3.0 0.0855179
R2146 d3.0.n9 d3.0 1.78121
R2147 d3.0 d3.0.n9 1.0355
R2148 d3.0.t11 d3.0 40.9895
R2149 d3.0.n9 d3.0 5.60621
R2150 d3.0.t10 d3.0 54.0878
R2151 d3.0.n8 d3.0 0.917674
R2152 d3.0.t1 d3.0.n8 0.352002
R2153 d3.0.n8 d3.0.t0 0.352002
R2154 d3.0 d3.0.n6 9.0005
R2155 d3.0.n5 d3.0 1.51767
R2156 d3.0.t9 d3.0.n5 0.984284
R2157 d3.0.n5 d3.0.t8 0.984284
R2158 d3.0 d3.0.n4 9.0005
R2159 d3.0.n3 d3.0 1.51767
R2160 d3.0.t7 d3.0.n3 0.984284
R2161 d3.0.n3 d3.0.t6 0.984284
R2162 d3.0 d3.0.n2 9.0005
R2163 d3.0.n1 d3.0 1.51767
R2164 d3.0.t5 d3.0.n1 0.984284
R2165 d3.0.n1 d3.0.t4 0.984284
R2166 n3a.0.n0 n3a.0.t10 0.984284
R2167 n3a.0.n0 n3a.0.t2 0.984284
R2168 n3a.0 n3a.0.n0 1.51767
R2169 n3a.0 n3a.0.n2 9.9905
R2170 n3a.0 n3a.0.n2 0.9905
R2171 n3a.0.n5 n3a.0 0.9905
R2172 n3a.0.n7 n3a.0.n5 0.9905
R2173 n3a.0 n3a.0.n7 1.22193
R2174 n3a.0 n3a.0.n9 0.329196
R2175 n3a.0.t13 n3a.0.n9 75.4923
R2176 n3a.0.t3 n3a.0.n9 75.1793
R2177 n3a.0 n3a.0.n8 0.917674
R2178 n3a.0.t0 n3a.0.n8 0.352002
R2179 n3a.0.n8 n3a.0.t4 0.352002
R2180 n3a.0 n3a.0.n7 9.0005
R2181 n3a.0 n3a.0.n6 1.51767
R2182 n3a.0.t1 n3a.0.n6 0.984284
R2183 n3a.0.n6 n3a.0.t9 0.984284
R2184 n3a.0 n3a.0.n5 9.0005
R2185 n3a.0 n3a.0.n4 1.51767
R2186 n3a.0.t8 n3a.0.n4 0.984284
R2187 n3a.0.n4 n3a.0.t7 0.984284
R2188 n3a.0 n3a.0.n3 1.51767
R2189 n3a.0.t6 n3a.0.n3 0.984284
R2190 n3a.0.n3 n3a.0.t5 0.984284
R2191 n3a.0 n3a.0.n2 9.0005
R2192 n3a.0 n3a.0.n1 1.51767
R2193 n3a.0.t12 n3a.0.n1 0.984284
R2194 n3a.0.n1 n3a.0.t11 0.984284
R2195 sb.0.n0 sb.0.t2 0.375328
R2196 sb.0.n0 sb.0.t1 0.375328
R2197 sb.0 sb.0.n0 0.792457
R2198 sb.0 sb.0.t0 1.4283
R2199 d2b.0.n0 d2b.0.t8 0.984284
R2200 d2b.0.n0 d2b.0.t10 0.984284
R2201 d2b.0 d2b.0.n0 1.51767
R2202 d2b.0 d2b.0.n31 9.0005
R2203 d2b.0.n31 d2b.0 1.03229
R2204 d2b.0 d2b.0.n30 0.463357
R2205 d2b.0 d2b.0.n30 0.722107
R2206 d2b.0.n29 d2b.0.n28 0.313543
R2207 d2b.0.n28 d2b.0.n27 0.313543
R2208 d2b.0.n27 d2b.0.n26 0.93963
R2209 d2b.0.n26 d2b.0.n25 0.313543
R2210 d2b.0.n25 d2b.0 1.01593
R2211 d2b.0 d2b.0.n24 0.550283
R2212 d2b.0.n24 d2b.0.n23 0.313543
R2213 d2b.0.n23 d2b.0.n22 0.313543
R2214 d2b.0.n22 d2b.0.n21 0.313543
R2215 d2b.0.n21 d2b.0 10.6538
R2216 d2b.0.n29 d2b.0.t3 38.862
R2217 d2b.0.n29 d2b.0.t5 38.5489
R2218 d2b.0.n28 d2b.0.t25 38.5489
R2219 d2b.0.n27 d2b.0.t24 38.5489
R2220 d2b.0.n26 d2b.0.t23 38.5489
R2221 d2b.0.n25 d2b.0.t22 38.5489
R2222 d2b.0.n24 d2b.0.t21 38.5489
R2223 d2b.0.n23 d2b.0.t20 38.5489
R2224 d2b.0.n22 d2b.0.t7 38.5489
R2225 d2b.0.n21 d2b.0.t9 38.5489
R2226 d2b.0.n30 d2b.0.n20 4.99229
R2227 d2b.0 d2b.0.n20 0.0953214
R2228 d2b.0 d2b.0.n19 1.39246
R2229 d2b.0.t2 d2b.0.n19 0.9105
R2230 d2b.0.n19 d2b.0.t19 0.9105
R2231 d2b.0.n20 d2b.0 0.121036
R2232 d2b.0 d2b.0.n8 0.993714
R2233 d2b.0.n8 d2b.0 1.44371
R2234 d2b.0 d2b.0.n17 1.27496
R2235 d2b.0.n17 d2b.0 0.309071
R2236 d2b.0 d2b.0.n18 0.792457
R2237 d2b.0.t16 d2b.0.n18 0.375328
R2238 d2b.0.n18 d2b.0.t1 0.375328
R2239 d2b.0 d2b.0.n17 9.0005
R2240 d2b.0 d2b.0.n16 0.792457
R2241 d2b.0.t0 d2b.0.n16 0.375328
R2242 d2b.0.n16 d2b.0.t17 0.375328
R2243 d2b.0 d2b.0.n8 10.5562
R2244 d2b.0.n15 d2b.0.n14 0.93963
R2245 d2b.0.n14 d2b.0.n13 0.313543
R2246 d2b.0.n13 d2b.0.n12 0.93963
R2247 d2b.0.n12 d2b.0 0.235283
R2248 d2b.0 d2b.0.n11 0.0787609
R2249 d2b.0.n11 d2b.0.n10 0.93963
R2250 d2b.0.n10 d2b.0.n9 0.313543
R2251 d2b.0.n9 d2b.0 10.3407
R2252 d2b.0.n15 d2b.0.t33 38.862
R2253 d2b.0.n15 d2b.0.t32 38.5489
R2254 d2b.0.n14 d2b.0.t31 38.5489
R2255 d2b.0.n13 d2b.0.t30 38.5489
R2256 d2b.0.n12 d2b.0.t29 38.5489
R2257 d2b.0.n11 d2b.0.t28 38.5489
R2258 d2b.0.n10 d2b.0.t27 38.5489
R2259 d2b.0.n9 d2b.0.t26 38.5489
R2260 d2b.0.n31 d2b.0.n2 0.9905
R2261 d2b.0.n2 d2b.0.n4 0.476214
R2262 d2b.0 d2b.0.n4 0.238357
R2263 d2b.0.n6 d2b.0 0.752643
R2264 d2b.0 d2b.0.n6 9.9905
R2265 d2b.0.n7 d2b.0 1.51767
R2266 d2b.0.t4 d2b.0.n7 0.984284
R2267 d2b.0.n7 d2b.0.t6 0.984284
R2268 d2b.0 d2b.0.n6 9.0005
R2269 d2b.0.n5 d2b.0 1.51767
R2270 d2b.0.t18 d2b.0.n5 0.984284
R2271 d2b.0.n5 d2b.0.t14 0.984284
R2272 d2b.0 d2b.0.n4 9.0005
R2273 d2b.0.n3 d2b.0 1.51767
R2274 d2b.0.t13 d2b.0.n3 0.984284
R2275 d2b.0.n3 d2b.0.t12 0.984284
R2276 d2b.0 d2b.0.n2 9.0005
R2277 d2b.0.n1 d2b.0 1.51767
R2278 d2b.0.t11 d2b.0.n1 0.984284
R2279 d2b.0.n1 d2b.0.t15 0.984284
R2280 rlb_m1.0 rlb_m1.0.t0 3.57
R2281 rlb_m1.0 rlb_m1.0.t1 3.57
R2282 rla_m1.0 rla_m1.0.t0 3.57
R2283 rla_m1.0 rla_m1.0.t1 3.57
R2284 sa.0.n0 sa.0.t2 0.375328
R2285 sa.0.n0 sa.0.t1 0.375328
R2286 sa.0 sa.0.n0 0.792457
R2287 sa.0 sa.0.t0 1.4283
R2288 d2a.0 d2a.0.n0 1.3005
R2289 d2a.0.n0 d2a.0.t15 0.984284
R2290 d2a.0.n0 d2a.0.t16 0.984284
R2291 d2a.0 d2a.0.n31 9.0005
R2292 d2a.0 d2a.0.n31 9.9905
R2293 d2a.0.n30 d2a.0 1.3005
R2294 d2a.0.t7 d2a.0.n30 0.984284
R2295 d2a.0.n30 d2a.0.t9 0.984284
R2296 d2a.0 d2a.0.n31 1.26693
R2297 d2a.0.n2 d2a.0 0.238357
R2298 d2a.0.n4 d2a.0.n2 0.9905
R2299 d2a.0.n6 d2a.0.n4 0.9905
R2300 d2a.0.n29 d2a.0 0.206214
R2301 d2a.0 d2a.0.n6 0.775143
R2302 d2a.0.n29 d2a.0 0.516393
R2303 d2a.0 d2a.0.n20 10.0277
R2304 d2a.0.n20 d2a.0.n21 0.313543
R2305 d2a.0.n21 d2a.0.n22 1.56572
R2306 d2a.0.n22 d2a.0.n23 0.313543
R2307 d2a.0.n23 d2a.0 0.235283
R2308 d2a.0 d2a.0.n24 0.704848
R2309 d2a.0.n24 d2a.0.n25 0.313543
R2310 d2a.0.n25 d2a.0.n26 0.313543
R2311 d2a.0.n26 d2a.0.n27 0.313543
R2312 d2a.0.n27 d2a.0.n28 1.56572
R2313 d2a.0.t8 d2a.0.n28 38.862
R2314 d2a.0.t6 d2a.0.n28 38.5489
R2315 d2a.0.t20 d2a.0.n27 38.5489
R2316 d2a.0.t21 d2a.0.n26 38.5489
R2317 d2a.0.t22 d2a.0.n25 38.5489
R2318 d2a.0.t23 d2a.0.n24 38.5489
R2319 d2a.0.t24 d2a.0.n23 38.5489
R2320 d2a.0.t25 d2a.0.n22 38.5489
R2321 d2a.0.t4 d2a.0.n21 38.5489
R2322 d2a.0.t2 d2a.0.n20 38.5489
R2323 d2a.0.n29 d2a.0 5.10318
R2324 d2a.0 d2a.0.n7 0.113
R2325 d2a.0.n7 d2a.0.n9 0.861929
R2326 d2a.0.n9 d2a.0 1.55621
R2327 d2a.0.n18 d2a.0 1.27496
R2328 d2a.0 d2a.0.n18 0.309071
R2329 d2a.0 d2a.0.n19 0.792457
R2330 d2a.0.t0 d2a.0.n19 0.375328
R2331 d2a.0.n19 d2a.0.t19 0.375328
R2332 d2a.0 d2a.0.n18 9.0005
R2333 d2a.0 d2a.0.n17 0.792457
R2334 d2a.0.t18 d2a.0.n17 0.375328
R2335 d2a.0.n17 d2a.0.t1 0.375328
R2336 d2a.0 d2a.0.n9 10.6687
R2337 d2a.0 d2a.0.n10 10.0277
R2338 d2a.0.n10 d2a.0.n11 0.93963
R2339 d2a.0.n11 d2a.0.n12 0.313543
R2340 d2a.0.n12 d2a.0 0.548326
R2341 d2a.0 d2a.0.n13 0.391804
R2342 d2a.0.n13 d2a.0.n14 0.313543
R2343 d2a.0.n14 d2a.0.n15 0.93963
R2344 d2a.0.n15 d2a.0.n16 0.313543
R2345 d2a.0.t26 d2a.0.n16 39.4881
R2346 d2a.0.t27 d2a.0.n16 38.5489
R2347 d2a.0.t28 d2a.0.n15 38.5489
R2348 d2a.0.t29 d2a.0.n14 38.5489
R2349 d2a.0.t30 d2a.0.n13 38.5489
R2350 d2a.0.t31 d2a.0.n12 38.5489
R2351 d2a.0.t32 d2a.0.n11 38.5489
R2352 d2a.0.t33 d2a.0.n10 38.5489
R2353 d2a.0 d2a.0.n7 4.59371
R2354 d2a.0 d2a.0.n8 1.39246
R2355 d2a.0.t10 d2a.0.n8 0.9105
R2356 d2a.0.n8 d2a.0.t17 0.9105
R2357 d2a.0 d2a.0.n6 9.0005
R2358 d2a.0.n5 d2a.0 1.3005
R2359 d2a.0.t3 d2a.0.n5 0.984284
R2360 d2a.0.n5 d2a.0.t5 0.984284
R2361 d2a.0 d2a.0.n4 9.0005
R2362 d2a.0.n3 d2a.0 1.3005
R2363 d2a.0.t11 d2a.0.n3 0.984284
R2364 d2a.0.n3 d2a.0.t12 0.984284
R2365 d2a.0 d2a.0.n2 9.0005
R2366 d2a.0.n1 d2a.0 1.3005
R2367 d2a.0.t13 d2a.0.n1 0.984284
R2368 d2a.0.n1 d2a.0.t14 0.984284
R2369 ts.0.t13 ts.0.n0 0.6557
R2370 ts.0.n0 ts.0.t1 0.6557
R2371 ts.0 ts.0.n0 1.35246
R2372 ts.0 ts.0.n11 9.0005
R2373 ts.0.n11 ts.0 0.868357
R2374 ts.0.t15 ts.0 1.4283
R2375 ts.0.t14 ts.0 1.4283
R2376 ts.0.n11 ts.0.n2 0.939071
R2377 ts.0.n2 ts.0.n4 0.939071
R2378 ts.0 ts.0.n4 0.939071
R2379 ts.0.n7 ts.0 0.939071
R2380 ts.0.n9 ts.0.n7 0.939071
R2381 ts.0 ts.0.n9 9.93907
R2382 ts.0 ts.0.n10 1.35246
R2383 ts.0.t0 ts.0.n10 0.6557
R2384 ts.0.n10 ts.0.t2 0.6557
R2385 ts.0 ts.0.n9 9.0005
R2386 ts.0 ts.0.n8 1.35246
R2387 ts.0.t3 ts.0.n8 0.6557
R2388 ts.0.n8 ts.0.t4 0.6557
R2389 ts.0 ts.0.n7 9.0005
R2390 ts.0 ts.0.n6 1.35246
R2391 ts.0.t5 ts.0.n6 0.6557
R2392 ts.0.n6 ts.0.t6 0.6557
R2393 ts.0 ts.0.n5 1.35246
R2394 ts.0.t7 ts.0.n5 0.6557
R2395 ts.0.n5 ts.0.t8 0.6557
R2396 ts.0 ts.0.n4 9.0005
R2397 ts.0 ts.0.n3 1.35246
R2398 ts.0.t9 ts.0.n3 0.6557
R2399 ts.0.n3 ts.0.t10 0.6557
R2400 ts.0 ts.0.n2 9.0005
R2401 ts.0 ts.0.n1 1.35246
R2402 ts.0.t11 ts.0.n1 0.6557
R2403 ts.0.n1 ts.0.t12 0.6557
R2404 tn.0.t12 tn.0.n0 0.6557
R2405 tn.0.n0 tn.0.t1 0.6557
R2406 tn.0 tn.0.n0 1.35246
R2407 tn.0 tn.0.n49 9.0005
R2408 tn.0.n49 tn.0 1.30229
R2409 tn.0 tn.0.n11 0.842643
R2410 tn.0.n11 tn.0.n13 0.617643
R2411 tn.0.n13 tn.0.n15 0.617643
R2412 tn.0.n15 tn.0.n17 0.617643
R2413 tn.0.n17 tn.0.n19 0.617643
R2414 tn.0.n19 tn.0.n21 0.617643
R2415 tn.0.n21 tn.0.n23 0.617643
R2416 tn.0.n23 tn.0.n25 0.617643
R2417 tn.0.n25 tn.0.n27 0.617643
R2418 tn.0.n27 tn.0.n29 0.617643
R2419 tn.0.n29 tn.0 0.309071
R2420 tn.0 tn.0.n31 0.309071
R2421 tn.0.n31 tn.0.n33 0.617643
R2422 tn.0.n33 tn.0.n35 0.617643
R2423 tn.0.n35 tn.0.n37 0.617643
R2424 tn.0.n37 tn.0.n39 0.617643
R2425 tn.0.n39 tn.0.n41 0.617643
R2426 tn.0.n41 tn.0.n43 0.617643
R2427 tn.0.n43 tn.0.n45 0.617643
R2428 tn.0.n45 tn.0.n47 0.617643
R2429 tn.0 tn.0.n47 9.61764
R2430 tn.0.n48 tn.0 0.6305
R2431 tn.0.t42 tn.0.n48 0.345342
R2432 tn.0.n48 tn.0.t30 0.345342
R2433 tn.0 tn.0.n47 9.0005
R2434 tn.0.n46 tn.0 0.6305
R2435 tn.0.t29 tn.0.n46 0.345342
R2436 tn.0.n46 tn.0.t41 0.345342
R2437 tn.0 tn.0.n45 9.0005
R2438 tn.0.n44 tn.0 0.6305
R2439 tn.0.t46 tn.0.n44 0.345342
R2440 tn.0.n44 tn.0.t28 0.345342
R2441 tn.0 tn.0.n43 9.0005
R2442 tn.0.n42 tn.0 0.6305
R2443 tn.0.t27 tn.0.n42 0.345342
R2444 tn.0.n42 tn.0.t45 0.345342
R2445 tn.0 tn.0.n41 9.0005
R2446 tn.0.n40 tn.0 0.6305
R2447 tn.0.t20 tn.0.n40 0.345342
R2448 tn.0.n40 tn.0.t16 0.345342
R2449 tn.0 tn.0.n39 9.0005
R2450 tn.0.n38 tn.0 0.6305
R2451 tn.0.t22 tn.0.n38 0.345342
R2452 tn.0.n38 tn.0.t15 0.345342
R2453 tn.0 tn.0.n37 9.0005
R2454 tn.0.n36 tn.0 0.6305
R2455 tn.0.t14 tn.0.n36 0.345342
R2456 tn.0.n36 tn.0.t25 0.345342
R2457 tn.0 tn.0.n35 9.0005
R2458 tn.0.n34 tn.0 0.6305
R2459 tn.0.t50 tn.0.n34 0.345342
R2460 tn.0.n34 tn.0.t19 0.345342
R2461 tn.0 tn.0.n33 9.0005
R2462 tn.0.n32 tn.0 0.6305
R2463 tn.0.t18 tn.0.n32 0.345342
R2464 tn.0.n32 tn.0.t17 0.345342
R2465 tn.0 tn.0.n31 9.0005
R2466 tn.0.n30 tn.0 0.6305
R2467 tn.0.t49 tn.0.n30 0.345342
R2468 tn.0.n30 tn.0.t21 0.345342
R2469 tn.0 tn.0.n29 9.0005
R2470 tn.0.n28 tn.0 0.6305
R2471 tn.0.t23 tn.0.n28 0.345342
R2472 tn.0.n28 tn.0.t48 0.345342
R2473 tn.0 tn.0.n27 9.0005
R2474 tn.0.n26 tn.0 0.6305
R2475 tn.0.t26 tn.0.n26 0.345342
R2476 tn.0.n26 tn.0.t2 0.345342
R2477 tn.0 tn.0.n25 9.0005
R2478 tn.0.n24 tn.0 0.6305
R2479 tn.0.t51 tn.0.n24 0.345342
R2480 tn.0.n24 tn.0.t47 0.345342
R2481 tn.0 tn.0.n23 9.0005
R2482 tn.0.n22 tn.0 0.6305
R2483 tn.0.t24 tn.0.n22 0.345342
R2484 tn.0.n22 tn.0.t13 0.345342
R2485 tn.0 tn.0.n21 9.0005
R2486 tn.0.n20 tn.0 0.6305
R2487 tn.0.t44 tn.0.n20 0.345342
R2488 tn.0.n20 tn.0.t36 0.345342
R2489 tn.0 tn.0.n19 9.0005
R2490 tn.0.n18 tn.0 0.6305
R2491 tn.0.t35 tn.0.n18 0.345342
R2492 tn.0.n18 tn.0.t43 0.345342
R2493 tn.0 tn.0.n17 9.0005
R2494 tn.0.n16 tn.0 0.6305
R2495 tn.0.t40 tn.0.n16 0.345342
R2496 tn.0.n16 tn.0.t34 0.345342
R2497 tn.0 tn.0.n15 9.0005
R2498 tn.0.n14 tn.0 0.6305
R2499 tn.0.t33 tn.0.n14 0.345342
R2500 tn.0.n14 tn.0.t39 0.345342
R2501 tn.0 tn.0.n13 9.0005
R2502 tn.0.n12 tn.0 0.6305
R2503 tn.0.t38 tn.0.n12 0.345342
R2504 tn.0.n12 tn.0.t32 0.345342
R2505 tn.0 tn.0.n11 9.0005
R2506 tn.0.n10 tn.0 0.6305
R2507 tn.0.t31 tn.0.n10 0.345342
R2508 tn.0.n10 tn.0.t37 0.345342
R2509 tn.0.n49 tn.0.n2 0.939071
R2510 tn.0.n2 tn.0.n4 0.939071
R2511 tn.0 tn.0.n4 0.469786
R2512 tn.0.n6 tn.0 0.469786
R2513 tn.0.n8 tn.0.n6 0.939071
R2514 tn.0 tn.0.n8 9.93907
R2515 tn.0 tn.0.n9 1.35246
R2516 tn.0.t0 tn.0.n9 0.6557
R2517 tn.0.n9 tn.0.t3 0.6557
R2518 tn.0 tn.0.n8 9.0005
R2519 tn.0 tn.0.n7 1.35246
R2520 tn.0.t4 tn.0.n7 0.6557
R2521 tn.0.n7 tn.0.t5 0.6557
R2522 tn.0 tn.0.n6 9.0005
R2523 tn.0 tn.0.n5 1.35246
R2524 tn.0.t6 tn.0.n5 0.6557
R2525 tn.0.n5 tn.0.t7 0.6557
R2526 tn.0 tn.0.n4 9.0005
R2527 tn.0 tn.0.n3 1.35246
R2528 tn.0.t8 tn.0.n3 0.6557
R2529 tn.0.n3 tn.0.t9 0.6557
R2530 tn.0 tn.0.n2 9.0005
R2531 tn.0 tn.0.n1 1.35246
R2532 tn.0.t10 tn.0.n1 0.6557
R2533 tn.0.n1 tn.0.t11 0.6557
R2534 ob.0.t23 ob.0 1.19252
R2535 ob.0 ob.0.n27 9.0005
R2536 ob.0.n27 ob.0 0.566214
R2537 ob.0 ob.0.n26 4.98907
R2538 ob.0 ob.0.n26 0.654607
R2539 ob.0.n25 ob.0 5.38121
R2540 ob.0.n25 ob.0 0.318714
R2541 ob.0.n24 ob.0 0.350717
R2542 ob.0.t29 ob.0.n24 44.1558
R2543 ob.0.t30 ob.0.n24 44.555
R2544 ob.0 ob.0.n25 3.35621
R2545 ob.0.t26 ob.0 3.57
R2546 ob.0.n26 ob.0 0.0953214
R2547 ob.0 ob.0.n18 1.23157
R2548 ob.0.n18 ob.0.n20 0.617643
R2549 ob.0.n20 ob.0 0.309071
R2550 ob.0 ob.0.n22 0.309071
R2551 ob.0 ob.0.n22 9.61764
R2552 ob.0 ob.0.n23 0.792457
R2553 ob.0.t1 ob.0.n23 0.362889
R2554 ob.0.n23 ob.0.t2 0.362889
R2555 ob.0 ob.0.n22 9.0005
R2556 ob.0 ob.0.n21 0.792457
R2557 ob.0.t4 ob.0.n21 0.362889
R2558 ob.0.n21 ob.0.t5 0.362889
R2559 ob.0 ob.0.n20 9.0005
R2560 ob.0 ob.0.n19 0.792457
R2561 ob.0.t7 ob.0.n19 0.362889
R2562 ob.0.n19 ob.0.t3 0.362889
R2563 ob.0 ob.0.n18 9.0005
R2564 ob.0 ob.0.n17 0.792457
R2565 ob.0.t0 ob.0.n17 0.362889
R2566 ob.0.n17 ob.0.t6 0.362889
R2567 ob.0.n27 ob.0.n1 1.27336
R2568 ob.0.n1 ob.0.n3 1.27336
R2569 ob.0.n3 ob.0.n5 1.27336
R2570 ob.0.n5 ob.0.n7 1.27336
R2571 ob.0 ob.0.n7 1.27336
R2572 ob.0.n10 ob.0 1.27336
R2573 ob.0.n12 ob.0.n10 1.27336
R2574 ob.0.n14 ob.0.n12 1.27336
R2575 ob.0.n16 ob.0.n14 1.27336
R2576 ob.0 ob.0.n16 10.2734
R2577 ob.0 ob.0.t14 1.19252
R2578 ob.0 ob.0.n16 9.0005
R2579 ob.0 ob.0.n15 0.847674
R2580 ob.0.t15 ob.0.n15 0.345342
R2581 ob.0.n15 ob.0.t16 0.345342
R2582 ob.0 ob.0.n14 9.0005
R2583 ob.0 ob.0.n13 0.847674
R2584 ob.0.t17 ob.0.n13 0.345342
R2585 ob.0.n13 ob.0.t18 0.345342
R2586 ob.0 ob.0.n12 9.0005
R2587 ob.0 ob.0.n11 0.847674
R2588 ob.0.t19 ob.0.n11 0.345342
R2589 ob.0.n11 ob.0.t11 0.345342
R2590 ob.0 ob.0.n10 9.0005
R2591 ob.0 ob.0.n9 0.847674
R2592 ob.0.t24 ob.0.n9 0.345342
R2593 ob.0.n9 ob.0.t13 0.345342
R2594 ob.0 ob.0.n8 0.847674
R2595 ob.0.t25 ob.0.n8 0.345342
R2596 ob.0.n8 ob.0.t27 0.345342
R2597 ob.0 ob.0.n7 9.0005
R2598 ob.0 ob.0.n6 0.847674
R2599 ob.0.t9 ob.0.n6 0.345342
R2600 ob.0.n6 ob.0.t28 0.345342
R2601 ob.0 ob.0.n5 9.0005
R2602 ob.0 ob.0.n4 0.847674
R2603 ob.0.t12 ob.0.n4 0.345342
R2604 ob.0.n4 ob.0.t10 0.345342
R2605 ob.0 ob.0.n3 9.0005
R2606 ob.0 ob.0.n2 0.847674
R2607 ob.0.t8 ob.0.n2 0.345342
R2608 ob.0.n2 ob.0.t20 0.345342
R2609 ob.0 ob.0.n1 9.0005
R2610 ob.0 ob.0.n0 0.847674
R2611 ob.0.t21 ob.0.n0 0.345342
R2612 ob.0.n0 ob.0.t22 0.345342
R2613 oa.0.n0 oa.0.t25 0.345342
R2614 oa.0.n0 oa.0.t26 0.345342
R2615 oa.0 oa.0.n0 0.847674
R2616 oa.0 oa.0.n2 10.2734
R2617 oa.0.n2 oa.0.n4 1.27336
R2618 oa.0.n4 oa.0.n6 1.27336
R2619 oa.0.n6 oa.0.n8 1.27336
R2620 oa.0 oa.0.n8 0.636929
R2621 oa.0.n10 oa.0 0.636929
R2622 oa.0.n12 oa.0.n10 1.27336
R2623 oa.0.n14 oa.0.n12 1.27336
R2624 oa.0.n16 oa.0.n14 1.27336
R2625 oa.0.n18 oa.0.n16 1.27336
R2626 oa.0 oa.0.n18 0.894071
R2627 oa.0 oa.0.n19 0.113
R2628 oa.0.n19 oa.0 2.34371
R2629 oa.0.n23 oa.0 1.3955
R2630 oa.0.n25 oa.0.n23 0.617643
R2631 oa.0 oa.0.n25 0.309071
R2632 oa.0.n27 oa.0 0.309071
R2633 oa.0 oa.0.n27 9.61764
R2634 oa.0 oa.0.n28 0.792457
R2635 oa.0.t0 oa.0.n28 0.362889
R2636 oa.0.n28 oa.0.t8 0.362889
R2637 oa.0 oa.0.n27 9.0005
R2638 oa.0 oa.0.n26 0.792457
R2639 oa.0.t5 oa.0.n26 0.362889
R2640 oa.0.n26 oa.0.t6 0.362889
R2641 oa.0 oa.0.n25 9.0005
R2642 oa.0 oa.0.n24 0.792457
R2643 oa.0.t7 oa.0.n24 0.362889
R2644 oa.0.n24 oa.0.t2 0.362889
R2645 oa.0 oa.0.n23 9.0005
R2646 oa.0 oa.0.n22 0.792457
R2647 oa.0.t3 oa.0.n22 0.362889
R2648 oa.0.n22 oa.0.t4 0.362889
R2649 oa.0.n19 oa.0 4.59371
R2650 oa.0.n21 oa.0 5.60621
R2651 oa.0.n21 oa.0 2.79371
R2652 oa.0.t27 oa.0 3.57
R2653 oa.0 oa.0.n21 0.431214
R2654 oa.0 oa.0.n20 0.350717
R2655 oa.0.t29 oa.0.n20 44.555
R2656 oa.0.t30 oa.0.n20 44.1558
R2657 oa.0 oa.0.n18 9.0005
R2658 oa.0.n17 oa.0 0.847674
R2659 oa.0.t17 oa.0.n17 0.345342
R2660 oa.0.n17 oa.0.t18 0.345342
R2661 oa.0 oa.0.n16 9.0005
R2662 oa.0.n15 oa.0 0.847674
R2663 oa.0.t19 oa.0.n15 0.345342
R2664 oa.0.n15 oa.0.t20 0.345342
R2665 oa.0 oa.0.n14 9.0005
R2666 oa.0.n13 oa.0 0.847674
R2667 oa.0.t21 oa.0.n13 0.345342
R2668 oa.0.n13 oa.0.t22 0.345342
R2669 oa.0 oa.0.n12 9.0005
R2670 oa.0.n11 oa.0 0.847674
R2671 oa.0.t9 oa.0.n11 0.345342
R2672 oa.0.n11 oa.0.t28 0.345342
R2673 oa.0 oa.0.n10 9.0005
R2674 oa.0.n9 oa.0 0.847674
R2675 oa.0.t1 oa.0.n9 0.345342
R2676 oa.0.n9 oa.0.t16 0.345342
R2677 oa.0 oa.0.n8 9.0005
R2678 oa.0.n7 oa.0 0.847674
R2679 oa.0.t15 oa.0.n7 0.345342
R2680 oa.0.n7 oa.0.t12 0.345342
R2681 oa.0 oa.0.n6 9.0005
R2682 oa.0.n5 oa.0 0.847674
R2683 oa.0.t13 oa.0.n5 0.345342
R2684 oa.0.n5 oa.0.t10 0.345342
R2685 oa.0 oa.0.n4 9.0005
R2686 oa.0.n3 oa.0 0.847674
R2687 oa.0.t11 oa.0.n3 0.345342
R2688 oa.0.n3 oa.0.t14 0.345342
R2689 oa.0 oa.0.n2 9.0005
R2690 oa.0.n1 oa.0 0.847674
R2691 oa.0.t23 oa.0.n1 0.345342
R2692 oa.0.n1 oa.0.t24 0.345342
R2693 fa.0.t14 fa.0.n0 0.6557
R2694 fa.0.n0 fa.0.t2 0.6557
R2695 fa.0 fa.0.n0 1.47767
R2696 fa.0 fa.0.n2 10.9162
R2697 fa.0.n2 fa.0.n4 1.91621
R2698 fa.0 fa.0.n4 1.91621
R2699 fa.0.n7 fa.0 1.91621
R2700 fa.0.n9 fa.0.n7 1.91621
R2701 fa.0.n11 fa.0.n9 1.91621
R2702 fa.0 fa.0.n11 1.47586
R2703 fa.0.n62 fa.0 7.40621
R2704 fa.0 fa.0.n62 1.30871
R2705 fa.0 fa.0.n56 1.31193
R2706 fa.0.n56 fa.0.n58 0.617643
R2707 fa.0.n58 fa.0 0.309071
R2708 fa.0 fa.0.n60 0.309071
R2709 fa.0 fa.0.n60 9.61764
R2710 fa.0.n61 fa.0 0.792457
R2711 fa.0.t21 fa.0.n61 0.362889
R2712 fa.0.n61 fa.0.t0 0.362889
R2713 fa.0 fa.0.n60 9.0005
R2714 fa.0.n59 fa.0 0.792457
R2715 fa.0.t19 fa.0.n59 0.362889
R2716 fa.0.n59 fa.0.t20 0.362889
R2717 fa.0 fa.0.n58 9.0005
R2718 fa.0.n57 fa.0 0.792457
R2719 fa.0.t17 fa.0.n57 0.362889
R2720 fa.0.n57 fa.0.t18 0.362889
R2721 fa.0 fa.0.n56 9.0005
R2722 fa.0.n55 fa.0 0.792457
R2723 fa.0.t15 fa.0.n55 0.362889
R2724 fa.0.n55 fa.0.t16 0.362889
R2725 fa.0.n62 fa.0 0.768714
R2726 fa.0 fa.0.n13 1.12229
R2727 fa.0.n13 fa.0.n15 1.14479
R2728 fa.0.n15 fa.0.n17 1.14479
R2729 fa.0.n17 fa.0.n19 1.14479
R2730 fa.0.n19 fa.0.n21 1.14479
R2731 fa.0.n21 fa.0.n23 1.14479
R2732 fa.0.n23 fa.0.n25 1.14479
R2733 fa.0.n25 fa.0.n27 1.14479
R2734 fa.0.n27 fa.0.n29 1.14479
R2735 fa.0.n29 fa.0.n31 1.14479
R2736 fa.0.n31 fa.0.n33 1.14479
R2737 fa.0.n33 fa.0 0.572643
R2738 fa.0 fa.0.n35 0.572643
R2739 fa.0.n35 fa.0.n37 1.14479
R2740 fa.0.n37 fa.0.n39 1.14479
R2741 fa.0.n39 fa.0.n41 1.14479
R2742 fa.0.n41 fa.0.n43 1.14479
R2743 fa.0.n43 fa.0.n45 1.14479
R2744 fa.0.n45 fa.0.n47 1.14479
R2745 fa.0.n47 fa.0.n49 1.14479
R2746 fa.0.n49 fa.0.n51 1.14479
R2747 fa.0.n51 fa.0.n53 1.14479
R2748 fa.0 fa.0.n53 10.1448
R2749 fa.0.n54 fa.0 0.737674
R2750 fa.0.t55 fa.0.n54 0.379667
R2751 fa.0.n54 fa.0.t56 0.379667
R2752 fa.0 fa.0.n53 9.0005
R2753 fa.0.n52 fa.0 0.737674
R2754 fa.0.t53 fa.0.n52 0.379667
R2755 fa.0.n52 fa.0.t54 0.379667
R2756 fa.0 fa.0.n51 9.0005
R2757 fa.0.n50 fa.0 0.737674
R2758 fa.0.t51 fa.0.n50 0.379667
R2759 fa.0.n50 fa.0.t52 0.379667
R2760 fa.0 fa.0.n49 9.0005
R2761 fa.0.n48 fa.0 0.737674
R2762 fa.0.t49 fa.0.n48 0.379667
R2763 fa.0.n48 fa.0.t50 0.379667
R2764 fa.0 fa.0.n47 9.0005
R2765 fa.0.n46 fa.0 0.737674
R2766 fa.0.t47 fa.0.n46 0.379667
R2767 fa.0.n46 fa.0.t48 0.379667
R2768 fa.0 fa.0.n45 9.0005
R2769 fa.0.n44 fa.0 0.737674
R2770 fa.0.t45 fa.0.n44 0.379667
R2771 fa.0.n44 fa.0.t46 0.379667
R2772 fa.0 fa.0.n43 9.0005
R2773 fa.0.n42 fa.0 0.737674
R2774 fa.0.t34 fa.0.n42 0.379667
R2775 fa.0.n42 fa.0.t29 0.379667
R2776 fa.0 fa.0.n41 9.0005
R2777 fa.0.n40 fa.0 0.737674
R2778 fa.0.t23 fa.0.n40 0.379667
R2779 fa.0.n40 fa.0.t33 0.379667
R2780 fa.0 fa.0.n39 9.0005
R2781 fa.0.n38 fa.0 0.737674
R2782 fa.0.t61 fa.0.n38 0.379667
R2783 fa.0.n38 fa.0.t24 0.379667
R2784 fa.0 fa.0.n37 9.0005
R2785 fa.0.n36 fa.0 0.737674
R2786 fa.0.t28 fa.0.n36 0.379667
R2787 fa.0.n36 fa.0.t25 0.379667
R2788 fa.0 fa.0.n35 9.0005
R2789 fa.0.n34 fa.0 0.737674
R2790 fa.0.t58 fa.0.n34 0.379667
R2791 fa.0.n34 fa.0.t63 0.379667
R2792 fa.0 fa.0.n33 9.0005
R2793 fa.0.n32 fa.0 0.737674
R2794 fa.0.t60 fa.0.n32 0.379667
R2795 fa.0.n32 fa.0.t65 0.379667
R2796 fa.0 fa.0.n31 9.0005
R2797 fa.0.n30 fa.0 0.737674
R2798 fa.0.t64 fa.0.n30 0.379667
R2799 fa.0.n30 fa.0.t57 0.379667
R2800 fa.0 fa.0.n29 9.0005
R2801 fa.0.n28 fa.0 0.737674
R2802 fa.0.t26 fa.0.n28 0.379667
R2803 fa.0.n28 fa.0.t32 0.379667
R2804 fa.0 fa.0.n27 9.0005
R2805 fa.0.n26 fa.0 0.737674
R2806 fa.0.t27 fa.0.n26 0.379667
R2807 fa.0.n26 fa.0.t31 0.379667
R2808 fa.0 fa.0.n25 9.0005
R2809 fa.0.n24 fa.0 0.737674
R2810 fa.0.t62 fa.0.n24 0.379667
R2811 fa.0.n24 fa.0.t22 0.379667
R2812 fa.0 fa.0.n23 9.0005
R2813 fa.0.n22 fa.0 0.737674
R2814 fa.0.t59 fa.0.n22 0.379667
R2815 fa.0.n22 fa.0.t30 0.379667
R2816 fa.0 fa.0.n21 9.0005
R2817 fa.0.n20 fa.0 0.737674
R2818 fa.0.t43 fa.0.n20 0.379667
R2819 fa.0.n20 fa.0.t44 0.379667
R2820 fa.0 fa.0.n19 9.0005
R2821 fa.0.n18 fa.0 0.737674
R2822 fa.0.t41 fa.0.n18 0.379667
R2823 fa.0.n18 fa.0.t42 0.379667
R2824 fa.0 fa.0.n17 9.0005
R2825 fa.0.n16 fa.0 0.737674
R2826 fa.0.t39 fa.0.n16 0.379667
R2827 fa.0.n16 fa.0.t40 0.379667
R2828 fa.0 fa.0.n15 9.0005
R2829 fa.0.n14 fa.0 0.737674
R2830 fa.0.t37 fa.0.n14 0.379667
R2831 fa.0.n14 fa.0.t38 0.379667
R2832 fa.0 fa.0.n13 9.0005
R2833 fa.0.n12 fa.0 0.737674
R2834 fa.0.t35 fa.0.n12 0.379667
R2835 fa.0.n12 fa.0.t36 0.379667
R2836 fa.0 fa.0.n11 9.0005
R2837 fa.0 fa.0.n10 1.47767
R2838 fa.0.t1 fa.0.n10 0.6557
R2839 fa.0.n10 fa.0.t3 0.6557
R2840 fa.0 fa.0.n9 9.0005
R2841 fa.0 fa.0.n8 1.47767
R2842 fa.0.t4 fa.0.n8 0.6557
R2843 fa.0.n8 fa.0.t5 0.6557
R2844 fa.0 fa.0.n7 9.0005
R2845 fa.0 fa.0.n6 1.47767
R2846 fa.0.t6 fa.0.n6 0.6557
R2847 fa.0.n6 fa.0.t7 0.6557
R2848 fa.0 fa.0.n5 1.47767
R2849 fa.0.t8 fa.0.n5 0.6557
R2850 fa.0.n5 fa.0.t9 0.6557
R2851 fa.0 fa.0.n4 9.0005
R2852 fa.0 fa.0.n3 1.47767
R2853 fa.0.t10 fa.0.n3 0.6557
R2854 fa.0.n3 fa.0.t11 0.6557
R2855 fa.0 fa.0.n2 9.0005
R2856 fa.0 fa.0.n1 1.47767
R2857 fa.0.t12 fa.0.n1 0.6557
R2858 fa.0.n1 fa.0.t13 0.6557
R2859 fb.0.n0 fb.0.t11 0.6557
R2860 fb.0.n0 fb.0.t12 0.6557
R2861 fb.0 fb.0.n0 1.47767
R2862 fb.0 fb.0.n60 9.0005
R2863 fb.0.n60 fb.0 1.96443
R2864 fb.0 fb.0.n59 7.40621
R2865 fb.0 fb.0.n59 1.30871
R2866 fb.0.n53 fb.0 1.148
R2867 fb.0.n55 fb.0.n53 0.617643
R2868 fb.0 fb.0.n55 0.309071
R2869 fb.0.n57 fb.0 0.309071
R2870 fb.0 fb.0.n57 9.61764
R2871 fb.0.n58 fb.0 0.792457
R2872 fb.0.t13 fb.0.n58 0.362889
R2873 fb.0.n58 fb.0.t14 0.362889
R2874 fb.0 fb.0.n57 9.0005
R2875 fb.0.n56 fb.0 0.792457
R2876 fb.0.t15 fb.0.n56 0.362889
R2877 fb.0.n56 fb.0.t16 0.362889
R2878 fb.0 fb.0.n55 9.0005
R2879 fb.0.n54 fb.0 0.792457
R2880 fb.0.t17 fb.0.n54 0.362889
R2881 fb.0.n54 fb.0.t18 0.362889
R2882 fb.0 fb.0.n53 9.0005
R2883 fb.0.n52 fb.0 0.792457
R2884 fb.0.t19 fb.0.n52 0.362889
R2885 fb.0.n52 fb.0.t0 0.362889
R2886 fb.0.n59 fb.0 0.656214
R2887 fb.0.n10 fb.0 0.826571
R2888 fb.0.n12 fb.0.n10 1.14479
R2889 fb.0.n14 fb.0.n12 1.14479
R2890 fb.0.n16 fb.0.n14 1.14479
R2891 fb.0.n18 fb.0.n16 1.14479
R2892 fb.0.n20 fb.0.n18 1.14479
R2893 fb.0.n22 fb.0.n20 1.14479
R2894 fb.0.n24 fb.0.n22 1.14479
R2895 fb.0.n26 fb.0.n24 1.14479
R2896 fb.0.n28 fb.0.n26 1.14479
R2897 fb.0.n30 fb.0.n28 1.14479
R2898 fb.0 fb.0.n30 1.14479
R2899 fb.0.n33 fb.0 1.14479
R2900 fb.0.n35 fb.0.n33 1.14479
R2901 fb.0.n37 fb.0.n35 1.14479
R2902 fb.0.n39 fb.0.n37 1.14479
R2903 fb.0.n41 fb.0.n39 1.14479
R2904 fb.0.n43 fb.0.n41 1.14479
R2905 fb.0.n45 fb.0.n43 1.14479
R2906 fb.0.n47 fb.0.n45 1.14479
R2907 fb.0.n49 fb.0.n47 1.14479
R2908 fb.0.n51 fb.0.n49 1.14479
R2909 fb.0 fb.0.n51 10.1448
R2910 fb.0 fb.0.t39 1.11684
R2911 fb.0 fb.0.n51 9.0005
R2912 fb.0 fb.0.n50 0.737674
R2913 fb.0.t40 fb.0.n50 0.379667
R2914 fb.0.n50 fb.0.t41 0.379667
R2915 fb.0 fb.0.n49 9.0005
R2916 fb.0 fb.0.n48 0.737674
R2917 fb.0.t42 fb.0.n48 0.379667
R2918 fb.0.n48 fb.0.t43 0.379667
R2919 fb.0 fb.0.n47 9.0005
R2920 fb.0 fb.0.n46 0.737674
R2921 fb.0.t44 fb.0.n46 0.379667
R2922 fb.0.n46 fb.0.t45 0.379667
R2923 fb.0 fb.0.n45 9.0005
R2924 fb.0 fb.0.n44 0.737674
R2925 fb.0.t46 fb.0.n44 0.379667
R2926 fb.0.n44 fb.0.t47 0.379667
R2927 fb.0 fb.0.n43 9.0005
R2928 fb.0 fb.0.n42 0.737674
R2929 fb.0.t48 fb.0.n42 0.379667
R2930 fb.0.n42 fb.0.t62 0.379667
R2931 fb.0 fb.0.n41 9.0005
R2932 fb.0 fb.0.n40 0.737674
R2933 fb.0.t37 fb.0.n40 0.379667
R2934 fb.0.n40 fb.0.t36 0.379667
R2935 fb.0 fb.0.n39 9.0005
R2936 fb.0 fb.0.n38 0.737674
R2937 fb.0.t35 fb.0.n38 0.379667
R2938 fb.0.n38 fb.0.t32 0.379667
R2939 fb.0 fb.0.n37 9.0005
R2940 fb.0 fb.0.n36 0.737674
R2941 fb.0.t31 fb.0.n36 0.379667
R2942 fb.0.n36 fb.0.t30 0.379667
R2943 fb.0 fb.0.n35 9.0005
R2944 fb.0 fb.0.n34 0.737674
R2945 fb.0.t22 fb.0.n34 0.379667
R2946 fb.0.n34 fb.0.t21 0.379667
R2947 fb.0 fb.0.n33 9.0005
R2948 fb.0 fb.0.n32 0.737674
R2949 fb.0.t20 fb.0.n32 0.379667
R2950 fb.0.n32 fb.0.t25 0.379667
R2951 fb.0 fb.0.n31 0.737674
R2952 fb.0.t24 fb.0.n31 0.379667
R2953 fb.0.n31 fb.0.t23 0.379667
R2954 fb.0 fb.0.n30 9.0005
R2955 fb.0 fb.0.n29 0.737674
R2956 fb.0.t27 fb.0.n29 0.379667
R2957 fb.0.n29 fb.0.t38 0.379667
R2958 fb.0 fb.0.n28 9.0005
R2959 fb.0 fb.0.n27 0.737674
R2960 fb.0.t26 fb.0.n27 0.379667
R2961 fb.0.n27 fb.0.t29 0.379667
R2962 fb.0 fb.0.n26 9.0005
R2963 fb.0 fb.0.n25 0.737674
R2964 fb.0.t61 fb.0.n25 0.379667
R2965 fb.0.n25 fb.0.t28 0.379667
R2966 fb.0 fb.0.n24 9.0005
R2967 fb.0 fb.0.n23 0.737674
R2968 fb.0.t33 fb.0.n23 0.379667
R2969 fb.0.n23 fb.0.t63 0.379667
R2970 fb.0 fb.0.n22 9.0005
R2971 fb.0 fb.0.n21 0.737674
R2972 fb.0.t34 fb.0.n21 0.379667
R2973 fb.0.n21 fb.0.t49 0.379667
R2974 fb.0 fb.0.n20 9.0005
R2975 fb.0 fb.0.n19 0.737674
R2976 fb.0.t50 fb.0.n19 0.379667
R2977 fb.0.n19 fb.0.t51 0.379667
R2978 fb.0 fb.0.n18 9.0005
R2979 fb.0 fb.0.n17 0.737674
R2980 fb.0.t52 fb.0.n17 0.379667
R2981 fb.0.n17 fb.0.t53 0.379667
R2982 fb.0 fb.0.n16 9.0005
R2983 fb.0 fb.0.n15 0.737674
R2984 fb.0.t54 fb.0.n15 0.379667
R2985 fb.0.n15 fb.0.t55 0.379667
R2986 fb.0 fb.0.n14 9.0005
R2987 fb.0 fb.0.n13 0.737674
R2988 fb.0.t56 fb.0.n13 0.379667
R2989 fb.0.n13 fb.0.t57 0.379667
R2990 fb.0 fb.0.n12 9.0005
R2991 fb.0 fb.0.n11 0.737674
R2992 fb.0.t58 fb.0.n11 0.379667
R2993 fb.0.n11 fb.0.t59 0.379667
R2994 fb.0 fb.0.n10 9.0005
R2995 fb.0.t60 fb.0 1.11684
R2996 fb.0.n60 fb.0.n2 1.91621
R2997 fb.0.n2 fb.0.n4 1.91621
R2998 fb.0 fb.0.n4 0.958357
R2999 fb.0.n6 fb.0 0.958357
R3000 fb.0.n8 fb.0.n6 1.91621
R3001 fb.0 fb.0.n8 10.9162
R3002 fb.0.n9 fb.0 1.47767
R3003 fb.0.t1 fb.0.n9 0.6557
R3004 fb.0.n9 fb.0.t2 0.6557
R3005 fb.0 fb.0.n8 9.0005
R3006 fb.0.n7 fb.0 1.47767
R3007 fb.0.t3 fb.0.n7 0.6557
R3008 fb.0.n7 fb.0.t4 0.6557
R3009 fb.0 fb.0.n6 9.0005
R3010 fb.0.n5 fb.0 1.47767
R3011 fb.0.t5 fb.0.n5 0.6557
R3012 fb.0.n5 fb.0.t6 0.6557
R3013 fb.0 fb.0.n4 9.0005
R3014 fb.0.n3 fb.0 1.47767
R3015 fb.0.t7 fb.0.n3 0.6557
R3016 fb.0.n3 fb.0.t8 0.6557
R3017 fb.0 fb.0.n2 9.0005
R3018 fb.0.n1 fb.0 1.47767
R3019 fb.0.t9 fb.0.n1 0.6557
R3020 fb.0.n1 fb.0.t10 0.6557
R3021 gn.0.t0 gn.0 1.2823
R3022 gn.0.n5 gn.0.n2 9.0005
R3023 gn.0 gn.0.n0 0.985824
R3024 gn.0.n1 gn.0.n0 1.21457
R3025 gn.0.n1 gn.0 0.08675
R3026 gn.0 gn.0.n2 0.21275
R3027 gn.0.n3 gn.0.n2 0.447521
R3028 gn.0 gn.0.n3 10.4681
R3029 gn.0.n36 gn.0 4.58118
R3030 gn.0.n36 gn.0 0.075987
R3031 gn.0.n27 gn.0.n28 0.39963
R3032 gn.0.n28 gn.0.n29 1.19789
R3033 gn.0.n29 gn.0.n30 0.39963
R3034 gn.0.n30 gn.0.n31 1.19789
R3035 gn.0.n31 gn.0.n32 0.39963
R3036 gn.0.n32 gn.0 0.95137
R3037 gn.0 gn.0.n33 0.247022
R3038 gn.0.n33 gn.0.n34 0.39963
R3039 gn.0.n34 gn.0.n35 1.19789
R3040 gn.0.n35 gn.0 12.8294
R3041 gn.0.t1 gn.0.n35 46.9298
R3042 gn.0.t2 gn.0.n34 46.9298
R3043 gn.0.t3 gn.0.n33 46.9298
R3044 gn.0.t4 gn.0.n32 46.9298
R3045 gn.0.t5 gn.0.n31 46.9298
R3046 gn.0.t6 gn.0.n30 46.9298
R3047 gn.0.t7 gn.0.n29 46.9298
R3048 gn.0.t8 gn.0.n28 46.9298
R3049 gn.0.t9 gn.0.n27 46.9298
R3050 gn.0.t10 gn.0.n27 48.1272
R3051 gn.0 gn.0.n36 0.264023
R3052 gn.0.n6 gn.0.n7 0.3605
R3053 gn.0.n7 gn.0.n8 1.0805
R3054 gn.0.n8 gn.0.n9 0.3605
R3055 gn.0.n9 gn.0.n10 1.0805
R3056 gn.0.n10 gn.0.n11 0.3605
R3057 gn.0.n11 gn.0.n12 1.0805
R3058 gn.0.n12 gn.0.n13 0.3605
R3059 gn.0.n13 gn.0.n14 1.0805
R3060 gn.0.n14 gn.0.n15 0.3605
R3061 gn.0.n15 gn.0.n16 1.0805
R3062 gn.0.n16 gn.0.n17 0.3605
R3063 gn.0.n17 gn.0.n18 1.0805
R3064 gn.0.n18 gn.0.n19 0.3605
R3065 gn.0.n19 gn.0.n20 1.0805
R3066 gn.0.n20 gn.0.n21 0.3605
R3067 gn.0.n21 gn.0 0.941587
R3068 gn.0 gn.0.n22 0.139413
R3069 gn.0.n22 gn.0.n23 0.3605
R3070 gn.0.n23 gn.0.n24 1.0805
R3071 gn.0.n24 gn.0.n25 0.3605
R3072 gn.0.n25 gn.0.n26 1.0805
R3073 gn.0.n26 gn.0 18.3781
R3074 gn.0.t11 gn.0.n26 57.0825
R3075 gn.0.t12 gn.0.n25 57.0825
R3076 gn.0.t13 gn.0.n24 57.0825
R3077 gn.0.t14 gn.0.n23 57.0825
R3078 gn.0.t15 gn.0.n22 57.0825
R3079 gn.0.t16 gn.0.n21 57.0825
R3080 gn.0.t17 gn.0.n20 57.0825
R3081 gn.0.t18 gn.0.n19 57.0825
R3082 gn.0.t19 gn.0.n18 57.0825
R3083 gn.0.t20 gn.0.n17 57.0825
R3084 gn.0.t21 gn.0.n16 57.0825
R3085 gn.0.t22 gn.0.n15 57.0825
R3086 gn.0.t23 gn.0.n14 57.0825
R3087 gn.0.t24 gn.0.n13 57.0825
R3088 gn.0.t25 gn.0.n12 57.0825
R3089 gn.0.t26 gn.0.n11 57.0825
R3090 gn.0.t27 gn.0.n10 57.0825
R3091 gn.0.t28 gn.0.n9 57.0825
R3092 gn.0.t29 gn.0.n8 57.0825
R3093 gn.0.t30 gn.0.n7 57.0825
R3094 gn.0.t31 gn.0.n6 57.0825
R3095 gn.0.t32 gn.0.n6 58.1625
R3096 gn.0.n4 gn.0.t33 0.033
R3097 gn.0.n5 gn.0.n1 9.03728
R3098 gn.0.n4 gn.0.n5 0.0189805
R3099 gn.0.n3 gn.0.n4 4.45525
R3100 gn.0.n0 gn.0.t34 2.12852
R3101 gp.0.t0 gp.0 1.2823
R3102 gp.0.n3 gp.0.n0 9.0005
R3103 gp.0 gp.0.n2 10.4681
R3104 gp.0.n2 gp.0.n0 0.447521
R3105 gp.0.n0 gp.0 0.21275
R3106 gp.0 gp.0.n4 0.08675
R3107 gp.0.n4 gp.0.n5 1.21457
R3108 gp.0.n5 gp.0 0.985824
R3109 gp.0.n6 gp.0 1.33121
R3110 gp.0 gp.0.n6 0.177286
R3111 gp.0 gp.0.n36 17.2981
R3112 gp.0.n36 gp.0.n35 0.3605
R3113 gp.0.n35 gp.0.n34 1.0805
R3114 gp.0.n34 gp.0.n33 0.3605
R3115 gp.0.n33 gp.0.n32 1.0805
R3116 gp.0.n32 gp.0 0.319413
R3117 gp.0 gp.0.n31 0.041587
R3118 gp.0.n31 gp.0.n30 1.0805
R3119 gp.0.n30 gp.0.n29 0.3605
R3120 gp.0.n29 gp.0.n28 1.0805
R3121 gp.0.n28 gp.0.n27 0.3605
R3122 gp.0.n27 gp.0.n26 1.0805
R3123 gp.0.n26 gp.0.n25 0.3605
R3124 gp.0.n25 gp.0.n24 1.0805
R3125 gp.0.n24 gp.0.n23 0.3605
R3126 gp.0.n23 gp.0.n22 1.0805
R3127 gp.0.n22 gp.0.n21 0.3605
R3128 gp.0.n21 gp.0.n20 1.0805
R3129 gp.0.n20 gp.0.n19 0.3605
R3130 gp.0.n19 gp.0.n18 1.0805
R3131 gp.0.n18 gp.0.n17 0.3605
R3132 gp.0.n17 gp.0.n16 1.0805
R3133 gp.0.n36 gp.0.t32 57.0825
R3134 gp.0.n35 gp.0.t31 57.0825
R3135 gp.0.n34 gp.0.t30 57.0825
R3136 gp.0.n33 gp.0.t29 57.0825
R3137 gp.0.n32 gp.0.t28 57.0825
R3138 gp.0.n31 gp.0.t27 57.0825
R3139 gp.0.n30 gp.0.t26 57.0825
R3140 gp.0.n29 gp.0.t25 57.0825
R3141 gp.0.n28 gp.0.t24 57.0825
R3142 gp.0.n27 gp.0.t23 57.0825
R3143 gp.0.n26 gp.0.t22 57.0825
R3144 gp.0.n25 gp.0.t21 57.0825
R3145 gp.0.n24 gp.0.t20 57.0825
R3146 gp.0.n23 gp.0.t19 57.0825
R3147 gp.0.n22 gp.0.t18 57.0825
R3148 gp.0.n21 gp.0.t17 57.0825
R3149 gp.0.n20 gp.0.t16 57.0825
R3150 gp.0.n19 gp.0.t15 57.0825
R3151 gp.0.n18 gp.0.t14 57.0825
R3152 gp.0.n17 gp.0.t13 57.0825
R3153 gp.0.n16 gp.0.t12 57.0825
R3154 gp.0.n16 gp.0.t11 57.4425
R3155 gp.0 gp.0.n6 4.59371
R3156 gp.0 gp.0.n15 14.8251
R3157 gp.0.n15 gp.0.n14 0.39963
R3158 gp.0.n14 gp.0 0.0474565
R3159 gp.0 gp.0.n13 1.15093
R3160 gp.0.n13 gp.0.n12 0.39963
R3161 gp.0.n12 gp.0.n11 1.19789
R3162 gp.0.n11 gp.0.n10 0.39963
R3163 gp.0.n10 gp.0.n9 1.19789
R3164 gp.0.n9 gp.0.n8 0.39963
R3165 gp.0.n8 gp.0.n7 1.19789
R3166 gp.0.n15 gp.0.t10 46.9298
R3167 gp.0.n14 gp.0.t9 46.9298
R3168 gp.0.n13 gp.0.t8 46.9298
R3169 gp.0.n12 gp.0.t7 46.9298
R3170 gp.0.n11 gp.0.t6 46.9298
R3171 gp.0.n10 gp.0.t5 46.9298
R3172 gp.0.n9 gp.0.t4 46.9298
R3173 gp.0.n8 gp.0.t3 46.9298
R3174 gp.0.n7 gp.0.t2 46.9298
R3175 gp.0.n7 gp.0.t1 47.329
R3176 gp.0.n5 gp.0.t33 2.12852
R3177 gp.0.n1 gp.0.t34 0.033
R3178 gp.0.n2 gp.0.n1 4.45525
R3179 gp.0.n1 gp.0.n3 0.0189805
R3180 gp.0.n3 gp.0.n4 9.03728
R3181 tp.0.n0 tp.0.t0 83.3193
C0 oa.0 VBN 0.31902f
C1 VREF tn.0 1.62411f
C2 EN d2b.0 0.31138f
C3 ob.0 fa.0 0
C4 VREF oa.0 2.14744f
C5 nm.0 EN 0.02238f
C6 gp.0 INP 0.14621f
C7 d2b.0 VDD 10.8442f
C8 fb.0 VBN 1.50358f
C9 d2a.0 EN 0.19588f
C10 INN gn.0 0.14621f
C11 VREF VBN 0.90664f
C12 VREF fb.0 2.62815f
C13 gp.0 VDD 4.52291f
C14 fa.0 VB2 1.71129f
C15 d2a.0 VDD 12.736f
C16 tn.0 VDD 0.2078f
C17 sa.0 ob.0 0.00738f
C18 oa.0 VDD 1.56447f
C19 VBN VDD 0.15007f
C20 VREF VDD 0.13393f
C21 rlb_m1.0 sa.0 0
C22 ob.0 VB2 0.58885f
C23 INP VDD 2.26778f
C24 EN VDD 16.9113f
C25 VBP INN 0.03712f
C26 d2b.0 sb.0 0.68313f
C27 d2b.0 d3.0 0.22886f
C28 gn.0 gp.0 2.07546f
C29 nm.0 d3.0 0.01765f
C30 tn.0 gn.0 0.99696f
C31 nm.0 nd.0 0.2193f
C32 gn.0 oa.0 0.30476f
C33 d2a.0 d3.0 0.63055f
C34 i1.0 EN 0.26447f
C35 i1.0 VDD 2.62233f
C36 gn.0 VBN 0.27781f
C37 EN i2.0 0.31277f
C38 fb.0 gn.0 2.60941f
C39 gp.0 fa.0 2.42263f
C40 VREF gn.0 2.83689f
C41 i2.0 VDD 4.28491f
C42 oa.0 fa.0 2.94526f
C43 ts.0 VBN 1.02135f
C44 sa.0 d2b.0 0.20987f
C45 fa.0 VBN 2.18465f
C46 VREF ts.0 0.00271f
C47 fb.0 fa.0 0.8011f
C48 rla_m1.0 sa.0 0.30587f
C49 ob.0 d2b.0 0.16374f
C50 VBP gp.0 0.26446f
C51 EN d3.0 0.4675f
C52 n3a.0 d2b.0 0.17133f
C53 gn.0 VDD 4.52025f
C54 sa.0 d2a.0 1.67001f
C55 VREF fa.0 2.48886f
C56 i1.0 i2.0 0.28557f
C57 ob.0 gp.0 0.36334f
C58 EN nd.0 0.90578f
C59 d3.0 VDD 4.26183f
C60 sa.0 oa.0 0.14911f
C61 tn.0 ob.0 9.55392f
C62 d2a.0 n3a.0 0.2367f
C63 VDD nd.0 2.7235f
C64 ob.0 oa.0 0.59251f
C65 ts.0 VDD 0.60574f
C66 gp.0 VB2 0.04355f
C67 rla_m1.0 rlb_m1.0 0.39394f
C68 ob.0 VBN 0.17663f
C69 fb.0 ob.0 2.91705f
C70 oa.0 VB2 0.59315f
C71 VREF ob.0 2.70252f
C72 i1.0 nd.0 0.21598f
C73 VBP INP 0.03875f
C74 VB2 VBN 0.12676f
C75 fb.0 VB2 2.09462f
C76 VBP VDD 28.4203f
C77 VREF VB2 6.32287f
C78 EN n3a.0 0.00401f
C79 ob.0 VDD 1.95948f
C80 n3a.0 VDD 4.03663f
C81 VB2 VDD 0.12285f
C82 ts.0 sb.0 0.20041f
C83 d3.0 nd.0 0.22426f
C84 OUT EN 0.00492f
C85 gn.0 fa.0 0.66886f
C86 OUT VDD 3.99882f
C87 rla_m1.0 d2b.0 0.00423f
C88 INN VDD 2.56298f
C89 d2a.0 d2b.0 4.0714f
C90 rla_m1.0 d2a.0 0
C91 VBP gn.0 0.26446f
C92 tn.0 gp.0 1.20295f
C93 sa.0 sb.0 1.08061f
C94 oa.0 gp.0 1.26032f
C95 ob.0 gn.0 1.01627f
C96 d2a.0 oa.0 0.16422f
C97 i1.0 OUT 0
C98 ob.0 sb.0 0.20964f
C99 tn.0 oa.0 9.87791f
C100 sa.0 ts.0 0.13628f
C101 n3a.0 d3.0 0.46613f
C102 gp.0 VBN 0.57567f
C103 OUT i2.0 0.50501f
C104 fb.0 gp.0 0.89735f
C105 tn.0 VBN 0.82513f
C106 gn.0 VB2 0.04523f
C107 VREF gp.0 2.30895f
C108 OUT VSS 4.00479f
C109 EN VSS 4.47846f
C110 VBN VSS 42.8176f
C111 VB2 VSS 5.5293f
C112 VREF VSS 4.19237f
C113 INN VSS 1.5011f
C114 VBP VSS 0.726562f
C115 INP VSS 1.78005f
C116 VDD VSS 146.332f
C117 i2.0 VSS 3.15337f
C118 i1.0 VSS 3.20908f
C119 nm.0 VSS 0.189663f
C120 nd.0 VSS 2.84479f
C121 d3.0 VSS 3.53745f
C122 n3a.0 VSS 2.13037f
C123 sb.0 VSS 3.00084f
C124 d2b.0 VSS 2.69886f
C125 rlb_m1.0 VSS 0.983954f
C126 rla_m1.0 VSS 1.34728f
C127 sa.0 VSS 4.65766f
C128 d2a.0 VSS 1.89442f
C129 ts.0 VSS 8.13819f
C130 tn.0 VSS 0.183562f
C131 ob.0 VSS 3.53608f
C132 oa.0 VSS 3.62424f
C133 fa.0 VSS 3.3773f
C134 fb.0 VSS 2.81142f
C135 gn.0 VSS 5.08741f
C136 gp.0 VSS 5.20272f
C137 tp.0.t0 VSS 47.531f
C138 tp.0.n0 VSS 55.369f
C139 gp.0.t0 VSS 0.0581957f
C140 gp.0.n0 VSS 0.0466848f
C141 gp.0.t34 VSS 1.22412f
C142 gp.0.n1 VSS 0.670681f
C143 gp.0.n2 VSS 0.204408f
C144 gp.0.n3 VSS 0.523847f
C145 gp.0.n4 VSS 0.0912726f
C146 gp.0.n5 VSS 0.159378f
C147 gp.0.t33 VSS 2.39442f
C148 gp.0.n6 VSS 0.0225039f
C149 gp.0.t1 VSS 0.0538913f
C150 gp.0.t2 VSS 0.053645f
C151 gp.0.n7 VSS 0.0685508f
C152 gp.0.t3 VSS 0.053645f
C153 gp.0.n8 VSS 0.0393803f
C154 gp.0.t4 VSS 0.053645f
C155 gp.0.n9 VSS 0.0393803f
C156 gp.0.t5 VSS 0.053645f
C157 gp.0.n10 VSS 0.0393803f
C158 gp.0.t6 VSS 0.053645f
C159 gp.0.n11 VSS 0.0393803f
C160 gp.0.t7 VSS 0.053645f
C161 gp.0.n12 VSS 0.0393803f
C162 gp.0.t8 VSS 0.053645f
C163 gp.0.n13 VSS 0.0389571f
C164 gp.0.t9 VSS 0.053645f
C165 gp.0.n14 VSS 0.0290315f
C166 gp.0.t10 VSS 0.053645f
C167 gp.0.n15 VSS 0.11677f
C168 gp.0.t11 VSS 0.0429836f
C169 gp.0.t12 VSS 0.0428257f
C170 gp.0.n16 VSS 0.0592631f
C171 gp.0.t13 VSS 0.0428257f
C172 gp.0.n17 VSS 0.0341633f
C173 gp.0.t14 VSS 0.0428257f
C174 gp.0.n18 VSS 0.0341633f
C175 gp.0.t15 VSS 0.0428257f
C176 gp.0.n19 VSS 0.0341633f
C177 gp.0.t16 VSS 0.0428257f
C178 gp.0.n20 VSS 0.0341633f
C179 gp.0.t17 VSS 0.0428257f
C180 gp.0.n21 VSS 0.0341633f
C181 gp.0.t18 VSS 0.0428257f
C182 gp.0.n22 VSS 0.0341633f
C183 gp.0.t19 VSS 0.0428257f
C184 gp.0.n23 VSS 0.0341633f
C185 gp.0.t20 VSS 0.0428257f
C186 gp.0.n24 VSS 0.0341633f
C187 gp.0.t21 VSS 0.0428257f
C188 gp.0.n25 VSS 0.0341633f
C189 gp.0.t22 VSS 0.0428257f
C190 gp.0.n26 VSS 0.0341633f
C191 gp.0.t23 VSS 0.0428257f
C192 gp.0.n27 VSS 0.0341633f
C193 gp.0.t24 VSS 0.0428257f
C194 gp.0.n28 VSS 0.0341633f
C195 gp.0.t25 VSS 0.0428257f
C196 gp.0.n29 VSS 0.0341633f
C197 gp.0.t26 VSS 0.0428257f
C198 gp.0.n30 VSS 0.0341633f
C199 gp.0.t27 VSS 0.0428257f
C200 gp.0.n31 VSS 0.0312927f
C201 gp.0.t28 VSS 0.0428257f
C202 gp.0.n32 VSS 0.0337938f
C203 gp.0.t29 VSS 0.0428257f
C204 gp.0.n33 VSS 0.0341633f
C205 gp.0.t30 VSS 0.0428257f
C206 gp.0.n34 VSS 0.0341633f
C207 gp.0.t31 VSS 0.0428257f
C208 gp.0.n35 VSS 0.0341633f
C209 gp.0.t32 VSS 0.0428257f
C210 gp.0.n36 VSS 0.141308f
C211 gn.0.t0 VSS 0.0584734f
C212 gn.0.n0 VSS 0.160139f
C213 gn.0.t34 VSS 2.40586f
C214 gn.0.n1 VSS 0.0917077f
C215 gn.0.n2 VSS 0.0469087f
C216 gn.0.n3 VSS 0.205385f
C217 gn.0.t33 VSS 1.22998f
C218 gn.0.n4 VSS 0.673885f
C219 gn.0.n5 VSS 0.526351f
C220 gn.0.t32 VSS 0.0436237f
C221 gn.0.t31 VSS 0.0430299f
C222 gn.0.n6 VSS 0.0656185f
C223 gn.0.t30 VSS 0.0430299f
C224 gn.0.n7 VSS 0.0343251f
C225 gn.0.t29 VSS 0.0430299f
C226 gn.0.n8 VSS 0.0343251f
C227 gn.0.t28 VSS 0.0430299f
C228 gn.0.n9 VSS 0.0343251f
C229 gn.0.t27 VSS 0.0430299f
C230 gn.0.n10 VSS 0.0343251f
C231 gn.0.t26 VSS 0.0430299f
C232 gn.0.n11 VSS 0.0343251f
C233 gn.0.t25 VSS 0.0430299f
C234 gn.0.n12 VSS 0.0343251f
C235 gn.0.t24 VSS 0.0430299f
C236 gn.0.n13 VSS 0.0343251f
C237 gn.0.t23 VSS 0.0430299f
C238 gn.0.n14 VSS 0.0343251f
C239 gn.0.t22 VSS 0.0430299f
C240 gn.0.n15 VSS 0.0343251f
C241 gn.0.t21 VSS 0.0430299f
C242 gn.0.n16 VSS 0.0343251f
C243 gn.0.t20 VSS 0.0430299f
C244 gn.0.n17 VSS 0.0343251f
C245 gn.0.t19 VSS 0.0430299f
C246 gn.0.n18 VSS 0.0343251f
C247 gn.0.t18 VSS 0.0430299f
C248 gn.0.n19 VSS 0.0343251f
C249 gn.0.t17 VSS 0.0430299f
C250 gn.0.n20 VSS 0.0343251f
C251 gn.0.t16 VSS 0.0430299f
C252 gn.0.n21 VSS 0.0330718f
C253 gn.0.t15 VSS 0.0430299f
C254 gn.0.n22 VSS 0.0258204f
C255 gn.0.t14 VSS 0.0430299f
C256 gn.0.n23 VSS 0.0343251f
C257 gn.0.t13 VSS 0.0430299f
C258 gn.0.n24 VSS 0.0343251f
C259 gn.0.t12 VSS 0.0430299f
C260 gn.0.n25 VSS 0.0343251f
C261 gn.0.t11 VSS 0.0430299f
C262 gn.0.n26 VSS 0.160536f
C263 gn.0.t10 VSS 0.0548164f
C264 gn.0.t9 VSS 0.0539006f
C265 gn.0.n27 VSS 0.0754265f
C266 gn.0.t8 VSS 0.0539006f
C267 gn.0.n28 VSS 0.0395667f
C268 gn.0.t7 VSS 0.0539006f
C269 gn.0.n29 VSS 0.0395667f
C270 gn.0.t6 VSS 0.0539006f
C271 gn.0.n30 VSS 0.0395667f
C272 gn.0.t5 VSS 0.0539006f
C273 gn.0.n31 VSS 0.0395667f
C274 gn.0.t4 VSS 0.0539006f
C275 gn.0.n32 VSS 0.0373413f
C276 gn.0.t3 VSS 0.0539006f
C277 gn.0.n33 VSS 0.0309745f
C278 gn.0.t2 VSS 0.0539006f
C279 gn.0.n34 VSS 0.0395667f
C280 gn.0.t1 VSS 0.0539006f
C281 gn.0.n35 VSS 0.0994466f
C282 gn.0.n36 VSS 0.0105332f
C283 fb.0.t12 VSS 0.0149109f
C284 fb.0.n0 VSS 0.0322146f
C285 fb.0.t9 VSS 0.0149109f
C286 fb.0.t10 VSS 0.0149109f
C287 fb.0.n1 VSS 0.0322146f
C288 fb.0.n2 VSS 0.0839818f
C289 fb.0.t7 VSS 0.0149109f
C290 fb.0.t8 VSS 0.0149109f
C291 fb.0.n3 VSS 0.0322146f
C292 fb.0.n4 VSS 0.064796f
C293 fb.0.t5 VSS 0.0149109f
C294 fb.0.t6 VSS 0.0149109f
C295 fb.0.n5 VSS 0.0322146f
C296 fb.0.n6 VSS 0.064796f
C297 fb.0.t3 VSS 0.0149109f
C298 fb.0.t4 VSS 0.0149109f
C299 fb.0.n7 VSS 0.0322146f
C300 fb.0.n8 VSS 0.123144f
C301 fb.0.t1 VSS 0.0149109f
C302 fb.0.t2 VSS 0.0149109f
C303 fb.0.n9 VSS 0.0322146f
C304 fb.0.t60 VSS 0.0792389f
C305 fb.0.n10 VSS 0.0467398f
C306 fb.0.t58 VSS 0.0286304f
C307 fb.0.t59 VSS 0.0286304f
C308 fb.0.n11 VSS 0.065629f
C309 fb.0.n12 VSS 0.0531487f
C310 fb.0.t56 VSS 0.0286304f
C311 fb.0.t57 VSS 0.0286304f
C312 fb.0.n13 VSS 0.065629f
C313 fb.0.n14 VSS 0.0531487f
C314 fb.0.t54 VSS 0.0286304f
C315 fb.0.t55 VSS 0.0286304f
C316 fb.0.n15 VSS 0.065629f
C317 fb.0.n16 VSS 0.0531487f
C318 fb.0.t52 VSS 0.0286304f
C319 fb.0.t53 VSS 0.0286304f
C320 fb.0.n17 VSS 0.065629f
C321 fb.0.n18 VSS 0.0531487f
C322 fb.0.t50 VSS 0.0286304f
C323 fb.0.t51 VSS 0.0286304f
C324 fb.0.n19 VSS 0.065629f
C325 fb.0.n20 VSS 0.0531487f
C326 fb.0.t34 VSS 0.0286304f
C327 fb.0.t49 VSS 0.0286304f
C328 fb.0.n21 VSS 0.065629f
C329 fb.0.n22 VSS 0.0531487f
C330 fb.0.t33 VSS 0.0286304f
C331 fb.0.t63 VSS 0.0286304f
C332 fb.0.n23 VSS 0.065629f
C333 fb.0.n24 VSS 0.0531487f
C334 fb.0.t61 VSS 0.0286304f
C335 fb.0.t28 VSS 0.0286304f
C336 fb.0.n25 VSS 0.065629f
C337 fb.0.n26 VSS 0.0531487f
C338 fb.0.t26 VSS 0.0286304f
C339 fb.0.t29 VSS 0.0286304f
C340 fb.0.n27 VSS 0.065629f
C341 fb.0.n28 VSS 0.0531487f
C342 fb.0.t27 VSS 0.0286304f
C343 fb.0.t38 VSS 0.0286304f
C344 fb.0.n29 VSS 0.065629f
C345 fb.0.n30 VSS 0.0531487f
C346 fb.0.t24 VSS 0.0286304f
C347 fb.0.t23 VSS 0.0286304f
C348 fb.0.n31 VSS 0.065629f
C349 fb.0.t20 VSS 0.0286304f
C350 fb.0.t25 VSS 0.0286304f
C351 fb.0.n32 VSS 0.065629f
C352 fb.0.n33 VSS 0.0531487f
C353 fb.0.t22 VSS 0.0286304f
C354 fb.0.t21 VSS 0.0286304f
C355 fb.0.n34 VSS 0.065629f
C356 fb.0.n35 VSS 0.0531487f
C357 fb.0.t31 VSS 0.0286304f
C358 fb.0.t30 VSS 0.0286304f
C359 fb.0.n36 VSS 0.065629f
C360 fb.0.n37 VSS 0.0531487f
C361 fb.0.t35 VSS 0.0286304f
C362 fb.0.t32 VSS 0.0286304f
C363 fb.0.n38 VSS 0.065629f
C364 fb.0.n39 VSS 0.0531487f
C365 fb.0.t37 VSS 0.0286304f
C366 fb.0.t36 VSS 0.0286304f
C367 fb.0.n40 VSS 0.065629f
C368 fb.0.n41 VSS 0.0531487f
C369 fb.0.t48 VSS 0.0286304f
C370 fb.0.t62 VSS 0.0286304f
C371 fb.0.n42 VSS 0.065629f
C372 fb.0.n43 VSS 0.0531487f
C373 fb.0.t46 VSS 0.0286304f
C374 fb.0.t47 VSS 0.0286304f
C375 fb.0.n44 VSS 0.065629f
C376 fb.0.n45 VSS 0.0531487f
C377 fb.0.t44 VSS 0.0286304f
C378 fb.0.t45 VSS 0.0286304f
C379 fb.0.n46 VSS 0.065629f
C380 fb.0.n47 VSS 0.0531487f
C381 fb.0.t42 VSS 0.0286304f
C382 fb.0.t43 VSS 0.0286304f
C383 fb.0.n48 VSS 0.065629f
C384 fb.0.n49 VSS 0.0531487f
C385 fb.0.t40 VSS 0.0286304f
C386 fb.0.t41 VSS 0.0286304f
C387 fb.0.n50 VSS 0.065629f
C388 fb.0.n51 VSS 0.0816112f
C389 fb.0.t39 VSS 0.0792389f
C390 fb.0.t19 VSS 0.0269609f
C391 fb.0.t0 VSS 0.0269609f
C392 fb.0.n52 VSS 0.0568906f
C393 fb.0.n53 VSS 0.0426431f
C394 fb.0.t17 VSS 0.0269609f
C395 fb.0.t18 VSS 0.0269609f
C396 fb.0.n54 VSS 0.0568906f
C397 fb.0.n55 VSS 0.0257782f
C398 fb.0.t15 VSS 0.0269609f
C399 fb.0.t16 VSS 0.0269609f
C400 fb.0.n56 VSS 0.0568906f
C401 fb.0.n57 VSS 0.045941f
C402 fb.0.t13 VSS 0.0269609f
C403 fb.0.t14 VSS 0.0269609f
C404 fb.0.n58 VSS 0.0568906f
C405 fb.0.n59 VSS 0.067847f
C406 fb.0.n60 VSS 0.0849245f
C407 fb.0.t11 VSS 0.0149109f
C408 fa.0.t14 VSS 0.0165228f
C409 fa.0.n0 VSS 0.0356968f
C410 fa.0.t12 VSS 0.0165228f
C411 fa.0.t13 VSS 0.0165228f
C412 fa.0.n1 VSS 0.0356968f
C413 fa.0.n2 VSS 0.13645f
C414 fa.0.t10 VSS 0.0165228f
C415 fa.0.t11 VSS 0.0165228f
C416 fa.0.n3 VSS 0.0356968f
C417 fa.0.n4 VSS 0.0930578f
C418 fa.0.t8 VSS 0.0165228f
C419 fa.0.t9 VSS 0.0165228f
C420 fa.0.n5 VSS 0.0356968f
C421 fa.0.t6 VSS 0.0165228f
C422 fa.0.t7 VSS 0.0165228f
C423 fa.0.n6 VSS 0.0356968f
C424 fa.0.n7 VSS 0.0930578f
C425 fa.0.t4 VSS 0.0165228f
C426 fa.0.t5 VSS 0.0165228f
C427 fa.0.n8 VSS 0.0356968f
C428 fa.0.n9 VSS 0.0930578f
C429 fa.0.t1 VSS 0.0165228f
C430 fa.0.t3 VSS 0.0165228f
C431 fa.0.n10 VSS 0.0356968f
C432 fa.0.n11 VSS 0.0832738f
C433 fa.0.t35 VSS 0.0317238f
C434 fa.0.t36 VSS 0.0317238f
C435 fa.0.n12 VSS 0.0727212f
C436 fa.0.n13 VSS 0.0583528f
C437 fa.0.t37 VSS 0.0317238f
C438 fa.0.t38 VSS 0.0317238f
C439 fa.0.n14 VSS 0.0727212f
C440 fa.0.n15 VSS 0.0588923f
C441 fa.0.t39 VSS 0.0317238f
C442 fa.0.t40 VSS 0.0317238f
C443 fa.0.n16 VSS 0.0727212f
C444 fa.0.n17 VSS 0.0588923f
C445 fa.0.t41 VSS 0.0317238f
C446 fa.0.t42 VSS 0.0317238f
C447 fa.0.n18 VSS 0.0727212f
C448 fa.0.n19 VSS 0.0588923f
C449 fa.0.t43 VSS 0.0317238f
C450 fa.0.t44 VSS 0.0317238f
C451 fa.0.n20 VSS 0.0727212f
C452 fa.0.n21 VSS 0.0588923f
C453 fa.0.t59 VSS 0.0317238f
C454 fa.0.t30 VSS 0.0317238f
C455 fa.0.n22 VSS 0.0727212f
C456 fa.0.n23 VSS 0.0588923f
C457 fa.0.t62 VSS 0.0317238f
C458 fa.0.t22 VSS 0.0317238f
C459 fa.0.n24 VSS 0.0727212f
C460 fa.0.n25 VSS 0.0588923f
C461 fa.0.t27 VSS 0.0317238f
C462 fa.0.t31 VSS 0.0317238f
C463 fa.0.n26 VSS 0.0727212f
C464 fa.0.n27 VSS 0.0588923f
C465 fa.0.t26 VSS 0.0317238f
C466 fa.0.t32 VSS 0.0317238f
C467 fa.0.n28 VSS 0.0727212f
C468 fa.0.n29 VSS 0.0588923f
C469 fa.0.t64 VSS 0.0317238f
C470 fa.0.t57 VSS 0.0317238f
C471 fa.0.n30 VSS 0.0727212f
C472 fa.0.n31 VSS 0.0588923f
C473 fa.0.t60 VSS 0.0317238f
C474 fa.0.t65 VSS 0.0317238f
C475 fa.0.n32 VSS 0.0727212f
C476 fa.0.n33 VSS 0.0461427f
C477 fa.0.t58 VSS 0.0317238f
C478 fa.0.t63 VSS 0.0317238f
C479 fa.0.n34 VSS 0.0727212f
C480 fa.0.n35 VSS 0.0461427f
C481 fa.0.t28 VSS 0.0317238f
C482 fa.0.t25 VSS 0.0317238f
C483 fa.0.n36 VSS 0.0727212f
C484 fa.0.n37 VSS 0.0588923f
C485 fa.0.t61 VSS 0.0317238f
C486 fa.0.t24 VSS 0.0317238f
C487 fa.0.n38 VSS 0.0727212f
C488 fa.0.n39 VSS 0.0588923f
C489 fa.0.t23 VSS 0.0317238f
C490 fa.0.t33 VSS 0.0317238f
C491 fa.0.n40 VSS 0.0727212f
C492 fa.0.n41 VSS 0.0588923f
C493 fa.0.t34 VSS 0.0317238f
C494 fa.0.t29 VSS 0.0317238f
C495 fa.0.n42 VSS 0.0727212f
C496 fa.0.n43 VSS 0.0588923f
C497 fa.0.t45 VSS 0.0317238f
C498 fa.0.t46 VSS 0.0317238f
C499 fa.0.n44 VSS 0.0727212f
C500 fa.0.n45 VSS 0.0588923f
C501 fa.0.t47 VSS 0.0317238f
C502 fa.0.t48 VSS 0.0317238f
C503 fa.0.n46 VSS 0.0727212f
C504 fa.0.n47 VSS 0.0588923f
C505 fa.0.t49 VSS 0.0317238f
C506 fa.0.t50 VSS 0.0317238f
C507 fa.0.n48 VSS 0.0727212f
C508 fa.0.n49 VSS 0.0588923f
C509 fa.0.t51 VSS 0.0317238f
C510 fa.0.t52 VSS 0.0317238f
C511 fa.0.n50 VSS 0.0727212f
C512 fa.0.n51 VSS 0.0588923f
C513 fa.0.t53 VSS 0.0317238f
C514 fa.0.t54 VSS 0.0317238f
C515 fa.0.n52 VSS 0.0727212f
C516 fa.0.n53 VSS 0.0904298f
C517 fa.0.t55 VSS 0.0317238f
C518 fa.0.t56 VSS 0.0317238f
C519 fa.0.n54 VSS 0.0727212f
C520 fa.0.t15 VSS 0.0298741f
C521 fa.0.t16 VSS 0.0298741f
C522 fa.0.n55 VSS 0.0630381f
C523 fa.0.n56 VSS 0.0508862f
C524 fa.0.t17 VSS 0.0298741f
C525 fa.0.t18 VSS 0.0298741f
C526 fa.0.n57 VSS 0.0630381f
C527 fa.0.n58 VSS 0.028564f
C528 fa.0.t19 VSS 0.0298741f
C529 fa.0.t20 VSS 0.0298741f
C530 fa.0.n59 VSS 0.0630381f
C531 fa.0.n60 VSS 0.0509056f
C532 fa.0.t21 VSS 0.0298741f
C533 fa.0.t0 VSS 0.0298741f
C534 fa.0.n61 VSS 0.0630381f
C535 fa.0.n62 VSS 0.0776801f
C536 fa.0.t2 VSS 0.0165228f
C537 oa.0.t26 VSS 0.0374198f
C538 oa.0.n0 VSS 0.084366f
C539 oa.0.t23 VSS 0.0374198f
C540 oa.0.t24 VSS 0.0374198f
C541 oa.0.n1 VSS 0.084366f
C542 oa.0.n2 VSS 0.117078f
C543 oa.0.t11 VSS 0.0374198f
C544 oa.0.t14 VSS 0.0374198f
C545 oa.0.n3 VSS 0.084366f
C546 oa.0.n4 VSS 0.0769854f
C547 oa.0.t13 VSS 0.0374198f
C548 oa.0.t10 VSS 0.0374198f
C549 oa.0.n5 VSS 0.084366f
C550 oa.0.n6 VSS 0.0769854f
C551 oa.0.t15 VSS 0.0374198f
C552 oa.0.t12 VSS 0.0374198f
C553 oa.0.n7 VSS 0.084366f
C554 oa.0.n8 VSS 0.0600995f
C555 oa.0.t1 VSS 0.0374198f
C556 oa.0.t16 VSS 0.0374198f
C557 oa.0.n9 VSS 0.084366f
C558 oa.0.n10 VSS 0.0600995f
C559 oa.0.t9 VSS 0.0374198f
C560 oa.0.t28 VSS 0.0374198f
C561 oa.0.n11 VSS 0.084366f
C562 oa.0.n12 VSS 0.0769854f
C563 oa.0.t21 VSS 0.0374198f
C564 oa.0.t22 VSS 0.0374198f
C565 oa.0.n13 VSS 0.084366f
C566 oa.0.n14 VSS 0.0769854f
C567 oa.0.t19 VSS 0.0374198f
C568 oa.0.t20 VSS 0.0374198f
C569 oa.0.n15 VSS 0.084366f
C570 oa.0.n16 VSS 0.0769854f
C571 oa.0.t17 VSS 0.0374198f
C572 oa.0.t18 VSS 0.0374198f
C573 oa.0.n17 VSS 0.084366f
C574 oa.0.n18 VSS 0.0669105f
C575 oa.0.n19 VSS 0.0694299f
C576 oa.0.t30 VSS 0.097559f
C577 oa.0.n20 VSS 0.114954f
C578 oa.0.t29 VSS 0.0980544f
C579 oa.0.t27 VSS 0.0528804f
C580 oa.0.n21 VSS 0.0970795f
C581 oa.0.t3 VSS 0.0356077f
C582 oa.0.t4 VSS 0.0356077f
C583 oa.0.n22 VSS 0.0751389f
C584 oa.0.n23 VSS 0.0628626f
C585 oa.0.t7 VSS 0.0356077f
C586 oa.0.t2 VSS 0.0356077f
C587 oa.0.n24 VSS 0.0751389f
C588 oa.0.n25 VSS 0.0340447f
C589 oa.0.t5 VSS 0.0356077f
C590 oa.0.t6 VSS 0.0356077f
C591 oa.0.n26 VSS 0.0751389f
C592 oa.0.n27 VSS 0.060677f
C593 oa.0.t0 VSS 0.0356077f
C594 oa.0.t8 VSS 0.0356077f
C595 oa.0.n28 VSS 0.0751389f
C596 oa.0.t25 VSS 0.0374198f
C597 ob.0.t23 VSS 0.102428f
C598 ob.0.t21 VSS 0.0356183f
C599 ob.0.t22 VSS 0.0356183f
C600 ob.0.n0 VSS 0.0803062f
C601 ob.0.n1 VSS 0.0732803f
C602 ob.0.t8 VSS 0.0356183f
C603 ob.0.t20 VSS 0.0356183f
C604 ob.0.n2 VSS 0.0803062f
C605 ob.0.n3 VSS 0.0732803f
C606 ob.0.t12 VSS 0.0356183f
C607 ob.0.t10 VSS 0.0356183f
C608 ob.0.n4 VSS 0.0803062f
C609 ob.0.n5 VSS 0.0732803f
C610 ob.0.t9 VSS 0.0356183f
C611 ob.0.t28 VSS 0.0356183f
C612 ob.0.n6 VSS 0.0803062f
C613 ob.0.n7 VSS 0.0732803f
C614 ob.0.t25 VSS 0.0356183f
C615 ob.0.t27 VSS 0.0356183f
C616 ob.0.n8 VSS 0.0803062f
C617 ob.0.t24 VSS 0.0356183f
C618 ob.0.t13 VSS 0.0356183f
C619 ob.0.n9 VSS 0.0803062f
C620 ob.0.n10 VSS 0.0732803f
C621 ob.0.t19 VSS 0.0356183f
C622 ob.0.t11 VSS 0.0356183f
C623 ob.0.n11 VSS 0.0803062f
C624 ob.0.n12 VSS 0.0732803f
C625 ob.0.t17 VSS 0.0356183f
C626 ob.0.t18 VSS 0.0356183f
C627 ob.0.n13 VSS 0.0803062f
C628 ob.0.n14 VSS 0.0732803f
C629 ob.0.t15 VSS 0.0356183f
C630 ob.0.t16 VSS 0.0356183f
C631 ob.0.n15 VSS 0.0803062f
C632 ob.0.n16 VSS 0.111444f
C633 ob.0.t14 VSS 0.102428f
C634 ob.0.t0 VSS 0.0338945f
C635 ob.0.t6 VSS 0.0338945f
C636 ob.0.n17 VSS 0.0715231f
C637 ob.0.n18 VSS 0.0557115f
C638 ob.0.t7 VSS 0.0338945f
C639 ob.0.t3 VSS 0.0338945f
C640 ob.0.n19 VSS 0.0715231f
C641 ob.0.n20 VSS 0.0324084f
C642 ob.0.t4 VSS 0.0338945f
C643 ob.0.t5 VSS 0.0338945f
C644 ob.0.n21 VSS 0.0715231f
C645 ob.0.n22 VSS 0.0577551f
C646 ob.0.t1 VSS 0.0338945f
C647 ob.0.t2 VSS 0.0338945f
C648 ob.0.n23 VSS 0.0715231f
C649 ob.0.t26 VSS 0.0503353f
C650 ob.0.t30 VSS 0.0933351f
C651 ob.0.t29 VSS 0.0928619f
C652 ob.0.n24 VSS 0.10942f
C653 ob.0.n25 VSS 0.101579f
C654 ob.0.n26 VSS 0.0247584f
C655 ob.0.n27 VSS 0.0554199f
C656 tn.0.t12 VSS 0.0179365f
C657 tn.0.n0 VSS 0.0370941f
C658 tn.0.t10 VSS 0.0179365f
C659 tn.0.t11 VSS 0.0179365f
C660 tn.0.n1 VSS 0.0370941f
C661 tn.0.n2 VSS 0.0540402f
C662 tn.0.t8 VSS 0.0179365f
C663 tn.0.t9 VSS 0.0179365f
C664 tn.0.n3 VSS 0.0370941f
C665 tn.0.n4 VSS 0.0426511f
C666 tn.0.t6 VSS 0.0179365f
C667 tn.0.t7 VSS 0.0179365f
C668 tn.0.n5 VSS 0.0370941f
C669 tn.0.n6 VSS 0.0426511f
C670 tn.0.t4 VSS 0.0179365f
C671 tn.0.t5 VSS 0.0179365f
C672 tn.0.n7 VSS 0.0370941f
C673 tn.0.n8 VSS 0.084506f
C674 tn.0.t0 VSS 0.0179365f
C675 tn.0.t3 VSS 0.0179365f
C676 tn.0.n9 VSS 0.0370941f
C677 tn.0.t31 VSS 0.0340787f
C678 tn.0.t37 VSS 0.0340787f
C679 tn.0.n10 VSS 0.0681574f
C680 tn.0.n11 VSS 0.0439364f
C681 tn.0.t38 VSS 0.0340787f
C682 tn.0.t32 VSS 0.0340787f
C683 tn.0.n12 VSS 0.0681574f
C684 tn.0.n13 VSS 0.0385873f
C685 tn.0.t33 VSS 0.0340787f
C686 tn.0.t39 VSS 0.0340787f
C687 tn.0.n14 VSS 0.0681574f
C688 tn.0.n15 VSS 0.0385873f
C689 tn.0.t40 VSS 0.0340787f
C690 tn.0.t34 VSS 0.0340787f
C691 tn.0.n16 VSS 0.0681574f
C692 tn.0.n17 VSS 0.0385873f
C693 tn.0.t35 VSS 0.0340787f
C694 tn.0.t43 VSS 0.0340787f
C695 tn.0.n18 VSS 0.0681574f
C696 tn.0.n19 VSS 0.0385873f
C697 tn.0.t44 VSS 0.0340787f
C698 tn.0.t36 VSS 0.0340787f
C699 tn.0.n20 VSS 0.0681574f
C700 tn.0.n21 VSS 0.0385873f
C701 tn.0.t24 VSS 0.0340787f
C702 tn.0.t13 VSS 0.0340787f
C703 tn.0.n22 VSS 0.0681574f
C704 tn.0.n23 VSS 0.0385873f
C705 tn.0.t51 VSS 0.0340787f
C706 tn.0.t47 VSS 0.0340787f
C707 tn.0.n24 VSS 0.0681574f
C708 tn.0.n25 VSS 0.0385873f
C709 tn.0.t26 VSS 0.0340787f
C710 tn.0.t2 VSS 0.0340787f
C711 tn.0.n26 VSS 0.0681574f
C712 tn.0.n27 VSS 0.0385873f
C713 tn.0.t23 VSS 0.0340787f
C714 tn.0.t48 VSS 0.0340787f
C715 tn.0.n28 VSS 0.0681574f
C716 tn.0.n29 VSS 0.0310068f
C717 tn.0.t49 VSS 0.0340787f
C718 tn.0.t21 VSS 0.0340787f
C719 tn.0.n30 VSS 0.0681574f
C720 tn.0.n31 VSS 0.0310068f
C721 tn.0.t18 VSS 0.0340787f
C722 tn.0.t17 VSS 0.0340787f
C723 tn.0.n32 VSS 0.0681574f
C724 tn.0.n33 VSS 0.0385873f
C725 tn.0.t50 VSS 0.0340787f
C726 tn.0.t19 VSS 0.0340787f
C727 tn.0.n34 VSS 0.0681574f
C728 tn.0.n35 VSS 0.0385873f
C729 tn.0.t14 VSS 0.0340787f
C730 tn.0.t25 VSS 0.0340787f
C731 tn.0.n36 VSS 0.0681574f
C732 tn.0.n37 VSS 0.0385873f
C733 tn.0.t22 VSS 0.0340787f
C734 tn.0.t15 VSS 0.0340787f
C735 tn.0.n38 VSS 0.0681574f
C736 tn.0.n39 VSS 0.0385873f
C737 tn.0.t20 VSS 0.0340787f
C738 tn.0.t16 VSS 0.0340787f
C739 tn.0.n40 VSS 0.0681574f
C740 tn.0.n41 VSS 0.0385873f
C741 tn.0.t27 VSS 0.0340787f
C742 tn.0.t45 VSS 0.0340787f
C743 tn.0.n42 VSS 0.0681574f
C744 tn.0.n43 VSS 0.0385873f
C745 tn.0.t46 VSS 0.0340787f
C746 tn.0.t28 VSS 0.0340787f
C747 tn.0.n44 VSS 0.0681574f
C748 tn.0.n45 VSS 0.0385873f
C749 tn.0.t29 VSS 0.0340787f
C750 tn.0.t41 VSS 0.0340787f
C751 tn.0.n46 VSS 0.0681574f
C752 tn.0.n47 VSS 0.0628403f
C753 tn.0.t42 VSS 0.0340787f
C754 tn.0.t30 VSS 0.0340787f
C755 tn.0.n48 VSS 0.0681574f
C756 tn.0.n49 VSS 0.0627318f
C757 tn.0.t1 VSS 0.0179365f
C758 ts.0.t13 VSS 0.0141889f
C759 ts.0.n0 VSS 0.0293375f
C760 ts.0.t11 VSS 0.0141889f
C761 ts.0.t12 VSS 0.0141889f
C762 ts.0.n1 VSS 0.0293375f
C763 ts.0.n2 VSS 0.042739f
C764 ts.0.t9 VSS 0.0141889f
C765 ts.0.t10 VSS 0.0141889f
C766 ts.0.n3 VSS 0.0293375f
C767 ts.0.n4 VSS 0.042739f
C768 ts.0.t7 VSS 0.0141889f
C769 ts.0.t8 VSS 0.0141889f
C770 ts.0.n5 VSS 0.0293375f
C771 ts.0.t5 VSS 0.0141889f
C772 ts.0.t6 VSS 0.0141889f
C773 ts.0.n6 VSS 0.0293375f
C774 ts.0.n7 VSS 0.042739f
C775 ts.0.t3 VSS 0.0141889f
C776 ts.0.t4 VSS 0.0141889f
C777 ts.0.n8 VSS 0.0293375f
C778 ts.0.n9 VSS 0.0668356f
C779 ts.0.t0 VSS 0.0141889f
C780 ts.0.t2 VSS 0.0141889f
C781 ts.0.n10 VSS 0.0293375f
C782 ts.0.t14 VSS 0.0952217f
C783 ts.0.t15 VSS 0.0952217f
C784 ts.0.n11 VSS 0.0413448f
C785 ts.0.t1 VSS 0.0141889f
C786 d2a.0.t16 VSS 0.0126201f
C787 d2a.0.n0 VSS 0.0252419f
C788 d2a.0.t13 VSS 0.0126201f
C789 d2a.0.t14 VSS 0.0126201f
C790 d2a.0.n1 VSS 0.0252419f
C791 d2a.0.n2 VSS 0.0363423f
C792 d2a.0.t11 VSS 0.0126201f
C793 d2a.0.t12 VSS 0.0126201f
C794 d2a.0.n3 VSS 0.0252419f
C795 d2a.0.n4 VSS 0.0537366f
C796 d2a.0.t3 VSS 0.0126201f
C797 d2a.0.t5 VSS 0.0126201f
C798 d2a.0.n5 VSS 0.0252419f
C799 d2a.0.n6 VSS 0.0487508f
C800 d2a.0.n7 VSS 0.026276f
C801 d2a.0.t10 VSS 0.013644f
C802 d2a.0.t17 VSS 0.013644f
C803 d2a.0.n8 VSS 0.0282171f
C804 d2a.0.n9 VSS 0.144673f
C805 d2a.0.t33 VSS 0.0197298f
C806 d2a.0.n10 VSS 0.0735697f
C807 d2a.0.t32 VSS 0.0197298f
C808 d2a.0.n11 VSS 0.0382733f
C809 d2a.0.t31 VSS 0.0197298f
C810 d2a.0.n12 VSS 0.0322382f
C811 d2a.0.t30 VSS 0.0197298f
C812 d2a.0.n13 VSS 0.0298232f
C813 d2a.0.t29 VSS 0.0197298f
C814 d2a.0.n14 VSS 0.0382733f
C815 d2a.0.t28 VSS 0.0197298f
C816 d2a.0.n15 VSS 0.0382733f
C817 d2a.0.t27 VSS 0.0197298f
C818 d2a.0.n16 VSS 0.0722767f
C819 d2a.0.t26 VSS 0.0205574f
C820 d2a.0.t18 VSS 0.0298114f
C821 d2a.0.t1 VSS 0.0298114f
C822 d2a.0.n17 VSS 0.0629161f
C823 d2a.0.n18 VSS 0.0444691f
C824 d2a.0.t0 VSS 0.0298114f
C825 d2a.0.t19 VSS 0.0298114f
C826 d2a.0.n19 VSS 0.0629161f
C827 d2a.0.t2 VSS 0.0197298f
C828 d2a.0.n20 VSS 0.0639129f
C829 d2a.0.t4 VSS 0.0197298f
C830 d2a.0.n21 VSS 0.0479283f
C831 d2a.0.t25 VSS 0.0197298f
C832 d2a.0.n22 VSS 0.0479283f
C833 d2a.0.t24 VSS 0.0197298f
C834 d2a.0.n23 VSS 0.0274099f
C835 d2a.0.t23 VSS 0.0197298f
C836 d2a.0.n24 VSS 0.0346516f
C837 d2a.0.t22 VSS 0.0197298f
C838 d2a.0.n25 VSS 0.0286165f
C839 d2a.0.t21 VSS 0.0197298f
C840 d2a.0.n26 VSS 0.0286165f
C841 d2a.0.t20 VSS 0.0197298f
C842 d2a.0.n27 VSS 0.0479283f
C843 d2a.0.t6 VSS 0.0197298f
C844 d2a.0.n28 VSS 0.0729029f
C845 d2a.0.t8 VSS 0.0199329f
C846 d2a.0.n29 VSS 0.0439055f
C847 d2a.0.t7 VSS 0.0126201f
C848 d2a.0.t9 VSS 0.0126201f
C849 d2a.0.n30 VSS 0.0252419f
C850 d2a.0.n31 VSS 0.0898944f
C851 d2a.0.t15 VSS 0.0126201f
C852 sa.0.t1 VSS 0.0475404f
C853 sa.0.n0 VSS 0.10033f
C854 sa.0.t0 VSS 0.182557f
C855 sa.0.t2 VSS 0.0475404f
C856 rla_m1.0.t0 VSS 0.067471f
C857 rla_m1.0.t1 VSS 0.067471f
C858 rlb_m1.0.t0 VSS 0.064148f
C859 rlb_m1.0.t1 VSS 0.064148f
C860 d2b.0.t10 VSS 0.0136892f
C861 d2b.0.n0 VSS 0.0295914f
C862 d2b.0.t11 VSS 0.0136892f
C863 d2b.0.t15 VSS 0.0136892f
C864 d2b.0.n1 VSS 0.0295914f
C865 d2b.0.n2 VSS 0.0455347f
C866 d2b.0.t13 VSS 0.0136892f
C867 d2b.0.t12 VSS 0.0136892f
C868 d2b.0.n3 VSS 0.0295914f
C869 d2b.0.n4 VSS 0.0266687f
C870 d2b.0.t18 VSS 0.0136892f
C871 d2b.0.t14 VSS 0.0136892f
C872 d2b.0.n5 VSS 0.0295914f
C873 d2b.0.n6 VSS 0.0847244f
C874 d2b.0.t4 VSS 0.0136892f
C875 d2b.0.t6 VSS 0.0136892f
C876 d2b.0.n7 VSS 0.0295914f
C877 d2b.0.n8 VSS 0.155023f
C878 d2b.0.t26 VSS 0.0214007f
C879 d2b.0.n9 VSS 0.0783202f
C880 d2b.0.t27 VSS 0.0214007f
C881 d2b.0.n10 VSS 0.0415124f
C882 d2b.0.t28 VSS 0.0214007f
C883 d2b.0.n11 VSS 0.0375836f
C884 d2b.0.t29 VSS 0.0214007f
C885 d2b.0.n12 VSS 0.0402028f
C886 d2b.0.t30 VSS 0.0214007f
C887 d2b.0.n13 VSS 0.0415124f
C888 d2b.0.t31 VSS 0.0214007f
C889 d2b.0.n14 VSS 0.0415124f
C890 d2b.0.t32 VSS 0.0214007f
C891 d2b.0.n15 VSS 0.0686009f
C892 d2b.0.t33 VSS 0.0216197f
C893 d2b.0.t0 VSS 0.0323361f
C894 d2b.0.t17 VSS 0.0323361f
C895 d2b.0.n16 VSS 0.0682427f
C896 d2b.0.n17 VSS 0.0482314f
C897 d2b.0.t16 VSS 0.0323361f
C898 d2b.0.t1 VSS 0.0323361f
C899 d2b.0.n18 VSS 0.0682427f
C900 d2b.0.t2 VSS 0.014798f
C901 d2b.0.t19 VSS 0.014798f
C902 d2b.0.n19 VSS 0.0306044f
C903 d2b.0.n20 VSS 0.0108669f
C904 d2b.0.t9 VSS 0.0214007f
C905 d2b.0.n21 VSS 0.0870949f
C906 d2b.0.t7 VSS 0.0214007f
C907 d2b.0.n22 VSS 0.0310379f
C908 d2b.0.t20 VSS 0.0214007f
C909 d2b.0.n23 VSS 0.0310379f
C910 d2b.0.t21 VSS 0.0214007f
C911 d2b.0.n24 VSS 0.0349986f
C912 d2b.0.t22 VSS 0.0214007f
C913 d2b.0.n25 VSS 0.0427877f
C914 d2b.0.t23 VSS 0.0214007f
C915 d2b.0.n26 VSS 0.0415124f
C916 d2b.0.t24 VSS 0.0214007f
C917 d2b.0.n27 VSS 0.0415124f
C918 d2b.0.t25 VSS 0.0214007f
C919 d2b.0.n28 VSS 0.0310379f
C920 d2b.0.t5 VSS 0.0214007f
C921 d2b.0.n29 VSS 0.0581264f
C922 d2b.0.t3 VSS 0.0216197f
C923 d2b.0.n30 VSS 0.0588268f
C924 d2b.0.n31 VSS 0.0592695f
C925 d2b.0.t8 VSS 0.0136892f
C926 sb.0.t1 VSS 0.0486579f
C927 sb.0.n0 VSS 0.102694f
C928 sb.0.t0 VSS 0.186859f
C929 sb.0.t2 VSS 0.0486579f
C930 n3a.0.t2 VSS 0.0187224f
C931 n3a.0.n0 VSS 0.040478f
C932 n3a.0.t12 VSS 0.0187224f
C933 n3a.0.t11 VSS 0.0187224f
C934 n3a.0.n1 VSS 0.040478f
C935 n3a.0.n2 VSS 0.124052f
C936 n3a.0.t6 VSS 0.0187224f
C937 n3a.0.t5 VSS 0.0187224f
C938 n3a.0.n3 VSS 0.040478f
C939 n3a.0.t8 VSS 0.0187224f
C940 n3a.0.t7 VSS 0.0187224f
C941 n3a.0.n4 VSS 0.040478f
C942 n3a.0.n5 VSS 0.0797251f
C943 n3a.0.t1 VSS 0.0187224f
C944 n3a.0.t9 VSS 0.0187224f
C945 n3a.0.n6 VSS 0.040478f
C946 n3a.0.n7 VSS 0.0875138f
C947 n3a.0.t0 VSS 0.0471637f
C948 n3a.0.t4 VSS 0.0471637f
C949 n3a.0.n8 VSS 0.104554f
C950 n3a.0.t3 VSS 0.0747738f
C951 n3a.0.n9 VSS 0.111455f
C952 n3a.0.t13 VSS 0.0749936f
C953 n3a.0.t10 VSS 0.0187224f
C954 d3.0.t2 VSS 0.0187359f
C955 d3.0.n0 VSS 0.0405066f
C956 d3.0.t5 VSS 0.0187359f
C957 d3.0.t4 VSS 0.0187359f
C958 d3.0.n1 VSS 0.0405066f
C959 d3.0.n2 VSS 0.107198f
C960 d3.0.t7 VSS 0.0187359f
C961 d3.0.t6 VSS 0.0187359f
C962 d3.0.n3 VSS 0.0405066f
C963 d3.0.n4 VSS 0.0628374f
C964 d3.0.t9 VSS 0.0187359f
C965 d3.0.t8 VSS 0.0187359f
C966 d3.0.n5 VSS 0.0405066f
C967 d3.0.n6 VSS 0.0924921f
C968 d3.0.n7 VSS 0.0203453f
C969 d3.0.t1 VSS 0.0471991f
C970 d3.0.t0 VSS 0.0471991f
C971 d3.0.n8 VSS 0.104632f
C972 d3.0.n9 VSS 0.111044f
C973 d3.0.t10 VSS 0.0483571f
C974 d3.0.t11 VSS 0.0322046f
C975 d3.0.t3 VSS 0.0187359f
C976 nd.0.t2 VSS 0.0266759f
C977 nd.0.n0 VSS 0.0558003f
C978 nd.0.t1 VSS 0.0266759f
C979 nd.0.t4 VSS 0.0266759f
C980 nd.0.n1 VSS 0.0558003f
C981 nd.0.n2 VSS 0.0383221f
C982 nd.0.n3 VSS 0.0437547f
C983 nd.0.t0 VSS 0.0177854f
C984 nd.0.t3 VSS 0.0177854f
C985 nd.0.n4 VSS 0.0379535f
C986 nd.0.t7 VSS 0.0212828f
C987 nd.0.n5 VSS 0.0613119f
C988 nd.0.t6 VSS 0.0523863f
C989 nd.0.t5 VSS 0.0266759f
C990 nm.0.t0 VSS 0.0315017f
C991 nm.0.n0 VSS 0.0630033f
C992 nm.0.t1 VSS 0.0315017f
C993 i1.0.t0 VSS 0.0124723f
C994 i1.0.n0 VSS 0.0254838f
C995 i1.0.n1 VSS 0.0144036f
C996 i1.0.n2 VSS 0.0257769f
C997 i1.0.n3 VSS 0.0727091f
C998 i1.0.t5 VSS 0.0492718f
C999 i1.0.n4 VSS 0.0844277f
C1000 i1.0.t4 VSS 0.0494654f
C1001 i1.0.t6 VSS 0.0396362f
C1002 i1.0.t1 VSS 0.0307595f
C1003 i1.0.t2 VSS 0.0307595f
C1004 i1.0.n5 VSS 0.0644605f
C1005 i1.0.t3 VSS 0.0124723f
C1006 i2.0.t2 VSS 0.0311956f
C1007 i2.0.n0 VSS 0.0660438f
C1008 i2.0.t1 VSS 0.0311956f
C1009 i2.0.t5 VSS 0.0311956f
C1010 i2.0.n1 VSS 0.0660438f
C1011 i2.0.n2 VSS 0.0357648f
C1012 i2.0.n3 VSS 0.0219162f
C1013 i2.0.t0 VSS 0.0249565f
C1014 i2.0.t4 VSS 0.0249565f
C1015 i2.0.n4 VSS 0.0518428f
C1016 i2.0.n5 VSS 0.0304774f
C1017 i2.0.t9 VSS 0.0660086f
C1018 i2.0.n6 VSS 0.0449736f
C1019 i2.0.t8 VSS 0.0660086f
C1020 i2.0.n7 VSS 0.049393f
C1021 i2.0.t7 VSS 0.0660086f
C1022 i2.0.n8 VSS 0.0944107f
C1023 i2.0.t6 VSS 0.0661892f
C1024 i2.0.t11 VSS 0.0526403f
C1025 i2.0.n9 VSS 0.0855895f
C1026 i2.0.t10 VSS 0.0528342f
C1027 i2.0.t3 VSS 0.0311956f
C1028 VDD.n0 VSS 0.680579f
C1029 VDD.n1 VSS 0.680579f
C1030 VDD.n2 VSS 0.112106f
C1031 VDD.n3 VSS 0.0911602f
C1032 VDD.n4 VSS 0.666306f
C1033 VDD.n5 VSS 0.666306f
C1034 VDD.t7 VSS 0.545874f
C1035 VDD.t196 VSS 0.347563f
C1036 VDD.t194 VSS 0.347563f
C1037 VDD.t192 VSS 0.347563f
C1038 VDD.t190 VSS 0.347563f
C1039 VDD.t188 VSS 0.347563f
C1040 VDD.t186 VSS 0.347563f
C1041 VDD.t184 VSS 0.347563f
C1042 VDD.t182 VSS 0.347563f
C1043 VDD.t180 VSS 0.347563f
C1044 VDD.t178 VSS 0.347563f
C1045 VDD.t176 VSS 0.26067f
C1046 VDD.t4 VSS 0.545874f
C1047 VDD.t154 VSS 0.347563f
C1048 VDD.t156 VSS 0.347563f
C1049 VDD.t158 VSS 0.347563f
C1050 VDD.t160 VSS 0.347563f
C1051 VDD.t162 VSS 0.347563f
C1052 VDD.t164 VSS 0.347563f
C1053 VDD.t166 VSS 0.347563f
C1054 VDD.t168 VSS 0.347563f
C1055 VDD.t170 VSS 0.347563f
C1056 VDD.t172 VSS 0.347563f
C1057 VDD.t174 VSS 0.26067f
C1058 VDD.t6 VSS 0.0950657f
C1059 VDD.n6 VSS 0.169987f
C1060 VDD.t3 VSS 0.0950657f
C1061 VDD.t5 VSS 0.0421136f
C1062 VDD.n7 VSS 0.229904f
C1063 VDD.n8 VSS 0.366676f
C1064 VDD.n9 VSS 0.366676f
C1065 VDD.n10 VSS 0.0562532f
C1066 VDD.t130 VSS 0.534068f
C1067 VDD.n13 VSS 0.0562532f
C1068 VDD.t90 VSS 0.0218805f
C1069 VDD.n14 VSS 0.0157043f
C1070 VDD.t77 VSS 0.0218805f
C1071 VDD.n15 VSS 0.0157043f
C1072 VDD.n16 VSS 2.19094f
C1073 VDD.n17 VSS 2.05829f
C1074 VDD.n18 VSS 0.0105332f
C1075 VDD.n19 VSS 0.02106f
C1076 VDD.n20 VSS 0.282042f
C1077 VDD.n21 VSS 0.0331515f
C1078 VDD.n22 VSS 0.0197497f
C1079 VDD.n23 VSS 0.481218f
C1080 VDD.n24 VSS 0.481218f
C1081 VDD.t52 VSS 0.422408f
C1082 VDD.t146 VSS 0.182931f
C1083 VDD.t124 VSS 0.137198f
C1084 VDD.t51 VSS 0.0261675f
C1085 VDD.n25 VSS 0.0726254f
C1086 VDD.t48 VSS 0.0261675f
C1087 VDD.t53 VSS 0.0420881f
C1088 VDD.t147 VSS 0.0162959f
C1089 VDD.t125 VSS 0.0162959f
C1090 VDD.n26 VSS 0.0348689f
C1091 VDD.n27 VSS 0.0214607f
C1092 VDD.t127 VSS 0.0162959f
C1093 VDD.t129 VSS 0.0162959f
C1094 VDD.n28 VSS 0.0348689f
C1095 VDD.n29 VSS 0.011748f
C1096 VDD.n30 VSS 0.12442f
C1097 VDD.t24 VSS 0.0187638f
C1098 VDD.n31 VSS 0.0490848f
C1099 VDD.n32 VSS 0.0224275f
C1100 VDD.n33 VSS 0.337354f
C1101 VDD.n34 VSS 0.337354f
C1102 VDD.t25 VSS 0.308814f
C1103 VDD.n35 VSS 0.0369106f
C1104 VDD.t26 VSS 0.0227074f
C1105 VDD.t143 VSS 0.00651962f
C1106 VDD.n36 VSS 0.0134845f
C1107 VDD.n37 VSS 0.0165694f
C1108 VDD.n38 VSS 0.0953201f
C1109 VDD.n39 VSS 0.0263202f
C1110 VDD.n40 VSS 0.200556f
C1111 VDD.t38 VSS 0.0308808f
C1112 VDD.n41 VSS 0.172372f
C1113 VDD.n42 VSS 0.0123841f
C1114 VDD.n43 VSS 0.0322737f
C1115 VDD.t27 VSS 0.0194062f
C1116 VDD.n44 VSS 0.0618569f
C1117 VDD.n45 VSS 0.0658323f
C1118 VDD.t36 VSS 0.0194062f
C1119 VDD.n46 VSS 0.0617933f
C1120 VDD.n47 VSS 0.0658323f
C1121 VDD.n48 VSS 0.407601f
C1122 VDD.t37 VSS 0.36223f
C1123 VDD.t152 VSS 0.156853f
C1124 VDD.t28 VSS 0.36223f
C1125 VDD.n49 VSS 0.407601f
C1126 VDD.n50 VSS 0.0302892f
C1127 VDD.t29 VSS 0.0429405f
C1128 VDD.t153 VSS 0.0120597f
C1129 VDD.n51 VSS 0.0252707f
C1130 VDD.n52 VSS 0.00742283f
C1131 VDD.n53 VSS 0.0245456f
C1132 VDD.n54 VSS 0.0143305f
C1133 VDD.n55 VSS 0.12816f
C1134 VDD.n56 VSS 0.217234f
C1135 VDD.n57 VSS 0.00863135f
C1136 VDD.t0 VSS 0.0187638f
C1137 VDD.n58 VSS 0.0490848f
C1138 VDD.n59 VSS 0.0608392f
C1139 VDD.n60 VSS 0.0608392f
C1140 VDD.t17 VSS 0.0161877f
C1141 VDD.n61 VSS 0.0207865f
C1142 VDD.t15 VSS 0.0187638f
C1143 VDD.n62 VSS 0.0223067f
C1144 VDD.n63 VSS 0.175171f
C1145 VDD.t145 VSS 0.00977625f
C1146 VDD.t119 VSS 0.00977625f
C1147 VDD.n64 VSS 0.0204557f
C1148 VDD.t41 VSS 0.0246092f
C1149 VDD.t39 VSS 0.0157807f
C1150 VDD.n65 VSS 0.0488304f
C1151 VDD.n66 VSS 0.0661122f
C1152 VDD.n67 VSS 0.0661122f
C1153 VDD.n68 VSS 0.0226247f
C1154 VDD.n69 VSS 0.142955f
C1155 VDD.t12 VSS 0.00989711f
C1156 VDD.n70 VSS 0.373476f
C1157 VDD.t14 VSS 0.014216f
C1158 VDD.t11 VSS 0.014216f
C1159 VDD.t9 VSS 0.00989711f
C1160 VDD.n71 VSS 0.0814349f
C1161 VDD.n72 VSS 0.0565522f
C1162 VDD.n73 VSS 0.110738f
C1163 VDD.n74 VSS 0.110738f
C1164 VDD.t13 VSS 0.27654f
C1165 VDD.t104 VSS 0.119745f
C1166 VDD.t112 VSS 0.119745f
C1167 VDD.t110 VSS 0.119745f
C1168 VDD.t99 VSS 0.119745f
C1169 VDD.t97 VSS 0.119745f
C1170 VDD.t108 VSS 0.119745f
C1171 VDD.t106 VSS 0.119745f
C1172 VDD.t95 VSS 0.0898118f
C1173 VDD.n75 VSS 0.0598724f
C1174 VDD.t93 VSS 0.0898118f
C1175 VDD.t84 VSS 0.119745f
C1176 VDD.t82 VSS 0.119745f
C1177 VDD.t137 VSS 0.119745f
C1178 VDD.t135 VSS 0.119745f
C1179 VDD.t80 VSS 0.119745f
C1180 VDD.t78 VSS 0.119745f
C1181 VDD.t133 VSS 0.119745f
C1182 VDD.t10 VSS 0.27654f
C1183 VDD.n76 VSS 0.373476f
C1184 VDD.t134 VSS 0.00602986f
C1185 VDD.t79 VSS 0.00602986f
C1186 VDD.n77 VSS 0.0120597f
C1187 VDD.n78 VSS 0.0241576f
C1188 VDD.t81 VSS 0.00602986f
C1189 VDD.t136 VSS 0.00602986f
C1190 VDD.n79 VSS 0.0120597f
C1191 VDD.n80 VSS 0.0144386f
C1192 VDD.t138 VSS 0.00602986f
C1193 VDD.t83 VSS 0.00602986f
C1194 VDD.n81 VSS 0.0120597f
C1195 VDD.n82 VSS 0.0144386f
C1196 VDD.t85 VSS 0.00602986f
C1197 VDD.t94 VSS 0.00602986f
C1198 VDD.n83 VSS 0.0120597f
C1199 VDD.n84 VSS 0.011748f
C1200 VDD.t96 VSS 0.00602986f
C1201 VDD.t107 VSS 0.00602986f
C1202 VDD.n85 VSS 0.0120597f
C1203 VDD.n86 VSS 0.011748f
C1204 VDD.t109 VSS 0.00602986f
C1205 VDD.t98 VSS 0.00602986f
C1206 VDD.n87 VSS 0.0120597f
C1207 VDD.n88 VSS 0.0144386f
C1208 VDD.t100 VSS 0.00602986f
C1209 VDD.t111 VSS 0.00602986f
C1210 VDD.n89 VSS 0.0120597f
C1211 VDD.n90 VSS 0.0144386f
C1212 VDD.t113 VSS 0.00602986f
C1213 VDD.t105 VSS 0.00602986f
C1214 VDD.n91 VSS 0.0120597f
C1215 VDD.n92 VSS 0.0144386f
C1216 VDD.n93 VSS 0.014992f
C1217 VDD.n94 VSS 0.0453766f
C1218 VDD.n95 VSS 0.048029f
C1219 VDD.n96 VSS 1.89627f
C1220 VDD.n97 VSS 0.494531f
C1221 VDD.n98 VSS 0.0161369f
C1222 VDD.t35 VSS 0.0246092f
C1223 VDD.n99 VSS 0.0229936f
C1224 VDD.t33 VSS 0.0157807f
C1225 VDD.n100 VSS 0.0607502f
C1226 VDD.n101 VSS 0.377642f
C1227 VDD.t34 VSS 0.329804f
C1228 VDD.t118 VSS 0.107113f
C1229 VDD.n102 VSS 0.0714042f
C1230 VDD.t144 VSS 0.107113f
C1231 VDD.t40 VSS 0.329804f
C1232 VDD.n103 VSS 0.377642f
C1233 VDD.n104 VSS 0.0168238f
C1234 VDD.n105 VSS 0.015081f
C1235 VDD.n106 VSS 0.195252f
C1236 VDD.n107 VSS 0.251079f
C1237 VDD.n108 VSS 0.0224275f
C1238 VDD.n109 VSS 0.0489703f
C1239 VDD.n110 VSS 0.337354f
C1240 VDD.t16 VSS 0.308814f
C1241 VDD.t140 VSS 0.156515f
C1242 VDD.t1 VSS 0.308814f
C1243 VDD.n111 VSS 0.337354f
C1244 VDD.n112 VSS 0.0369106f
C1245 VDD.t141 VSS 0.00651962f
C1246 VDD.n113 VSS 0.0134845f
C1247 VDD.t2 VSS 0.0227074f
C1248 VDD.n114 VSS 0.0129566f
C1249 VDD.n115 VSS 0.28811f
C1250 VDD.n116 VSS 0.218175f
C1251 VDD.n117 VSS 0.0552482f
C1252 VDD.n118 VSS 0.387991f
C1253 VDD.n119 VSS 0.387991f
C1254 VDD.t22 VSS 0.27654f
C1255 VDD.t67 VSS 0.119745f
C1256 VDD.t65 VSS 0.119745f
C1257 VDD.t122 VSS 0.119745f
C1258 VDD.t120 VSS 0.119745f
C1259 VDD.t114 VSS 0.119745f
C1260 VDD.t116 VSS 0.119745f
C1261 VDD.t63 VSS 0.119745f
C1262 VDD.t55 VSS 0.119745f
C1263 VDD.t57 VSS 0.119745f
C1264 VDD.t59 VSS 0.0898118f
C1265 VDD.t21 VSS 0.00989711f
C1266 VDD.n120 VSS 0.0886669f
C1267 VDD.t20 VSS 0.0213716f
C1268 VDD.t23 VSS 0.0213716f
C1269 VDD.t68 VSS 0.00602986f
C1270 VDD.n121 VSS 0.0130329f
C1271 VDD.n122 VSS 0.0188783f
C1272 VDD.t66 VSS 0.00602986f
C1273 VDD.t123 VSS 0.00602986f
C1274 VDD.n123 VSS 0.0130329f
C1275 VDD.n124 VSS 0.0144386f
C1276 VDD.t121 VSS 0.00602986f
C1277 VDD.t115 VSS 0.00602986f
C1278 VDD.n125 VSS 0.0130329f
C1279 VDD.n126 VSS 0.0144386f
C1280 VDD.t117 VSS 0.00602986f
C1281 VDD.t64 VSS 0.00602986f
C1282 VDD.n127 VSS 0.0130329f
C1283 VDD.n128 VSS 0.0144386f
C1284 VDD.t56 VSS 0.00602986f
C1285 VDD.t58 VSS 0.00602986f
C1286 VDD.n129 VSS 0.0130329f
C1287 VDD.n130 VSS 0.0144386f
C1288 VDD.t60 VSS 0.00602986f
C1289 VDD.t70 VSS 0.00602986f
C1290 VDD.n131 VSS 0.0130329f
C1291 VDD.t72 VSS 0.00602986f
C1292 VDD.t62 VSS 0.00602986f
C1293 VDD.n132 VSS 0.0130329f
C1294 VDD.n133 VSS 0.0144386f
C1295 VDD.t132 VSS 0.00602986f
C1296 VDD.t74 VSS 0.00602986f
C1297 VDD.n134 VSS 0.0130329f
C1298 VDD.n135 VSS 0.0144386f
C1299 VDD.t76 VSS 0.00602986f
C1300 VDD.t89 VSS 0.00602986f
C1301 VDD.n136 VSS 0.0130329f
C1302 VDD.n137 VSS 0.0144386f
C1303 VDD.t87 VSS 0.00602986f
C1304 VDD.t92 VSS 0.00602986f
C1305 VDD.n138 VSS 0.0130329f
C1306 VDD.n139 VSS 0.0144386f
C1307 VDD.t103 VSS 0.00602986f
C1308 VDD.n140 VSS 0.0130329f
C1309 VDD.n141 VSS 0.0188783f
C1310 VDD.t18 VSS 0.00989711f
C1311 VDD.n142 VSS 0.0424889f
C1312 VDD.n143 VSS 0.0142287f
C1313 VDD.n144 VSS 0.125107f
C1314 VDD.t19 VSS 0.27654f
C1315 VDD.t102 VSS 0.119745f
C1316 VDD.t91 VSS 0.119745f
C1317 VDD.t86 VSS 0.119745f
C1318 VDD.t88 VSS 0.119745f
C1319 VDD.t75 VSS 0.119745f
C1320 VDD.t73 VSS 0.119745f
C1321 VDD.t131 VSS 0.119745f
C1322 VDD.t61 VSS 0.119745f
C1323 VDD.t71 VSS 0.119745f
C1324 VDD.t69 VSS 0.0898118f
C1325 VDD.n145 VSS 0.0598724f
C1326 VDD.n146 VSS 0.125107f
C1327 VDD.n147 VSS 0.0607629f
C1328 VDD.n148 VSS 0.457614f
C1329 VDD.t44 VSS 0.030709f
C1330 VDD.t47 VSS 0.030709f
C1331 VDD.n149 VSS 0.0980742f
C1332 VDD.n150 VSS 0.034201f
C1333 VDD.t45 VSS 0.0196606f
C1334 VDD.n151 VSS 0.0638923f
C1335 VDD.n152 VSS 0.0695914f
C1336 VDD.t42 VSS 0.0196606f
C1337 VDD.n153 VSS 0.0638287f
C1338 VDD.n154 VSS 0.0695914f
C1339 VDD.n155 VSS 0.413732f
C1340 VDD.t43 VSS 0.364507f
C1341 VDD.t150 VSS 0.11839f
C1342 VDD.n156 VSS 0.0789288f
C1343 VDD.t148 VSS 0.11839f
C1344 VDD.t46 VSS 0.364507f
C1345 VDD.n157 VSS 0.413732f
C1346 VDD.n158 VSS 0.0303973f
C1347 VDD.n159 VSS 0.0151192f
C1348 VDD.t149 VSS 0.0122251f
C1349 VDD.t151 VSS 0.0122251f
C1350 VDD.n160 VSS 0.025875f
C1351 VDD.n161 VSS 0.0246537f
C1352 VDD.n162 VSS 0.0161369f
C1353 VDD.n163 VSS 0.209022f
C1354 VDD.n164 VSS 0.127963f
C1355 VDD.n165 VSS 0.0149093f
C1356 VDD.t32 VSS 0.0161877f
C1357 VDD.t30 VSS 0.0187638f
C1358 VDD.n166 VSS 0.0489703f
C1359 VDD.n167 VSS 0.0207865f
C1360 VDD.n168 VSS 0.0608392f
C1361 VDD.t31 VSS 0.308814f
C1362 VDD.t142 VSS 0.156515f
C1363 VDD.n169 VSS 0.0608392f
C1364 VDD.n170 VSS 0.0223067f
C1365 VDD.n171 VSS 0.483317f
C1366 VDD.n172 VSS 0.532943f
C1367 VDD.n173 VSS 0.0155453f
C1368 VDD.t50 VSS 0.0420881f
C1369 VDD.n174 VSS 0.0274333f
C1370 VDD.n175 VSS 0.0725745f
C1371 VDD.n176 VSS 0.0824398f
C1372 VDD.t49 VSS 0.422408f
C1373 VDD.t128 VSS 0.182931f
C1374 VDD.t126 VSS 0.137198f
C1375 VDD.n177 VSS 0.0914655f
C1376 VDD.n178 VSS 0.0824398f
C1377 VDD.n179 VSS 0.0407015f
C1378 VDD.n180 VSS 2.0231f
C1379 VDD.n181 VSS 0.954855f
C1380 VDD.n183 VSS 0.0752142f
C1381 VDD.n184 VSS 0.0105332f
C1382 VDD.n185 VSS 0.189546f
C1383 VDD.n186 VSS 1.32248f
C1384 VDD.n187 VSS 0.0613226f
C1385 VDD.n188 VSS 0.0452748f
C1386 VDD.n189 VSS 0.0470558f
C1387 VDD.n190 VSS 0.494124f
C1388 VDD.n191 VSS 0.494124f
C1389 VDD.n192 VSS 0.0467123f
C1390 VDD.n193 VSS 0.0708445f
C1391 VDD.t139 VSS 0.743708f
C1392 VDD.n196 VSS 0.0708445f
C1393 VDD.n197 VSS 0.0248382f
C1394 VDD.n198 VSS 0.0517881f
C1395 VDD.n199 VSS 1.17263f
C1396 VDD.n200 VSS 1.14653f
C1397 VDD.t8 VSS 0.0421136f
C1398 VDD.n201 VSS 0.0331515f
C1399 VDD.n202 VSS 0.0205448f
C1400 VDD.t197 VSS 0.0162959f
C1401 VDD.t195 VSS 0.0162959f
C1402 VDD.n203 VSS 0.0349007f
C1403 VDD.n204 VSS 0.0245519f
C1404 VDD.t193 VSS 0.0162959f
C1405 VDD.t191 VSS 0.0162959f
C1406 VDD.n205 VSS 0.0349007f
C1407 VDD.n206 VSS 0.0245519f
C1408 VDD.t189 VSS 0.0162959f
C1409 VDD.t187 VSS 0.0162959f
C1410 VDD.n207 VSS 0.0349007f
C1411 VDD.n208 VSS 0.0245519f
C1412 VDD.t185 VSS 0.0162959f
C1413 VDD.t183 VSS 0.0162959f
C1414 VDD.n209 VSS 0.0349007f
C1415 VDD.n210 VSS 0.0245519f
C1416 VDD.t181 VSS 0.0162959f
C1417 VDD.t179 VSS 0.0162959f
C1418 VDD.n211 VSS 0.0349007f
C1419 VDD.n212 VSS 0.0245519f
C1420 VDD.t177 VSS 0.0162959f
C1421 VDD.t175 VSS 0.0162959f
C1422 VDD.n213 VSS 0.0349007f
C1423 VDD.t173 VSS 0.0162959f
C1424 VDD.t171 VSS 0.0162959f
C1425 VDD.n214 VSS 0.0349007f
C1426 VDD.n215 VSS 0.0245519f
C1427 VDD.t169 VSS 0.0162959f
C1428 VDD.t167 VSS 0.0162959f
C1429 VDD.n216 VSS 0.0349007f
C1430 VDD.n217 VSS 0.0245519f
C1431 VDD.t165 VSS 0.0162959f
C1432 VDD.t163 VSS 0.0162959f
C1433 VDD.n218 VSS 0.0349007f
C1434 VDD.n219 VSS 0.0245519f
C1435 VDD.t161 VSS 0.0162959f
C1436 VDD.t159 VSS 0.0162959f
C1437 VDD.n220 VSS 0.0349007f
C1438 VDD.n221 VSS 0.0245519f
C1439 VDD.t157 VSS 0.0162959f
C1440 VDD.t155 VSS 0.0162959f
C1441 VDD.n222 VSS 0.0349007f
C1442 VDD.n223 VSS 0.0245519f
C1443 VDD.n224 VSS 0.229904f
C1444 VDD.n225 VSS 0.0248382f
C1445 VDD.n226 VSS 0.0467123f
C1446 VDD.n227 VSS 0.0708445f
C1447 VDD.t101 VSS 0.743708f
C1448 VDD.n228 VSS 0.0470558f
C1449 VDD.n230 VSS 0.494124f
C1450 VDD.n231 VSS 0.0708445f
C1451 VDD.n233 VSS 0.494124f
C1452 VDD.n234 VSS 0.0452748f
C1453 VDD.n235 VSS 0.0562532f
C1454 VDD.t54 VSS 0.534068f
C1455 VDD.n237 VSS 0.366676f
C1456 VDD.n238 VSS 0.0562532f
C1457 VDD.n240 VSS 0.366676f
C1458 VDD.n241 VSS 0.291958f
C1459 VDD.n242 VSS 0.0613226f
C1460 VDD.n243 VSS 0.0517881f
C1461 VDD.n244 VSS 1.17263f
C1462 VDD.n245 VSS 1.14653f
C1463 VDD.n246 VSS 0.0205448f
C1464 VDD.n247 VSS 0.0274333f
C1465 VDD.n248 VSS 0.169975f
C1466 VDD.n249 VSS 0.224472f
C1467 VDD.n250 VSS 0.173785f
C1468 VDD.n251 VSS 0.224472f
C1469 VDD.n252 VSS 0.171081f
C1470 INP.t0 VSS 0.165716f
C1471 VBP.t21 VSS 0.0574109f
C1472 VBP.t20 VSS 0.0574109f
C1473 VBP.t19 VSS 0.0574109f
C1474 VBP.t18 VSS 0.0574109f
C1475 VBP.t17 VSS 0.0574109f
C1476 VBP.t16 VSS 0.0574109f
C1477 VBP.t15 VSS 0.0574109f
C1478 VBP.t14 VSS 0.0574109f
C1479 VBP.t13 VSS 0.0574109f
C1480 VBP.t12 VSS 0.0574109f
C1481 VBP.t11 VSS 0.0574109f
C1482 VBP.t10 VSS 0.0574109f
C1483 VBP.t9 VSS 0.0574109f
C1484 VBP.t8 VSS 0.0574109f
C1485 VBP.t7 VSS 0.0574109f
C1486 VBP.t6 VSS 0.0574109f
C1487 VBP.t5 VSS 0.0574109f
C1488 VBP.t4 VSS 0.0574109f
C1489 VBP.t3 VSS 0.0574109f
C1490 VBP.t2 VSS 0.0574109f
C1491 VBP.t1 VSS 0.0574109f
C1492 VBP.t0 VSS 0.0580798f
C1493 VBP.n0 VSS 0.0579284f
C1494 VBP.n1 VSS 0.0304499f
C1495 VBP.n2 VSS 0.0304499f
C1496 VBP.n3 VSS 0.0304499f
C1497 VBP.n4 VSS 0.0304499f
C1498 VBP.n5 VSS 0.0304499f
C1499 VBP.n6 VSS 0.0304499f
C1500 VBP.n7 VSS 0.0304499f
C1501 VBP.n8 VSS 0.0304499f
C1502 VBP.n9 VSS 0.0304499f
C1503 VBP.n10 VSS 0.0298426f
C1504 VBP.n11 VSS 0.0283429f
C1505 VBP.n12 VSS 0.0304499f
C1506 VBP.n13 VSS 0.0304499f
C1507 VBP.n14 VSS 0.0304499f
C1508 VBP.n15 VSS 0.0304499f
C1509 VBP.n16 VSS 0.0304499f
C1510 VBP.n17 VSS 0.0304499f
C1511 VBP.n18 VSS 0.0304499f
C1512 VBP.n19 VSS 0.0304499f
C1513 VBP.n20 VSS 0.0429033f
C1514 VBP.n21 VSS 0.155005f
C1515 INN.t0 VSS 0.157965f
C1516 VREF.t20 VSS 0.0624667f
C1517 VREF.t21 VSS 0.0624667f
C1518 VREF.t22 VSS 0.0624667f
C1519 VREF.t23 VSS 0.0624667f
C1520 VREF.t24 VSS 0.0624667f
C1521 VREF.t25 VSS 0.0624667f
C1522 VREF.t26 VSS 0.0624667f
C1523 VREF.t27 VSS 0.0624667f
C1524 VREF.t28 VSS 0.0624667f
C1525 VREF.t29 VSS 0.0624667f
C1526 VREF.t30 VSS 0.0624667f
C1527 VREF.t31 VSS 0.0624667f
C1528 VREF.t32 VSS 0.0624667f
C1529 VREF.t33 VSS 0.0624667f
C1530 VREF.t34 VSS 0.0624667f
C1531 VREF.t35 VSS 0.0624667f
C1532 VREF.t36 VSS 0.0624667f
C1533 VREF.t37 VSS 0.0624667f
C1534 VREF.t38 VSS 0.0624667f
C1535 VREF.t39 VSS 0.0624667f
C1536 VREF.t40 VSS 0.0624667f
C1537 VREF.t41 VSS 0.0624667f
C1538 VREF.t42 VSS 0.0624667f
C1539 VREF.t43 VSS 0.0626967f
C1540 VREF.n0 VSS 0.0769963f
C1541 VREF.n1 VSS 0.0403831f
C1542 VREF.n2 VSS 0.0403831f
C1543 VREF.n3 VSS 0.0403831f
C1544 VREF.n4 VSS 0.0403831f
C1545 VREF.n5 VSS 0.0403831f
C1546 VREF.n6 VSS 0.0403831f
C1547 VREF.n7 VSS 0.0403831f
C1548 VREF.n8 VSS 0.0403831f
C1549 VREF.n9 VSS 0.0403831f
C1550 VREF.n10 VSS 0.0403831f
C1551 VREF.n11 VSS 0.0385882f
C1552 VREF.n12 VSS 0.0374573f
C1553 VREF.n13 VSS 0.0403831f
C1554 VREF.n14 VSS 0.0403831f
C1555 VREF.n15 VSS 0.0403831f
C1556 VREF.n16 VSS 0.0403831f
C1557 VREF.n17 VSS 0.0403831f
C1558 VREF.n18 VSS 0.0403831f
C1559 VREF.n19 VSS 0.0403831f
C1560 VREF.n20 VSS 0.0403831f
C1561 VREF.n21 VSS 0.0403831f
C1562 VREF.n22 VSS 0.0630974f
C1563 VREF.t0 VSS 0.0782482f
C1564 VREF.t1 VSS 0.0782482f
C1565 VREF.t2 VSS 0.0782482f
C1566 VREF.t3 VSS 0.0782482f
C1567 VREF.t4 VSS 0.0782482f
C1568 VREF.t5 VSS 0.0782482f
C1569 VREF.t6 VSS 0.0782482f
C1570 VREF.t7 VSS 0.0786086f
C1571 VREF.n23 VSS 0.0895176f
C1572 VREF.n24 VSS 0.0469674f
C1573 VREF.n25 VSS 0.0469674f
C1574 VREF.n26 VSS 0.0437333f
C1575 VREF.n27 VSS 0.0449663f
C1576 VREF.n28 VSS 0.0469674f
C1577 VREF.n29 VSS 0.0667725f
C1578 VREF.n30 VSS 0.230911f
C1579 VREF.t63 VSS 0.0624667f
C1580 VREF.t62 VSS 0.0624667f
C1581 VREF.t61 VSS 0.0624667f
C1582 VREF.t60 VSS 0.0624667f
C1583 VREF.t59 VSS 0.0624667f
C1584 VREF.t58 VSS 0.0624667f
C1585 VREF.t57 VSS 0.0624667f
C1586 VREF.t56 VSS 0.0624667f
C1587 VREF.t55 VSS 0.0624667f
C1588 VREF.t54 VSS 0.0624667f
C1589 VREF.t53 VSS 0.0624667f
C1590 VREF.t52 VSS 0.0624667f
C1591 VREF.t51 VSS 0.0624667f
C1592 VREF.t50 VSS 0.0624667f
C1593 VREF.t49 VSS 0.0624667f
C1594 VREF.t48 VSS 0.0624667f
C1595 VREF.t47 VSS 0.0624667f
C1596 VREF.t46 VSS 0.0624667f
C1597 VREF.t45 VSS 0.0624667f
C1598 VREF.t44 VSS 0.0626967f
C1599 VREF.n31 VSS 0.0769963f
C1600 VREF.n32 VSS 0.0403831f
C1601 VREF.n33 VSS 0.0403831f
C1602 VREF.n34 VSS 0.0403831f
C1603 VREF.n35 VSS 0.0403831f
C1604 VREF.n36 VSS 0.0403831f
C1605 VREF.n37 VSS 0.0403831f
C1606 VREF.n38 VSS 0.0403831f
C1607 VREF.n39 VSS 0.0403831f
C1608 VREF.n40 VSS 0.0385622f
C1609 VREF.n41 VSS 0.0374833f
C1610 VREF.n42 VSS 0.0403831f
C1611 VREF.n43 VSS 0.0403831f
C1612 VREF.n44 VSS 0.0403831f
C1613 VREF.n45 VSS 0.0403831f
C1614 VREF.n46 VSS 0.0403831f
C1615 VREF.n47 VSS 0.0403831f
C1616 VREF.n48 VSS 0.0403831f
C1617 VREF.n49 VSS 0.0630974f
C1618 VREF.n50 VSS 0.298987f
C1619 VREF.t19 VSS 0.0782482f
C1620 VREF.t18 VSS 0.0782482f
C1621 VREF.t17 VSS 0.0782482f
C1622 VREF.t16 VSS 0.0782482f
C1623 VREF.t15 VSS 0.0782482f
C1624 VREF.t14 VSS 0.0782482f
C1625 VREF.t13 VSS 0.0782482f
C1626 VREF.t12 VSS 0.0782482f
C1627 VREF.t11 VSS 0.0782482f
C1628 VREF.t10 VSS 0.0782482f
C1629 VREF.t9 VSS 0.0782482f
C1630 VREF.t8 VSS 0.0786086f
C1631 VREF.n51 VSS 0.0895176f
C1632 VREF.n52 VSS 0.0469674f
C1633 VREF.n53 VSS 0.0469674f
C1634 VREF.n54 VSS 0.0469674f
C1635 VREF.n55 VSS 0.0469674f
C1636 VREF.n56 VSS 0.0437333f
C1637 VREF.n57 VSS 0.0449663f
C1638 VREF.n58 VSS 0.0469674f
C1639 VREF.n59 VSS 0.0469674f
C1640 VREF.n60 VSS 0.0469674f
C1641 VREF.n61 VSS 0.0667725f
C1642 VREF.n62 VSS 0.3214f
C1643 VB2.t0 VSS 0.128738f
C1644 VB2.t1 VSS 0.128738f
C1645 VB2.t2 VSS 0.128738f
C1646 VB2.t3 VSS 0.128738f
C1647 VB2.t4 VSS 0.128738f
C1648 VB2.t5 VSS 0.128738f
C1649 VB2.t6 VSS 0.129366f
C1650 VB2.n0 VSS 0.150528f
C1651 VB2.n1 VSS 0.0790898f
C1652 VB2.n2 VSS 0.0790898f
C1653 VB2.n3 VSS 0.0734465f
C1654 VB2.n4 VSS 0.0756667f
C1655 VB2.n5 VSS 0.129406f
C1656 VB2.t13 VSS 0.128738f
C1657 VB2.t12 VSS 0.128738f
C1658 VB2.t11 VSS 0.128738f
C1659 VB2.t10 VSS 0.128738f
C1660 VB2.t9 VSS 0.128738f
C1661 VB2.t8 VSS 0.128738f
C1662 VB2.t7 VSS 0.129366f
C1663 VB2.n6 VSS 0.150528f
C1664 VB2.n7 VSS 0.0790898f
C1665 VB2.n8 VSS 0.0790898f
C1666 VB2.n9 VSS 0.0734465f
C1667 VB2.n10 VSS 0.0756667f
C1668 VB2.n11 VSS 0.129406f
C1669 VB2.n12 VSS 0.772062f
C1670 VBN.t0 VSS 0.062632f
C1671 VBN.t1 VSS 0.062632f
C1672 VBN.t2 VSS 0.062632f
C1673 VBN.t3 VSS 0.062632f
C1674 VBN.t4 VSS 0.062632f
C1675 VBN.t5 VSS 0.062632f
C1676 VBN.t6 VSS 0.062632f
C1677 VBN.t7 VSS 0.062632f
C1678 VBN.t8 VSS 0.062632f
C1679 VBN.t9 VSS 0.062632f
C1680 VBN.t10 VSS 0.062632f
C1681 VBN.t11 VSS 0.0641772f
C1682 VBN.n0 VSS 0.0862993f
C1683 VBN.n1 VSS 0.0464847f
C1684 VBN.n2 VSS 0.0464847f
C1685 VBN.n3 VSS 0.0464847f
C1686 VBN.n4 VSS 0.0464847f
C1687 VBN.n5 VSS 0.0444931f
C1688 VBN.n6 VSS 0.0424328f
C1689 VBN.n7 VSS 0.0464847f
C1690 VBN.n8 VSS 0.0464847f
C1691 VBN.n9 VSS 0.0464847f
C1692 VBN.n10 VSS 0.0721006f
C1693 VBN.t23 VSS 0.062632f
C1694 VBN.t24 VSS 0.062632f
C1695 VBN.t27 VSS 0.062632f
C1696 VBN.t28 VSS 0.062632f
C1697 VBN.t31 VSS 0.062632f
C1698 VBN.t32 VSS 0.062632f
C1699 VBN.t35 VSS 0.062632f
C1700 VBN.t36 VSS 0.062632f
C1701 VBN.t39 VSS 0.062632f
C1702 VBN.t40 VSS 0.062632f
C1703 VBN.t43 VSS 0.062632f
C1704 VBN.t44 VSS 0.0641772f
C1705 VBN.n11 VSS 0.098369f
C1706 VBN.n12 VSS 0.0585544f
C1707 VBN.n13 VSS 0.0585544f
C1708 VBN.n14 VSS 0.0585544f
C1709 VBN.n15 VSS 0.0585544f
C1710 VBN.n16 VSS 0.0535668f
C1711 VBN.n17 VSS 0.0574985f
C1712 VBN.n18 VSS 0.0585544f
C1713 VBN.n19 VSS 0.0585544f
C1714 VBN.n20 VSS 0.0585544f
C1715 VBN.n21 VSS 0.0821186f
C1716 VBN.n22 VSS 0.276444f
C1717 VBN.t21 VSS 0.062632f
C1718 VBN.t20 VSS 0.062632f
C1719 VBN.t19 VSS 0.062632f
C1720 VBN.t18 VSS 0.062632f
C1721 VBN.t17 VSS 0.062632f
C1722 VBN.t16 VSS 0.062632f
C1723 VBN.t15 VSS 0.062632f
C1724 VBN.t14 VSS 0.062632f
C1725 VBN.t13 VSS 0.062632f
C1726 VBN.t12 VSS 0.0641772f
C1727 VBN.n23 VSS 0.0862993f
C1728 VBN.n24 VSS 0.0464847f
C1729 VBN.n25 VSS 0.0464847f
C1730 VBN.n26 VSS 0.0464847f
C1731 VBN.n27 VSS 0.0444931f
C1732 VBN.n28 VSS 0.0424328f
C1733 VBN.n29 VSS 0.0464847f
C1734 VBN.n30 VSS 0.0464847f
C1735 VBN.n31 VSS 0.0721006f
C1736 VBN.n32 VSS 0.225822f
C1737 VBN.t45 VSS 0.062632f
C1738 VBN.t42 VSS 0.062632f
C1739 VBN.t41 VSS 0.062632f
C1740 VBN.t38 VSS 0.062632f
C1741 VBN.t37 VSS 0.062632f
C1742 VBN.t34 VSS 0.062632f
C1743 VBN.t33 VSS 0.062632f
C1744 VBN.t30 VSS 0.062632f
C1745 VBN.t29 VSS 0.062632f
C1746 VBN.t26 VSS 0.062632f
C1747 VBN.t25 VSS 0.062632f
C1748 VBN.t22 VSS 0.0682033f
C1749 VBN.n33 VSS 0.106413f
C1750 VBN.n34 VSS 0.0585544f
C1751 VBN.n35 VSS 0.0585544f
C1752 VBN.n36 VSS 0.0585544f
C1753 VBN.n37 VSS 0.0585544f
C1754 VBN.n38 VSS 0.0445188f
C1755 VBN.n39 VSS 0.0544854f
C1756 VBN.n40 VSS 0.0585544f
C1757 VBN.n41 VSS 0.0585544f
C1758 VBN.n42 VSS 0.0585544f
C1759 VBN.n43 VSS 0.0841789f
C1760 VBN.n44 VSS 0.262563f
C1761 EN.t2 VSS 0.0902456f
C1762 EN.t1 VSS 0.0510434f
C1763 EN.n0 VSS 0.784291f
C1764 EN.t3 VSS 0.0902456f
C1765 EN.n1 VSS 0.25831f
C1766 EN.t0 VSS 0.0766389f
C1767 EN.n2 VSS 0.496031f
C1768 OUT.t1 VSS 0.0409531f
C1769 OUT.t7 VSS 0.0409531f
C1770 OUT.n0 VSS 0.0859333f
C1771 OUT.t8 VSS 0.0409531f
C1772 OUT.t0 VSS 0.0409531f
C1773 OUT.n1 VSS 0.0859333f
C1774 OUT.n2 VSS 0.0444057f
C1775 OUT.t3 VSS 0.0511927f
C1776 OUT.t9 VSS 0.0511927f
C1777 OUT.n3 VSS 0.109527f
C1778 OUT.t4 VSS 0.0511927f
C1779 OUT.t5 VSS 0.0511927f
C1780 OUT.n4 VSS 0.109527f
C1781 OUT.t6 VSS 0.0511927f
C1782 OUT.t2 VSS 0.0511927f
C1783 OUT.n5 VSS 0.109527f
C1784 OUT.n6 VSS 0.0609974f
C1785 OUT.n7 VSS 0.146979f
Crep0 fa.0.n0 tp.0.n0 25.37f
Crep1 VB2 tp.0.n0 0.05309f
Crep2 VDD tp.0.n0 11.3411f
Crep3 VREF tp.0.n0 14.9051f
Crep4 fb.0.n0 tp.0.n0 25.7432f
Crep5 VBP tp.0.n0 3.37779f
Crep6 gp.0.n0 tp.0.n0 12.8915f
Crep7 gn.0.n0 tp.0.n0 13.4751f
.ends lvds_lane
