* lvds_lane: parasitic R (extresist, tolerance 10) on all nets; C from the C-coupled extraction (check.rc_repair, T11: Magic 8.3.636 extresist counts every coupling twice)
* GENERATED by layout/macro/run_macro.py (T10) from a GDS with sha256 76388d798e912e38ec1a8b2ec6028ab2e4ddf5ef093cc082a891e6fab623c3f2 -- do not edit by hand.
* Ports in the order of subckt lvds_lane of netlist/lvds_rx_lvs_ref.spice (Magic's own order was: INP INN OUT EN VBN VB2 VREF VBP VDD VSS).
* NGSPICE file created from lvds_lane.ext - technology: gf180mcuD

.subckt lvds_lane VDD VSS INP INN EN VBN VBP VB2 VREF OUT
X0 tp.0.t0 gn.0.t18 fb.0.t63 tp.0.t0 pfet_03v3 ad=1.248p pd=5.32u as=1.248p ps=5.32u w=4.8u l=0.4u
X1 ob.0.t14 VREF.t16 tn.0.t15 VSS.t35 nfet_03v3 ad=1.235p pd=5.27u as=1.235p ps=5.27u w=4.75u l=0.5u
X2 oa.0.t22 VREF.t2 tn.0.t21 VSS.t49 nfet_03v3 ad=1.235p pd=5.27u as=1.235p ps=5.27u w=4.75u l=0.5u
X3 tp.0.t0 VREF.t63 fb.0.t12 tp.0.t0 pfet_03v3 ad=1.248p pd=5.32u as=2.112p ps=10.48u w=4.8u l=0.4u
X4 fb.0.t59 gn.0.t11 tp.0.t0 tp.0.t0 pfet_03v3 ad=1.248p pd=5.32u as=1.248p ps=5.32u w=4.8u l=0.4u
X5 oa.0.t16 VREF.t14 tn.0.t29 VSS.t37 nfet_03v3 ad=1.235p pd=5.27u as=1.235p ps=5.27u w=4.75u l=0.5u
X6 ob.0.t20 VREF.t4 tn.0.t13 VSS.t47 nfet_03v3 ad=1.235p pd=5.27u as=1.235p ps=5.27u w=4.75u l=0.5u
X7 tn.0.t44 VBN.t8 VSS.t196 VSS.t195 nfet_03v3 ad=0.65p pd=3.02u as=0.65p ps=3.02u w=2.5u l=1u
X8 tp.0.t0 VREF.t49 fa.0.t23 tp.0.t0 pfet_03v3 ad=1.248p pd=5.32u as=1.248p ps=5.32u w=4.8u l=0.4u
X9 ts.0.t6 VBN.t2 VSS.t210 VSS.t209 nfet_03v3 ad=0.65p pd=3.02u as=0.65p ps=3.02u w=2.5u l=1u
X10 tp.0.t0 VREF.t33 fa.0.t31 tp.0.t0 pfet_03v3 ad=1.248p pd=5.32u as=1.248p ps=5.32u w=4.8u l=0.4u
X11 n3a.0.t9 d2a.0.t29 VDD.t141 VDD.t140 pfet_03v3 ad=0.52p pd=2.52u as=0.52p ps=2.52u w=2u l=0.4u
X12 d2b.0.t5 d2b.0.t4 VDD.t130 VDD.t129 pfet_03v3 ad=0.52p pd=2.52u as=0.52p ps=2.52u w=2u l=0.4u
X13 VDD.t167 d2b.0.t25 d3.0.t7 VDD.t166 pfet_03v3 ad=0.52p pd=2.52u as=0.52p ps=2.52u w=2u l=0.4u
X14 fb.0.t13 VREF.t60 tp.0.t0 tp.0.t0 pfet_03v3 ad=1.248p pd=5.32u as=1.248p ps=5.32u w=4.8u l=0.4u
X15 VSS.t182 VBN.t17 fb.0.t51 VSS.t181 nfet_03v3 ad=0.65p pd=3.02u as=0.65p ps=3.02u w=2.5u l=1u
X16 VSS.t132 VBN.t5 ts.0.t3 VSS.t131 nfet_03v3 ad=0.65p pd=3.02u as=0.65p ps=3.02u w=2.5u l=1u
X17 tp.0.t0 gn.0.t12 fb.0.t4 tp.0.t0 pfet_03v3 ad=1.248p pd=5.32u as=1.248p ps=5.32u w=4.8u l=0.4u
X18 VSS.t186 VBN.t13 tn.0.t39 VSS.t185 nfet_03v3 ad=0.65p pd=3.02u as=0.65p ps=3.02u w=2.5u l=1u
X19 tn.0.t3 gp.0.t9 oa.0.t3 VSS.t9 nfet_03v3 ad=1.235p pd=5.27u as=1.235p ps=5.27u w=4.75u l=0.5u
X20 VDD.t73 VDD.t71 d2b.0.t12 VDD.t72 pfet_03v3 ad=0.88p pd=4.88u as=0.52p ps=2.52u w=2u l=0.4u
X21 gp.0.t0 INP.t0 VDD.t70 ppolyf_u r_width=5u r_length=1.8u
X22 tp.0.t0 VREF.t47 fb.0.t20 tp.0.t0 pfet_03v3 ad=1.248p pd=5.32u as=1.248p ps=5.32u w=4.8u l=0.4u
X23 ob.0.t5 rlb_m1.0.t0 VSS.t17 ppolyf_u_1k r_width=2u r_length=9.11u
X24 fa.0.t13 VB2.t9 oa.0.t9 VSS.t22 nfet_03v3 ad=1.1752p pd=5.04u as=1.1752p ps=5.04u w=4.52u l=0.5u
X25 ob.0.t12 VB2.t3 fb.0.t8 VSS.t28 nfet_03v3 ad=1.1752p pd=5.04u as=1.1752p ps=5.04u w=4.52u l=0.5u
X26 VDD.t189 EN.t2 d2b.0.t19 VDD.t188 pfet_03v3 ad=0.52p pd=2.52u as=0.52p ps=2.52u w=2u l=0.5u
X27 VDD.t29 VBP.t7 tp.0.t0 VDD.t28 pfet_03v3 ad=1.3p pd=5.52u as=1.3p ps=5.52u w=5u l=1u
X28 fa.0.t15 VB2.t7 oa.0.t7 VSS.t24 nfet_03v3 ad=1.1752p pd=5.04u as=1.1752p ps=5.04u w=4.52u l=0.5u
X29 ob.0.t10 VB2.t5 fb.0.t6 VSS.t26 nfet_03v3 ad=1.1752p pd=5.04u as=1.1752p ps=5.04u w=4.52u l=0.5u
X30 tn.0.t51 gn.0.t8 ob.0.t28 VSS.t244 nfet_03v3 ad=1.235p pd=5.27u as=1.235p ps=5.27u w=4.75u l=0.5u
X31 VDD.t126 i1.0.t5 i2.0.t4 VDD.t125 pfet_03v3 ad=0.975p pd=4.27u as=0.975p ps=4.27u w=3.75u l=0.28u
X32 VDD.t191 EN.t3 d2a.0.t19 VDD.t190 pfet_03v3 ad=0.52p pd=2.52u as=0.52p ps=2.52u w=2u l=0.5u
X33 tp.0.t0 VREF.t29 fa.0.t33 tp.0.t0 pfet_03v3 ad=1.248p pd=5.32u as=1.248p ps=5.32u w=4.8u l=0.4u
X34 ob.0.t25 VSS.t77 VSS.t79 VSS.t78 nfet_03v3 ad=1.1752p pd=5.04u as=1.9888p ps=9.92u w=4.52u l=0.5u
X35 tn.0.t48 gp.0.t7 oa.0.t27 VSS.t220 nfet_03v3 ad=1.235p pd=5.27u as=1.235p ps=5.27u w=4.75u l=0.5u
X36 VDD.t128 nd.0.t6 i1.0.t2 VDD.t127 pfet_03v3 ad=0.962p pd=4.22u as=0.962p ps=4.22u w=3.7u l=0.28u
X37 tp.0.t0 VBP.t10 VDD.t23 VDD.t22 pfet_03v3 ad=1.3p pd=5.52u as=1.3p ps=5.52u w=5u l=1u
X38 n3a.0.t4 VDD.t83 VDD.t85 VDD.t84 pfet_03v3 ad=0.52p pd=2.52u as=0.88p ps=4.88u w=2u l=0.4u
X39 VDD.t133 rla_m1.0.t1 VSS.t221 ppolyf_u_1k r_width=2u r_length=9.11u
X40 fa.0.t51 VBN.t32 VSS.t148 VSS.t147 nfet_03v3 ad=0.65p pd=3.02u as=0.65p ps=3.02u w=2.5u l=1u
X41 fb.0.t48 VBN.t22 VSS.t168 VSS.t167 nfet_03v3 ad=0.65p pd=3.02u as=0.65p ps=3.02u w=2.5u l=1u
X42 d2b.0.t9 d2b.0.t8 VDD.t179 VDD.t178 pfet_03v3 ad=0.52p pd=2.52u as=0.52p ps=2.52u w=2u l=0.4u
X43 VDD.t145 d2b.0.t29 d3.0.t4 VDD.t144 pfet_03v3 ad=0.52p pd=2.52u as=0.52p ps=2.52u w=2u l=0.4u
X44 ts.0.t0 sa.0.t0 VSS.t3 ppolyf_u_1k r_width=2u r_length=8.86u
X45 tp.0.t0 gp.0.t19 fa.0.t40 tp.0.t0 pfet_03v3 ad=1.248p pd=5.32u as=1.248p ps=5.32u w=4.8u l=0.4u
X46 i2.0.t2 VDD.t113 VDD.t115 VDD.t114 pfet_03v3 ad=0.975p pd=4.27u as=1.65p ps=8.38u w=3.75u l=0.28u
X47 VDD.t61 d2a.0.t13 d2a.0.t14 VDD.t60 pfet_03v3 ad=0.52p pd=2.52u as=0.52p ps=2.52u w=2u l=0.4u
X48 d3.0.t8 d2b.0.t26 VDD.t169 VDD.t168 pfet_03v3 ad=0.52p pd=2.52u as=0.52p ps=2.52u w=2u l=0.4u
X49 oa.0.t20 VREF.t6 tn.0.t25 VSS.t45 nfet_03v3 ad=1.235p pd=5.27u as=1.235p ps=5.27u w=4.75u l=0.5u
X50 VSS.t213 i2.0.t11 OUT.t2 VSS.t212 nfet_03v3 ad=1.04p pd=4.52u as=1.04p ps=4.52u w=4u l=0.28u
X51 VDD.t112 VDD.t110 VDD.t112 VDD.t111 pfet_03v3 ad=0.962p pd=4.22u as=0 ps=0 w=3.7u l=0.28u
X52 fb.0.t27 VREF.t32 tp.0.t0 tp.0.t0 pfet_03v3 ad=1.248p pd=5.32u as=1.248p ps=5.32u w=4.8u l=0.4u
X53 VSS.t138 VBN.t37 fb.0.t41 VSS.t137 nfet_03v3 ad=0.65p pd=3.02u as=0.65p ps=3.02u w=2.5u l=1u
X54 OUT.t4 i2.0.t8 VDD.t185 VDD.t184 pfet_03v3 ad=1.3p pd=5.52u as=1.3p ps=5.52u w=5u l=0.28u
X55 VDD.t82 VDD.t80 tp.0.t0 VDD.t81 pfet_03v3 ad=2.2p pd=10.88u as=1.3p ps=5.52u w=5u l=1u
X56 tp.0.t0 VREF.t61 fa.0.t17 tp.0.t0 pfet_03v3 ad=1.248p pd=5.32u as=1.248p ps=5.32u w=4.8u l=0.4u
X57 ts.0.t9 sb.0.t1 VSS.t214 ppolyf_u_1k r_width=2u r_length=8.86u
X58 VSS.t226 VSS.t227 VSS.t225 ppolyf_u_1k r_width=2u r_length=9.11u
X59 tp.0.t0 VREF.t21 fa.0.t37 tp.0.t0 pfet_03v3 ad=1.248p pd=5.32u as=1.248p ps=5.32u w=4.8u l=0.4u
X60 tn.0.t18 VREF.t11 ob.0.t17 VSS.t40 nfet_03v3 ad=1.235p pd=5.27u as=1.235p ps=5.27u w=4.75u l=0.5u
X61 tp.0.t0 VBP.t14 VDD.t15 VDD.t14 pfet_03v3 ad=1.3p pd=5.52u as=1.3p ps=5.52u w=5u l=1u
X62 tp.0.t0 gp.0.t27 fa.0.t62 tp.0.t0 pfet_03v3 ad=1.248p pd=5.32u as=1.248p ps=5.32u w=4.8u l=0.4u
X63 fa.0.t30 VREF.t34 tp.0.t0 tp.0.t0 pfet_03v3 ad=1.248p pd=5.32u as=1.248p ps=5.32u w=4.8u l=0.4u
X64 OUT.t7 VSS.t125 VSS.t127 VSS.t126 nfet_03v3 ad=1.04p pd=4.52u as=1.76p ps=8.88u w=4u l=0.28u
X65 tn.0.t4 gp.0.t1 oa.0.t4 VSS.t10 nfet_03v3 ad=1.235p pd=5.27u as=1.235p ps=5.27u w=4.75u l=0.5u
X66 VSS.t118 VSS.t116 VSS.t118 VSS.t117 nfet_03v3 ad=0.78p pd=3.52u as=0 ps=0 w=3u l=0.28u
X67 VDD.t187 i2.0.t9 OUT.t5 VDD.t186 pfet_03v3 ad=1.3p pd=5.52u as=1.3p ps=5.52u w=5u l=0.28u
X68 VSS.t76 VSS.t74 fa.0.t47 VSS.t75 nfet_03v3 ad=1.1p pd=5.88u as=0.65p ps=3.02u w=2.5u l=1u
X69 VDD.t161 d2b.0.t22 d2a.0.t3 VDD.t160 pfet_03v3 ad=0.52p pd=2.52u as=0.52p ps=2.52u w=2u l=0.4u
X70 VSS.t82 VSS.t80 fb.0.t38 VSS.t81 nfet_03v3 ad=1.9888p pd=9.92u as=1.1752p ps=5.04u w=4.52u l=0.5u
X71 nm.0.t0 d3.0.t11 nd.0.t2 VSS.t211 nfet_03v3 ad=0.52p pd=2.52u as=0.52p ps=2.52u w=2u l=0.28u
X72 VDD.t5 VBP.t19 tp.0.t0 VDD.t4 pfet_03v3 ad=1.3p pd=5.52u as=1.3p ps=5.52u w=5u l=1u
X73 tp.0.t0 gn.0.t26 fb.0.t60 tp.0.t0 pfet_03v3 ad=1.248p pd=5.32u as=1.248p ps=5.32u w=4.8u l=0.4u
X74 fa.0.t42 gp.0.t26 tp.0.t0 tp.0.t0 pfet_03v3 ad=1.248p pd=5.32u as=1.248p ps=5.32u w=4.8u l=0.4u
X75 tp.0.t0 gn.0.t14 fb.0.t37 tp.0.t0 pfet_03v3 ad=1.248p pd=5.32u as=1.248p ps=5.32u w=4.8u l=0.4u
X76 d2a.0.t12 d2a.0.t11 VDD.t59 VDD.t58 pfet_03v3 ad=0.52p pd=2.52u as=0.52p ps=2.52u w=2u l=0.4u
X77 tp.0.t0 VBP.t4 VDD.t35 VDD.t34 pfet_03v3 ad=1.3p pd=5.52u as=1.3p ps=5.52u w=5u l=1u
X78 fb.0.t3 gn.0.t19 tp.0.t0 tp.0.t0 pfet_03v3 ad=1.248p pd=5.32u as=1.248p ps=5.32u w=4.8u l=0.4u
X79 n3a.0.t11 d2a.0.t31 VDD.t175 VDD.t174 pfet_03v3 ad=0.52p pd=2.52u as=0.52p ps=2.52u w=2u l=0.4u
X80 VSS.t190 VBN.t11 tn.0.t41 VSS.t189 nfet_03v3 ad=0.65p pd=3.02u as=0.65p ps=3.02u w=2.5u l=1u
X81 ob.0.t22 VREF.t0 tn.0.t20 VSS.t51 nfet_03v3 ad=2.09p pd=10.38u as=1.235p ps=5.27u w=4.75u l=0.5u
X82 VSS.t61 VSS.t59 ts.0.t2 VSS.t60 nfet_03v3 ad=1.1p pd=5.88u as=0.65p ps=3.02u w=2.5u l=1u
X83 VSS.t106 VSS.t104 d3.0.t0 VSS.t105 nfet_03v3 ad=1.1396p pd=6.06u as=0.6734p ps=3.11u w=2.59u l=0.28u
X84 VDD.t155 rlb_m1.0.t1 VSS.t235 ppolyf_u_1k r_width=2u r_length=9.11u
X85 fa.0.t16 VREF.t62 tp.0.t0 tp.0.t0 pfet_03v3 ad=1.248p pd=5.32u as=1.248p ps=5.32u w=4.8u l=0.4u
X86 fa.0.t4 gp.0.t20 tp.0.t0 tp.0.t0 pfet_03v3 ad=1.248p pd=5.32u as=1.248p ps=5.32u w=4.8u l=0.4u
X87 fb.0.t33 VREF.t20 tp.0.t0 tp.0.t0 pfet_03v3 ad=2.112p pd=10.48u as=1.248p ps=5.32u w=4.8u l=0.4u
X88 fa.0.t53 VBN.t28 VSS.t156 VSS.t155 nfet_03v3 ad=0.65p pd=3.02u as=0.65p ps=3.02u w=2.5u l=1u
X89 tn.0.t31 gp.0.t5 oa.0.t24 VSS.t52 nfet_03v3 ad=1.235p pd=5.27u as=1.235p ps=5.27u w=4.75u l=0.5u
X90 VDD.t88 VDD.t86 n3a.0.t5 VDD.t87 pfet_03v3 ad=0.88p pd=4.88u as=0.52p ps=2.52u w=2u l=0.4u
X91 VDD.t25 VBP.t9 tp.0.t0 VDD.t24 pfet_03v3 ad=1.3p pd=5.52u as=1.3p ps=5.52u w=5u l=1u
X92 d2a.0.t0 VSS.t95 VSS.t97 VSS.t96 nfet_03v3 ad=1.0036p pd=4.38u as=1.6984p ps=8.6u w=3.86u l=0.5u
X93 nd.0.t3 VDD.t101 VDD.t103 VDD.t102 pfet_03v3 ad=0.78p pd=3.52u as=1.32p ps=6.88u w=3u l=0.28u
X94 VSS.t103 VSS.t101 sb.0.t0 VSS.t102 nfet_03v3 ad=1.6984p pd=8.6u as=1.0036p ps=4.38u w=3.86u l=0.5u
X95 fa.0.t41 gp.0.t28 tp.0.t0 tp.0.t0 pfet_03v3 ad=1.248p pd=5.32u as=1.248p ps=5.32u w=4.8u l=0.4u
X96 fb.0.t39 gn.0.t13 tp.0.t0 tp.0.t0 pfet_03v3 ad=1.248p pd=5.32u as=1.248p ps=5.32u w=4.8u l=0.4u
X97 tn.0.t35 VSS.t83 VSS.t85 VSS.t84 nfet_03v3 ad=0.65p pd=3.02u as=1.1p ps=5.88u w=2.5u l=1u
X98 d2b.0.t17 ob.0.t30 sb.0.t3 VSS.t232 nfet_03v3 ad=1.0036p pd=4.38u as=1.0036p ps=4.38u w=3.86u l=0.5u
X99 tn.0.t24 VREF.t9 oa.0.t19 VSS.t42 nfet_03v3 ad=1.235p pd=5.27u as=1.235p ps=5.27u w=4.75u l=0.5u
X100 d2a.0.t8 oa.0.t30 sa.0.t2 VSS.t228 nfet_03v3 ad=1.0036p pd=4.38u as=1.0036p ps=4.38u w=3.86u l=0.5u
X101 fb.0.t25 VREF.t36 tp.0.t0 tp.0.t0 pfet_03v3 ad=1.248p pd=5.32u as=1.248p ps=5.32u w=4.8u l=0.4u
X102 tn.0.t8 gn.0.t10 ob.0.t3 VSS.t14 nfet_03v3 ad=1.235p pd=5.27u as=1.235p ps=5.27u w=4.75u l=0.5u
X103 tn.0.t49 gn.0.t2 ob.0.t27 VSS.t242 nfet_03v3 ad=1.235p pd=5.27u as=1.235p ps=5.27u w=4.75u l=0.5u
X104 VSS.t5 VSS.t6 VSS.t4 ppolyf_u_1k r_width=2u r_length=8.86u
X105 tp.0.t0 VREF.t45 fa.0.t25 tp.0.t0 pfet_03v3 ad=1.248p pd=5.32u as=1.248p ps=5.32u w=4.8u l=0.4u
X106 fa.0.t36 VREF.t22 tp.0.t0 tp.0.t0 pfet_03v3 ad=1.248p pd=5.32u as=1.248p ps=5.32u w=4.8u l=0.4u
D0 gn.0.t33 VDD.t154 diode_pd2nw_03v3 pj=26u area=40p
X107 fb.0.t61 gn.0.t27 tp.0.t0 tp.0.t0 pfet_03v3 ad=1.248p pd=5.32u as=1.248p ps=5.32u w=4.8u l=0.4u
X108 tn.0.t0 gp.0.t3 oa.0.t0 VSS.t0 nfet_03v3 ad=1.235p pd=5.27u as=1.235p ps=5.27u w=4.75u l=0.5u
X109 fa.0.t38 gp.0.t14 tp.0.t0 tp.0.t0 pfet_03v3 ad=1.248p pd=5.32u as=1.248p ps=5.32u w=4.8u l=0.4u
X110 fb.0.t40 VBN.t38 VSS.t136 VSS.t135 nfet_03v3 ad=0.65p pd=3.02u as=0.65p ps=3.02u w=2.5u l=1u
X111 tn.0.t46 VBN.t6 VSS.t200 VSS.t199 nfet_03v3 ad=0.65p pd=3.02u as=0.65p ps=3.02u w=2.5u l=1u
X112 fb.0.t44 VBN.t30 VSS.t152 VSS.t151 nfet_03v3 ad=0.65p pd=3.02u as=0.65p ps=3.02u w=2.5u l=1u
X113 ts.0.t4 VBN.t4 VSS.t206 VSS.t205 nfet_03v3 ad=0.65p pd=3.02u as=0.65p ps=3.02u w=2.5u l=1u
D1 VSS.t234 gn.0.t34 diode_nd2ps_03v3 pj=26u area=40p
X114 tp.0.t0 gn.0.t32 fb.0.t55 tp.0.t0 pfet_03v3 ad=1.248p pd=5.32u as=1.248p ps=5.32u w=4.8u l=0.4u
X115 oa.0.t8 VB2.t10 fa.0.t12 VSS.t21 nfet_03v3 ad=1.1752p pd=5.04u as=1.1752p ps=5.04u w=4.52u l=0.5u
X116 VDD.t153 d2a.0.t21 d2b.0.t15 VDD.t152 pfet_03v3 ad=0.52p pd=2.52u as=0.52p ps=2.52u w=2u l=0.4u
X117 VDD.t76 VDD.t74 VDD.t76 VDD.t75 pfet_03v3 ad=0.52p pd=2.52u as=0 ps=0 w=2u l=0.5u
X118 VSS.t142 VBN.t35 fa.0.t50 VSS.t141 nfet_03v3 ad=0.65p pd=3.02u as=0.65p ps=3.02u w=2.5u l=1u
X119 VSS.t174 VBN.t19 fa.0.t58 VSS.t173 nfet_03v3 ad=0.65p pd=3.02u as=0.65p ps=3.02u w=2.5u l=1u
X120 n3a.0.t0 d2a.0.t25 VDD.t57 VDD.t56 pfet_03v3 ad=0.52p pd=2.52u as=0.52p ps=2.52u w=2u l=0.4u
X121 tp.0.t0 gp.0.t25 fa.0.t5 tp.0.t0 pfet_03v3 ad=1.248p pd=5.32u as=1.248p ps=5.32u w=4.8u l=0.4u
X122 tp.0.t0 gp.0.t15 fa.0.t2 tp.0.t0 pfet_03v3 ad=1.248p pd=5.32u as=1.248p ps=5.32u w=4.8u l=0.4u
X123 fb.0.t0 gn.0.t15 tp.0.t0 tp.0.t0 pfet_03v3 ad=1.248p pd=5.32u as=1.248p ps=5.32u w=4.8u l=0.4u
X124 oa.0.t2 rla_m1.0.t0 VSS.t7 ppolyf_u_1k r_width=2u r_length=9.11u
X125 fa.0.t46 VSS.t71 VSS.t73 VSS.t72 nfet_03v3 ad=0.65p pd=3.02u as=1.1p ps=5.88u w=2.5u l=1u
X126 tn.0.t16 VREF.t15 ob.0.t15 VSS.t36 nfet_03v3 ad=1.235p pd=5.27u as=1.235p ps=5.27u w=4.75u l=0.5u
X127 tp.0.t0 VBP.t12 VDD.t19 VDD.t18 pfet_03v3 ad=1.3p pd=5.52u as=1.3p ps=5.52u w=5u l=1u
X128 VSS.t146 VBN.t33 fb.0.t43 VSS.t145 nfet_03v3 ad=0.65p pd=3.02u as=0.65p ps=3.02u w=2.5u l=1u
X129 VDD.t9 VBP.t17 tp.0.t0 VDD.t8 pfet_03v3 ad=1.3p pd=5.52u as=1.3p ps=5.52u w=5u l=1u
X130 VDD.t37 VBP.t3 tp.0.t0 VDD.t36 pfet_03v3 ad=1.3p pd=5.52u as=1.3p ps=5.52u w=5u l=1u
X131 fa.0.t24 VREF.t46 tp.0.t0 tp.0.t0 pfet_03v3 ad=1.248p pd=5.32u as=1.248p ps=5.32u w=4.8u l=0.4u
X132 tp.0.t0 VREF.t35 fb.0.t26 tp.0.t0 pfet_03v3 ad=1.248p pd=5.32u as=1.248p ps=5.32u w=4.8u l=0.4u
X133 gn.0.t0 INN.t0 VDD.t45 ppolyf_u r_width=5u r_length=1.8u
X134 fa.0.t18 VREF.t58 tp.0.t0 tp.0.t0 pfet_03v3 ad=1.248p pd=5.32u as=1.248p ps=5.32u w=4.8u l=0.4u
X135 tp.0.t0 VBP.t6 VDD.t31 VDD.t30 pfet_03v3 ad=1.3p pd=5.52u as=1.3p ps=5.52u w=5u l=1u
X136 tp.0.t0 gp.0.t13 fa.0.t43 tp.0.t0 pfet_03v3 ad=1.248p pd=5.32u as=1.248p ps=5.32u w=4.8u l=0.4u
X137 tp.0.t0 VDD.t77 VDD.t79 VDD.t78 pfet_03v3 ad=1.3p pd=5.52u as=2.2p ps=10.88u w=5u l=1u
X138 fb.0.t21 VREF.t44 tp.0.t0 tp.0.t0 pfet_03v3 ad=1.248p pd=5.32u as=1.248p ps=5.32u w=4.8u l=0.4u
X139 fa.0.t28 VREF.t38 tp.0.t0 tp.0.t0 pfet_03v3 ad=1.248p pd=5.32u as=1.248p ps=5.32u w=4.8u l=0.4u
X140 oa.0.t10 VB2.t8 fa.0.t14 VSS.t23 nfet_03v3 ad=1.1752p pd=5.04u as=1.1752p ps=5.04u w=4.52u l=0.5u
X141 sb.0.t4 ob.0.t31 d2b.0.t18 VSS.t233 nfet_03v3 ad=1.0036p pd=4.38u as=1.0036p ps=4.38u w=3.86u l=0.5u
X142 VDD.t41 VBP.t1 tp.0.t0 VDD.t40 pfet_03v3 ad=1.3p pd=5.52u as=1.3p ps=5.52u w=5u l=1u
X143 VSS.t70 VSS.t68 fa.0.t45 VSS.t69 nfet_03v3 ad=1.9888p pd=9.92u as=1.1752p ps=5.04u w=4.52u l=0.5u
X144 VDD.t181 d2b.0.t10 d2b.0.t11 VDD.t180 pfet_03v3 ad=0.52p pd=2.52u as=0.52p ps=2.52u w=2u l=0.4u
X145 d3.0.t5 d2b.0.t30 VDD.t147 VDD.t146 pfet_03v3 ad=0.52p pd=2.52u as=0.52p ps=2.52u w=2u l=0.4u
X146 tp.0.t0 VREF.t55 fb.0.t16 tp.0.t0 pfet_03v3 ad=1.248p pd=5.32u as=1.248p ps=5.32u w=4.8u l=0.4u
X147 fb.0.t5 VB2.t6 ob.0.t6 VSS.t25 nfet_03v3 ad=1.1752p pd=5.04u as=1.1752p ps=5.04u w=4.52u l=0.5u
X148 tn.0.t38 VBN.t14 VSS.t184 VSS.t183 nfet_03v3 ad=0.65p pd=3.02u as=0.65p ps=3.02u w=2.5u l=1u
X149 ob.0.t2 gn.0.t7 tn.0.t7 VSS.t13 nfet_03v3 ad=1.235p pd=5.27u as=1.235p ps=5.27u w=4.75u l=0.5u
D2 VSS.t8 gp.0.t33 diode_nd2ps_03v3 pj=26u area=40p
X150 OUT.t9 VDD.t119 VDD.t121 VDD.t120 pfet_03v3 ad=1.3p pd=5.52u as=2.2p ps=10.88u w=5u l=0.28u
X151 VDD.t135 d2a.0.t26 n3a.0.t6 VDD.t134 pfet_03v3 ad=0.52p pd=2.52u as=0.52p ps=2.52u w=2u l=0.4u
X152 fa.0.t3 gp.0.t32 tp.0.t0 tp.0.t0 pfet_03v3 ad=1.248p pd=5.32u as=1.248p ps=5.32u w=4.8u l=0.4u
X153 tp.0.t0 gp.0.t31 fa.0.t61 tp.0.t0 pfet_03v3 ad=1.248p pd=5.32u as=1.248p ps=5.32u w=4.8u l=0.4u
X154 fb.0.t23 VREF.t40 tp.0.t0 tp.0.t0 pfet_03v3 ad=1.248p pd=5.32u as=1.248p ps=5.32u w=4.8u l=0.4u
X155 VSS.t198 VBN.t7 tn.0.t45 VSS.t197 nfet_03v3 ad=0.65p pd=3.02u as=0.65p ps=3.02u w=2.5u l=1u
X156 VSS.t216 i1.0.t6 i2.0.t5 VSS.t215 nfet_03v3 ad=0.78p pd=3.52u as=0.78p ps=3.52u w=3u l=0.28u
X157 VSS.t241 nd.0.t7 i1.0.t3 VSS.t240 nfet_03v3 ad=0.39p pd=2.02u as=0.39p ps=2.02u w=1.5u l=0.28u
X158 VSS.t246 EN.t1 nm.0.t1 VSS.t245 nfet_03v3 ad=0.52p pd=2.52u as=0.52p ps=2.52u w=2u l=0.28u
D3 gp.0.t34 VDD.t44 diode_pd2nw_03v3 pj=26u area=40p
X159 fa.0.t55 VBN.t24 VSS.t164 VSS.t163 nfet_03v3 ad=0.65p pd=3.02u as=0.65p ps=3.02u w=2.5u l=1u
X160 tn.0.t19 VREF.t19 ob.0.t13 VSS.t32 nfet_03v3 ad=1.235p pd=5.27u as=2.09p ps=10.38u w=4.75u l=0.5u
X161 tn.0.t30 VREF.t13 oa.0.t17 VSS.t38 nfet_03v3 ad=1.235p pd=5.27u as=1.235p ps=5.27u w=4.75u l=0.5u
X162 nd.0.t0 VSS.t110 VSS.t112 VSS.t111 nfet_03v3 ad=0.52p pd=2.52u as=0.88p ps=4.88u w=2u l=0.28u
X163 tn.0.t5 gn.0.t4 ob.0.t1 VSS.t11 nfet_03v3 ad=1.235p pd=5.27u as=1.235p ps=5.27u w=4.75u l=0.5u
X164 tn.0.t12 VREF.t7 ob.0.t19 VSS.t44 nfet_03v3 ad=1.235p pd=5.27u as=1.235p ps=5.27u w=4.75u l=0.5u
X165 tp.0.t0 gp.0.t23 fa.0.t39 tp.0.t0 pfet_03v3 ad=1.248p pd=5.32u as=1.248p ps=5.32u w=4.8u l=0.4u
X166 ts.0.t1 VSS.t86 VSS.t88 VSS.t87 nfet_03v3 ad=0.65p pd=3.02u as=1.1p ps=5.88u w=2.5u l=1u
X167 tp.0.t0 gn.0.t20 fb.0.t56 tp.0.t0 pfet_03v3 ad=1.248p pd=5.32u as=1.248p ps=5.32u w=4.8u l=0.4u
X168 VSS.t158 VBN.t27 fa.0.t54 VSS.t157 nfet_03v3 ad=0.65p pd=3.02u as=0.65p ps=3.02u w=2.5u l=1u
X169 tn.0.t40 VBN.t12 VSS.t188 VSS.t187 nfet_03v3 ad=0.65p pd=3.02u as=0.65p ps=3.02u w=2.5u l=1u
X170 d2a.0.t16 d2a.0.t15 VDD.t47 VDD.t46 pfet_03v3 ad=0.52p pd=2.52u as=0.52p ps=2.52u w=2u l=0.4u
X171 tp.0.t0 VREF.t59 fb.0.t14 tp.0.t0 pfet_03v3 ad=1.248p pd=5.32u as=1.248p ps=5.32u w=4.8u l=0.4u
X172 VDD.t124 VDD.t122 OUT.t0 VDD.t123 pfet_03v3 ad=2.2p pd=10.88u as=1.3p ps=5.52u w=5u l=0.28u
X173 i2.0.t0 VSS.t122 VSS.t124 VSS.t123 nfet_03v3 ad=0.78p pd=3.52u as=1.32p ps=6.88u w=3u l=0.28u
X174 VSS.t100 VSS.t98 VSS.t100 VSS.t99 nfet_03v3 ad=0.52p pd=2.52u as=0 ps=0 w=2u l=0.28u
X175 tp.0.t0 VREF.t23 fb.0.t32 tp.0.t0 pfet_03v3 ad=1.248p pd=5.32u as=1.248p ps=5.32u w=4.8u l=0.4u
X176 i1.0.t0 VSS.t119 VSS.t121 VSS.t120 nfet_03v3 ad=0.39p pd=2.02u as=0.66p ps=3.88u w=1.5u l=0.28u
X177 VSS.t194 VBN.t9 tn.0.t43 VSS.t193 nfet_03v3 ad=0.65p pd=3.02u as=0.65p ps=3.02u w=2.5u l=1u
X178 oa.0.t18 VREF.t10 tn.0.t23 VSS.t41 nfet_03v3 ad=1.235p pd=5.27u as=1.235p ps=5.27u w=4.75u l=0.5u
X179 d2a.0.t2 d2b.0.t23 VDD.t163 VDD.t162 pfet_03v3 ad=0.52p pd=2.52u as=0.52p ps=2.52u w=2u l=0.4u
X180 tp.0.t0 VBP.t8 VDD.t27 VDD.t26 pfet_03v3 ad=1.3p pd=5.52u as=1.3p ps=5.52u w=5u l=1u
X181 tp.0.t0 VREF.t37 fa.0.t29 tp.0.t0 pfet_03v3 ad=1.248p pd=5.32u as=1.248p ps=5.32u w=4.8u l=0.4u
X182 VSS.t208 VBN.t1 ts.0.t7 VSS.t207 nfet_03v3 ad=0.65p pd=3.02u as=0.65p ps=3.02u w=2.5u l=1u
X183 oa.0.t26 VSS.t65 VSS.t67 VSS.t66 nfet_03v3 ad=1.1752p pd=5.04u as=1.9888p ps=9.92u w=4.52u l=0.5u
X184 VDD.t67 d3.0.t10 nd.0.t1 VDD.t66 pfet_03v3 ad=0.78p pd=3.52u as=0.78p ps=3.52u w=3u l=0.28u
X185 VDD.t165 d2b.0.t24 d2a.0.t1 VDD.t164 pfet_03v3 ad=0.52p pd=2.52u as=0.52p ps=2.52u w=2u l=0.4u
X186 fb.0.t15 VREF.t56 tp.0.t0 tp.0.t0 pfet_03v3 ad=1.248p pd=5.32u as=1.248p ps=5.32u w=4.8u l=0.4u
X187 tp.0.t0 VREF.t25 fa.0.t35 tp.0.t0 pfet_03v3 ad=1.248p pd=5.32u as=1.248p ps=5.32u w=4.8u l=0.4u
X188 fa.0.t59 VBN.t16 VSS.t180 VSS.t179 nfet_03v3 ad=0.65p pd=3.02u as=0.65p ps=3.02u w=2.5u l=1u
X189 OUT.t1 i2.0.t6 VDD.t65 VDD.t64 pfet_03v3 ad=1.3p pd=5.52u as=1.3p ps=5.52u w=5u l=0.28u
X190 VDD.t100 VDD.t98 VDD.t100 VDD.t99 pfet_03v3 ad=0.52p pd=2.52u as=0 ps=0 w=2u l=0.5u
X191 tp.0.t0 gn.0.t22 fb.0.t58 tp.0.t0 pfet_03v3 ad=1.248p pd=5.32u as=1.248p ps=5.32u w=4.8u l=0.4u
X192 fa.0.t34 VREF.t26 tp.0.t0 tp.0.t0 pfet_03v3 ad=1.248p pd=5.32u as=1.248p ps=5.32u w=4.8u l=0.4u
X193 oa.0.t12 VB2.t12 fa.0.t10 VSS.t19 nfet_03v3 ad=1.1752p pd=5.04u as=1.1752p ps=5.04u w=4.52u l=0.5u
X194 fb.0.t11 VB2.t0 ob.0.t9 VSS.t31 nfet_03v3 ad=1.1752p pd=5.04u as=1.1752p ps=5.04u w=4.52u l=0.5u
X195 d2a.0.t6 VDD.t89 VDD.t91 VDD.t90 pfet_03v3 ad=0.52p pd=2.52u as=0.88p ps=4.88u w=2u l=0.5u
X196 fb.0.t36 gn.0.t25 tp.0.t0 tp.0.t0 pfet_03v3 ad=1.248p pd=5.32u as=1.248p ps=5.32u w=4.8u l=0.4u
X197 VSS.t150 VBN.t31 fa.0.t52 VSS.t149 nfet_03v3 ad=0.65p pd=3.02u as=0.65p ps=3.02u w=2.5u l=1u
X198 fb.0.t9 VB2.t2 ob.0.t7 VSS.t29 nfet_03v3 ad=1.1752p pd=5.04u as=1.1752p ps=5.04u w=4.52u l=0.5u
X199 VDD.t149 d2b.0.t31 d3.0.t6 VDD.t148 pfet_03v3 ad=0.52p pd=2.52u as=0.52p ps=2.52u w=2u l=0.4u
X200 tp.0.t0 VREF.t39 fb.0.t24 tp.0.t0 pfet_03v3 ad=1.248p pd=5.32u as=1.248p ps=5.32u w=4.8u l=0.4u
X201 d3.0.t3 d2b.0.t28 VDD.t143 VDD.t142 pfet_03v3 ad=0.52p pd=2.52u as=0.52p ps=2.52u w=2u l=0.4u
X202 nd.0.t5 EN.t0 VDD.t193 VDD.t192 pfet_03v3 ad=0.78p pd=3.52u as=0.78p ps=3.52u w=3u l=0.28u
X203 fa.0.t20 VREF.t54 tp.0.t0 tp.0.t0 pfet_03v3 ad=1.248p pd=5.32u as=1.248p ps=5.32u w=4.8u l=0.4u
X204 fb.0.t29 VREF.t28 tp.0.t0 tp.0.t0 pfet_03v3 ad=1.248p pd=5.32u as=1.248p ps=5.32u w=4.8u l=0.4u
X205 tn.0.t28 VREF.t17 oa.0.t15 VSS.t34 nfet_03v3 ad=1.235p pd=5.27u as=1.235p ps=5.27u w=4.75u l=0.5u
X206 fa.0.t0 gp.0.t24 tp.0.t0 tp.0.t0 pfet_03v3 ad=1.248p pd=5.32u as=1.248p ps=5.32u w=4.8u l=0.4u
X207 fa.0.t49 VBN.t36 VSS.t140 VSS.t139 nfet_03v3 ad=0.65p pd=3.02u as=0.65p ps=3.02u w=2.5u l=1u
X208 tn.0.t22 VREF.t1 oa.0.t23 VSS.t50 nfet_03v3 ad=1.235p pd=5.27u as=1.235p ps=5.27u w=4.75u l=0.5u
X209 tp.0.t0 VBP.t0 VDD.t43 VDD.t42 pfet_03v3 ad=1.3p pd=5.52u as=1.3p ps=5.52u w=5u l=1u
X210 fb.0.t2 gn.0.t17 tp.0.t0 tp.0.t0 pfet_03v3 ad=1.248p pd=5.32u as=1.248p ps=5.32u w=4.8u l=0.4u
X211 tn.0.t14 VREF.t3 ob.0.t21 VSS.t48 nfet_03v3 ad=1.235p pd=5.27u as=1.235p ps=5.27u w=4.75u l=0.5u
X212 VDD.t132 d2b.0.t6 d2b.0.t7 VDD.t131 pfet_03v3 ad=0.52p pd=2.52u as=0.52p ps=2.52u w=2u l=0.4u
X213 tn.0.t33 gn.0.t6 ob.0.t24 VSS.t57 nfet_03v3 ad=1.235p pd=5.27u as=1.235p ps=5.27u w=4.75u l=0.5u
X214 n3a.0.t1 VSS.t107 VSS.t109 VSS.t108 nfet_03v3 ad=0.6734p pd=3.11u as=1.1396p ps=6.06u w=2.59u l=0.28u
X215 VSS.t170 VBN.t21 fb.0.t49 VSS.t169 nfet_03v3 ad=0.65p pd=3.02u as=0.65p ps=3.02u w=2.5u l=1u
X216 ob.0.t18 VREF.t8 tn.0.t11 VSS.t43 nfet_03v3 ad=1.235p pd=5.27u as=1.235p ps=5.27u w=4.75u l=0.5u
X217 oa.0.t25 gp.0.t10 tn.0.t34 VSS.t58 nfet_03v3 ad=1.235p pd=5.27u as=1.235p ps=5.27u w=4.75u l=0.5u
X218 d3.0.t1 d2b.0.t32 VDD.t63 VDD.t62 pfet_03v3 ad=0.52p pd=2.52u as=0.52p ps=2.52u w=2u l=0.4u
X219 tp.0.t0 VREF.t57 fa.0.t19 tp.0.t0 pfet_03v3 ad=1.248p pd=5.32u as=1.248p ps=5.32u w=4.8u l=0.4u
X220 fb.0.t31 VREF.t24 tp.0.t0 tp.0.t0 pfet_03v3 ad=1.248p pd=5.32u as=1.248p ps=5.32u w=4.8u l=0.4u
X221 ob.0.t4 gn.0.t3 tn.0.t9 VSS.t15 nfet_03v3 ad=1.235p pd=5.27u as=1.235p ps=5.27u w=4.75u l=0.5u
X222 VDD.t139 d2a.0.t28 n3a.0.t8 VDD.t138 pfet_03v3 ad=0.52p pd=2.52u as=0.52p ps=2.52u w=2u l=0.4u
X223 VSS.t239 n3a.0.t2 n3a.0.t3 VSS.t238 nfet_03v3 ad=0.6734p pd=3.11u as=0.6734p ps=3.11u w=2.59u l=0.28u
X224 fb.0.t34 gn.0.t23 tp.0.t0 tp.0.t0 pfet_03v3 ad=1.248p pd=5.32u as=1.248p ps=5.32u w=4.8u l=0.4u
X225 fb.0.t46 VBN.t26 VSS.t160 VSS.t159 nfet_03v3 ad=0.65p pd=3.02u as=0.65p ps=3.02u w=2.5u l=1u
X226 oa.0.t6 gp.0.t4 tn.0.t10 VSS.t16 nfet_03v3 ad=1.235p pd=5.27u as=1.235p ps=5.27u w=4.75u l=0.5u
X227 d2a.0.t4 d2b.0.t21 VDD.t159 VDD.t158 pfet_03v3 ad=0.52p pd=2.52u as=0.52p ps=2.52u w=2u l=0.4u
X228 VDD.t13 VBP.t15 tp.0.t0 VDD.t12 pfet_03v3 ad=1.3p pd=5.52u as=1.3p ps=5.52u w=5u l=1u
X229 VDD.t33 VBP.t5 tp.0.t0 VDD.t32 pfet_03v3 ad=1.3p pd=5.52u as=1.3p ps=5.52u w=5u l=1u
X230 ob.0.t0 gn.0.t9 tn.0.t2 VSS.t2 nfet_03v3 ad=1.235p pd=5.27u as=1.235p ps=5.27u w=4.75u l=0.5u
X231 d2b.0.t3 VSS.t89 VSS.t91 VSS.t90 nfet_03v3 ad=1.0036p pd=4.38u as=1.6984p ps=8.6u w=3.86u l=0.5u
X232 fb.0.t7 VB2.t4 ob.0.t11 VSS.t27 nfet_03v3 ad=1.1752p pd=5.04u as=1.1752p ps=5.04u w=4.52u l=0.5u
X233 oa.0.t28 gp.0.t8 tn.0.t50 VSS.t243 nfet_03v3 ad=1.235p pd=5.27u as=1.235p ps=5.27u w=4.75u l=0.5u
X234 VSS.t94 VSS.t92 sa.0.t1 VSS.t93 nfet_03v3 ad=1.6984p pd=8.6u as=1.0036p ps=4.38u w=3.86u l=0.5u
X235 fb.0.t54 gn.0.t31 tp.0.t0 tp.0.t0 pfet_03v3 ad=1.248p pd=5.32u as=1.248p ps=5.32u w=4.8u l=0.4u
X236 fa.0.t63 gp.0.t22 tp.0.t0 tp.0.t0 pfet_03v3 ad=1.248p pd=5.32u as=1.248p ps=5.32u w=4.8u l=0.4u
X237 tp.0.t0 VREF.t41 fa.0.t27 tp.0.t0 pfet_03v3 ad=1.248p pd=5.32u as=1.248p ps=5.32u w=4.8u l=0.4u
X238 tp.0.t0 VREF.t27 fb.0.t30 tp.0.t0 pfet_03v3 ad=1.248p pd=5.32u as=1.248p ps=5.32u w=4.8u l=0.4u
X239 tp.0.t0 VBP.t20 VDD.t3 VDD.t2 pfet_03v3 ad=1.3p pd=5.52u as=1.3p ps=5.52u w=5u l=1u
X240 tp.0.t0 gn.0.t24 fb.0.t35 tp.0.t0 pfet_03v3 ad=1.248p pd=5.32u as=1.248p ps=5.32u w=4.8u l=0.4u
X241 tp.0.t0 gn.0.t16 fb.0.t1 tp.0.t0 pfet_03v3 ad=1.248p pd=5.32u as=1.248p ps=5.32u w=4.8u l=0.4u
X242 VSS.t204 VBN.t3 ts.0.t5 VSS.t203 nfet_03v3 ad=0.65p pd=3.02u as=0.65p ps=3.02u w=2.5u l=1u
X243 VSS.t178 VBN.t15 tn.0.t37 VSS.t177 nfet_03v3 ad=0.65p pd=3.02u as=0.65p ps=3.02u w=2.5u l=1u
X244 tn.0.t26 VREF.t5 oa.0.t21 VSS.t46 nfet_03v3 ad=1.235p pd=5.27u as=1.235p ps=5.27u w=4.75u l=0.5u
X245 fa.0.t1 gp.0.t30 tp.0.t0 tp.0.t0 pfet_03v3 ad=1.248p pd=5.32u as=1.248p ps=5.32u w=4.8u l=0.4u
X246 VDD.t118 VDD.t116 i2.0.t3 VDD.t117 pfet_03v3 ad=1.65p pd=8.38u as=0.975p ps=4.27u w=3.75u l=0.28u
X247 VDD.t177 d2a.0.t32 n3a.0.t12 VDD.t176 pfet_03v3 ad=0.52p pd=2.52u as=0.52p ps=2.52u w=2u l=0.4u
X248 VDD.t53 d2a.0.t23 d2b.0.t1 VDD.t52 pfet_03v3 ad=0.52p pd=2.52u as=0.52p ps=2.52u w=2u l=0.4u
X249 tp.0.t0 gp.0.t17 fa.0.t7 tp.0.t0 pfet_03v3 ad=1.248p pd=5.32u as=1.248p ps=5.32u w=4.8u l=0.4u
X250 VDD.t157 d2b.0.t20 d2a.0.t5 VDD.t156 pfet_03v3 ad=0.52p pd=2.52u as=0.52p ps=2.52u w=2u l=0.4u
X251 VSS.t115 VSS.t113 VSS.t115 VSS.t114 nfet_03v3 ad=0.39p pd=2.02u as=0 ps=0 w=1.5u l=0.28u
X252 sb.0.t2 ob.0.t29 d2b.0.t16 VSS.t231 nfet_03v3 ad=1.0036p pd=4.38u as=1.0036p ps=4.38u w=3.86u l=0.5u
X253 fb.0.t52 gn.0.t29 tp.0.t0 tp.0.t0 pfet_03v3 ad=1.248p pd=5.32u as=1.248p ps=5.32u w=4.8u l=0.4u
X254 VSS.t64 VSS.t62 tn.0.t36 VSS.t63 nfet_03v3 ad=1.1p pd=5.88u as=0.65p ps=3.02u w=2.5u l=1u
X255 ob.0.t16 VREF.t12 tn.0.t17 VSS.t39 nfet_03v3 ad=1.235p pd=5.27u as=1.235p ps=5.27u w=4.75u l=0.5u
X256 sa.0.t3 oa.0.t31 d2a.0.t9 VSS.t229 nfet_03v3 ad=1.0036p pd=4.38u as=1.0036p ps=4.38u w=3.86u l=0.5u
X257 tp.0.t0 gn.0.t28 fb.0.t62 tp.0.t0 pfet_03v3 ad=1.248p pd=5.32u as=1.248p ps=5.32u w=4.8u l=0.4u
X258 fa.0.t60 gp.0.t12 tp.0.t0 tp.0.t0 pfet_03v3 ad=1.248p pd=5.32u as=1.248p ps=5.32u w=4.8u l=0.4u
X259 VSS.t154 VBN.t29 fb.0.t45 VSS.t153 nfet_03v3 ad=0.65p pd=3.02u as=0.65p ps=3.02u w=2.5u l=1u
X260 ob.0.t26 gn.0.t1 tn.0.t47 VSS.t219 nfet_03v3 ad=1.235p pd=5.27u as=1.235p ps=5.27u w=4.75u l=0.5u
X261 i2.0.t1 i1.0.t4 VDD.t69 VDD.t68 pfet_03v3 ad=0.975p pd=4.27u as=0.975p ps=4.27u w=3.75u l=0.28u
X262 sa.0.t4 oa.0.t29 d2a.0.t10 VSS.t230 nfet_03v3 ad=1.0036p pd=4.38u as=1.0036p ps=4.38u w=3.86u l=0.5u
X263 VDD.t173 d2a.0.t30 n3a.0.t10 VDD.t172 pfet_03v3 ad=0.52p pd=2.52u as=0.52p ps=2.52u w=2u l=0.4u
X264 fb.0.t42 VBN.t34 VSS.t144 VSS.t143 nfet_03v3 ad=0.65p pd=3.02u as=0.65p ps=3.02u w=2.5u l=1u
X265 fa.0.t57 VBN.t20 VSS.t172 VSS.t171 nfet_03v3 ad=0.65p pd=3.02u as=0.65p ps=3.02u w=2.5u l=1u
X266 i1.0.t1 VDD.t107 VDD.t109 VDD.t108 pfet_03v3 ad=0.962p pd=4.22u as=1.628p ps=8.28u w=3.7u l=0.28u
X267 n3a.0.t7 d2a.0.t27 VDD.t137 VDD.t136 pfet_03v3 ad=0.52p pd=2.52u as=0.52p ps=2.52u w=2u l=0.4u
X268 tn.0.t42 VBN.t10 VSS.t192 VSS.t191 nfet_03v3 ad=0.65p pd=3.02u as=0.65p ps=3.02u w=2.5u l=1u
X269 VSS.t166 VBN.t23 fa.0.t56 VSS.t165 nfet_03v3 ad=0.65p pd=3.02u as=0.65p ps=3.02u w=2.5u l=1u
X270 tp.0.t0 VREF.t53 fa.0.t21 tp.0.t0 pfet_03v3 ad=1.248p pd=5.32u as=1.248p ps=5.32u w=4.8u l=0.4u
X271 fb.0.t57 gn.0.t21 tp.0.t0 tp.0.t0 pfet_03v3 ad=1.248p pd=5.32u as=1.248p ps=5.32u w=4.8u l=0.4u
X272 fa.0.t65 gp.0.t16 tp.0.t0 tp.0.t0 pfet_03v3 ad=1.248p pd=5.32u as=1.248p ps=5.32u w=4.8u l=0.4u
X273 OUT.t6 i2.0.t10 VSS.t237 VSS.t236 nfet_03v3 ad=1.04p pd=4.52u as=1.04p ps=4.52u w=4u l=0.28u
X274 VDD.t21 VBP.t11 tp.0.t0 VDD.t20 pfet_03v3 ad=1.3p pd=5.52u as=1.3p ps=5.52u w=5u l=1u
X275 VSS.t134 VBN.t39 fa.0.t48 VSS.t133 nfet_03v3 ad=0.65p pd=3.02u as=0.65p ps=3.02u w=2.5u l=1u
X276 tp.0.t0 gn.0.t30 fb.0.t53 tp.0.t0 pfet_03v3 ad=1.248p pd=5.32u as=1.248p ps=5.32u w=4.8u l=0.4u
X277 fa.0.t64 gp.0.t18 tp.0.t0 tp.0.t0 pfet_03v3 ad=1.248p pd=5.32u as=1.248p ps=5.32u w=4.8u l=0.4u
X278 VDD.t183 i2.0.t7 OUT.t3 VDD.t182 pfet_03v3 ad=1.3p pd=5.52u as=1.3p ps=5.52u w=5u l=0.28u
X279 d2b.0.t2 d2a.0.t24 VDD.t55 VDD.t54 pfet_03v3 ad=0.52p pd=2.52u as=0.52p ps=2.52u w=2u l=0.4u
X280 tp.0.t0 VREF.t43 fb.0.t22 tp.0.t0 pfet_03v3 ad=1.248p pd=5.32u as=1.248p ps=5.32u w=4.8u l=0.4u
X281 fb.0.t50 VBN.t18 VSS.t176 VSS.t175 nfet_03v3 ad=0.65p pd=3.02u as=0.65p ps=3.02u w=2.5u l=1u
X282 VDD.t49 d2a.0.t17 d2a.0.t18 VDD.t48 pfet_03v3 ad=0.52p pd=2.52u as=0.52p ps=2.52u w=2u l=0.4u
X283 VSS.t223 VSS.t224 VSS.t222 ppolyf_u_1k r_width=2u r_length=9.11u
X284 fa.0.t22 VREF.t50 tp.0.t0 tp.0.t0 pfet_03v3 ad=1.248p pd=5.32u as=1.248p ps=5.32u w=4.8u l=0.4u
X285 ob.0.t23 gn.0.t5 tn.0.t32 VSS.t56 nfet_03v3 ad=1.235p pd=5.27u as=1.235p ps=5.27u w=4.75u l=0.5u
X286 oa.0.t5 gp.0.t6 tn.0.t6 VSS.t12 nfet_03v3 ad=1.235p pd=5.27u as=1.235p ps=5.27u w=4.75u l=0.5u
X287 VSS.t130 VSS.t128 OUT.t8 VSS.t129 nfet_03v3 ad=1.76p pd=8.88u as=1.04p ps=4.52u w=4u l=0.28u
X288 VDD.t106 VDD.t104 nd.0.t4 VDD.t105 pfet_03v3 ad=1.32p pd=6.88u as=0.78p ps=3.52u w=3u l=0.28u
X289 tp.0.t0 gp.0.t29 fa.0.t6 tp.0.t0 pfet_03v3 ad=1.248p pd=5.32u as=1.248p ps=5.32u w=4.8u l=0.4u
X290 VDD.t1 VBP.t21 tp.0.t0 VDD.t0 pfet_03v3 ad=1.3p pd=5.52u as=1.3p ps=5.52u w=5u l=1u
X291 tp.0.t0 gp.0.t11 fa.0.t8 tp.0.t0 pfet_03v3 ad=1.248p pd=5.32u as=1.248p ps=5.32u w=4.8u l=0.4u
X292 d2a.0.t7 VDD.t92 VDD.t94 VDD.t93 pfet_03v3 ad=0.52p pd=2.52u as=0.88p ps=4.88u w=2u l=0.4u
X293 VDD.t171 d2b.0.t27 d3.0.t9 VDD.t170 pfet_03v3 ad=0.52p pd=2.52u as=0.52p ps=2.52u w=2u l=0.4u
X294 VDD.t17 VBP.t13 tp.0.t0 VDD.t16 pfet_03v3 ad=1.3p pd=5.52u as=1.3p ps=5.52u w=5u l=1u
X295 d2b.0.t0 d2a.0.t22 VDD.t51 VDD.t50 pfet_03v3 ad=0.52p pd=2.52u as=0.52p ps=2.52u w=2u l=0.4u
X296 fb.0.t19 VREF.t48 tp.0.t0 tp.0.t0 pfet_03v3 ad=1.248p pd=5.32u as=1.248p ps=5.32u w=4.8u l=0.4u
X297 oa.0.t1 gp.0.t2 tn.0.t1 VSS.t1 nfet_03v3 ad=1.235p pd=5.27u as=1.235p ps=5.27u w=4.75u l=0.5u
X298 tp.0.t0 VBP.t18 VDD.t7 VDD.t6 pfet_03v3 ad=1.3p pd=5.52u as=1.3p ps=5.52u w=5u l=1u
X299 tp.0.t0 VBP.t2 VDD.t39 VDD.t38 pfet_03v3 ad=1.3p pd=5.52u as=1.3p ps=5.52u w=5u l=1u
X300 fa.0.t9 VB2.t13 oa.0.t11 VSS.t18 nfet_03v3 ad=1.1752p pd=5.04u as=1.1752p ps=5.04u w=4.52u l=0.5u
X301 tp.0.t0 gp.0.t21 fa.0.t44 tp.0.t0 pfet_03v3 ad=1.248p pd=5.32u as=1.248p ps=5.32u w=4.8u l=0.4u
X302 fa.0.t11 VB2.t11 oa.0.t13 VSS.t20 nfet_03v3 ad=1.1752p pd=5.04u as=1.1752p ps=5.04u w=4.52u l=0.5u
X303 ob.0.t8 VB2.t1 fb.0.t10 VSS.t30 nfet_03v3 ad=1.1752p pd=5.04u as=1.1752p ps=5.04u w=4.52u l=0.5u
X304 d2b.0.t14 d2a.0.t20 VDD.t151 VDD.t150 pfet_03v3 ad=0.52p pd=2.52u as=0.52p ps=2.52u w=2u l=0.4u
X305 VSS.t162 VBN.t25 fb.0.t47 VSS.t161 nfet_03v3 ad=0.65p pd=3.02u as=0.65p ps=3.02u w=2.5u l=1u
X306 ts.0.t8 VBN.t0 VSS.t202 VSS.t201 nfet_03v3 ad=0.65p pd=3.02u as=0.65p ps=3.02u w=2.5u l=1u
X307 d3.0.t2 n3a.0.t13 VSS.t218 VSS.t217 nfet_03v3 ad=0.6734p pd=3.11u as=0.6734p ps=3.11u w=2.59u l=0.28u
X308 tp.0.t0 VBP.t16 VDD.t11 VDD.t10 pfet_03v3 ad=1.3p pd=5.52u as=1.3p ps=5.52u w=5u l=1u
X309 fa.0.t26 VREF.t42 tp.0.t0 tp.0.t0 pfet_03v3 ad=1.248p pd=5.32u as=1.248p ps=5.32u w=4.8u l=0.4u
X310 VSS.t54 VSS.t55 VSS.t53 ppolyf_u_1k r_width=2u r_length=8.86u
X311 fb.0.t17 VREF.t52 tp.0.t0 tp.0.t0 pfet_03v3 ad=1.248p pd=5.32u as=1.248p ps=5.32u w=4.8u l=0.4u
X312 tp.0.t0 VREF.t51 fb.0.t18 tp.0.t0 pfet_03v3 ad=1.248p pd=5.32u as=1.248p ps=5.32u w=4.8u l=0.4u
X313 tp.0.t0 VREF.t31 fb.0.t28 tp.0.t0 pfet_03v3 ad=1.248p pd=5.32u as=1.248p ps=5.32u w=4.8u l=0.4u
X314 fa.0.t32 VREF.t30 tp.0.t0 tp.0.t0 pfet_03v3 ad=1.248p pd=5.32u as=1.248p ps=5.32u w=4.8u l=0.4u
X315 oa.0.t14 VREF.t18 tn.0.t27 VSS.t33 nfet_03v3 ad=1.235p pd=5.27u as=1.235p ps=5.27u w=4.75u l=0.5u
X316 d2b.0.t13 VDD.t95 VDD.t97 VDD.t96 pfet_03v3 ad=0.52p pd=2.52u as=0.88p ps=4.88u w=2u l=0.5u
R0 OUT.n6 OUT 9.0005
R1 OUT.n2 OUT 9.0005
R2 OUT.n7 OUT 5.04371
R3 OUT OUT.n7 2.23121
R4 OUT.n7 OUT 1.78121
R5 OUT OUT.n6 0.93425
R6 OUT OUT.n1 0.879957
R7 OUT OUT.n0 0.879957
R8 OUT OUT.n2 0.698
R9 OUT OUT.n5 0.612457
R10 OUT OUT.n4 0.612457
R11 OUT OUT.n3 0.612457
R12 OUT.n6 OUT 0.476214
R13 OUT.n1 OUT.t2 0.41
R14 OUT.n1 OUT.t7 0.41
R15 OUT.n0 OUT.t8 0.41
R16 OUT.n0 OUT.t6 0.41
R17 OUT.n5 OUT.t5 0.3645
R18 OUT.n5 OUT.t9 0.3645
R19 OUT.n4 OUT.t3 0.3645
R20 OUT.n4 OUT.t4 0.3645
R21 OUT.n3 OUT.t0 0.3645
R22 OUT.n3 OUT.t1 0.3645
R23 OUT.n2 OUT 0.238357
R24 EN EN.t0 54.0878
R25 EN EN.t1 40.9915
R26 EN EN.t3 27.4653
R27 EN EN.t2 27.4653
R28 EN.n0 EN 10.1384
R29 EN EN.n2 8.30621
R30 EN.n0 EN 6.05621
R31 EN.n1 EN 5.94371
R32 EN.n2 EN 5.71871
R33 EN.n1 EN.n0 3.78693
R34 EN.n2 EN.n1 0.411929
R35 VBN.n27 VBN.t16 17.1092
R36 VBN.n17 VBN.t6 15.9196
R37 VBN.n5 VBN.t38 15.9196
R38 VBN.n0 VBN.t5 15.9196
R39 VBN.n25 VBN.t15 15.3248
R40 VBN.n24 VBN.t14 15.3248
R41 VBN.n23 VBN.t13 15.3248
R42 VBN.n22 VBN.t12 15.3248
R43 VBN.n21 VBN.t11 15.3248
R44 VBN.n20 VBN.t10 15.3248
R45 VBN.n19 VBN.t9 15.3248
R46 VBN.n18 VBN.t8 15.3248
R47 VBN.n17 VBN.t7 15.3248
R48 VBN.n37 VBN.t39 15.3248
R49 VBN.n36 VBN.t36 15.3248
R50 VBN.n35 VBN.t35 15.3248
R51 VBN.n34 VBN.t32 15.3248
R52 VBN.n33 VBN.t31 15.3248
R53 VBN.n32 VBN.t28 15.3248
R54 VBN.n31 VBN.t27 15.3248
R55 VBN.n30 VBN.t24 15.3248
R56 VBN.n29 VBN.t23 15.3248
R57 VBN.n28 VBN.t20 15.3248
R58 VBN.n27 VBN.t19 15.3248
R59 VBN.n15 VBN.t17 15.3248
R60 VBN.n14 VBN.t18 15.3248
R61 VBN.n13 VBN.t21 15.3248
R62 VBN.n12 VBN.t22 15.3248
R63 VBN.n11 VBN.t25 15.3248
R64 VBN.n10 VBN.t26 15.3248
R65 VBN.n9 VBN.t29 15.3248
R66 VBN.n8 VBN.t30 15.3248
R67 VBN.n7 VBN.t33 15.3248
R68 VBN.n6 VBN.t34 15.3248
R69 VBN.n5 VBN.t37 15.3248
R70 VBN.n0 VBN.t4 15.3248
R71 VBN.n1 VBN.t3 15.3248
R72 VBN.n2 VBN.t2 15.3248
R73 VBN.n3 VBN.t1 15.3248
R74 VBN.n4 VBN.t0 15.3248
R75 VBN.n16 VBN 12.4301
R76 VBN VBN.n15 10.9238
R77 VBN VBN.n25 10.329
R78 VBN VBN.n37 10.329
R79 VBN VBN.n4 10.329
R80 VBN.n38 VBN.n26 8.96193
R81 VBN VBN.n16 8.08121
R82 VBN VBN.n38 8.08121
R83 VBN.n26 VBN 5.63836
R84 VBN.n26 VBN 5.49371
R85 VBN.n38 VBN 5.49371
R86 VBN.n16 VBN 4.81871
R87 VBN.n29 VBN.n28 1.78485
R88 VBN.n31 VBN.n30 1.78485
R89 VBN.n35 VBN.n34 1.78485
R90 VBN.n37 VBN.n36 1.78485
R91 VBN.n14 VBN.n13 1.78485
R92 VBN.n12 VBN.n11 1.78485
R93 VBN.n10 VBN.n9 1.78485
R94 VBN.n8 VBN.n7 1.78485
R95 VBN.n6 VBN.n5 1.78485
R96 VBN.n33 VBN 1.38376
R97 VBN.n18 VBN.n17 0.595283
R98 VBN.n19 VBN.n18 0.595283
R99 VBN.n20 VBN.n19 0.595283
R100 VBN.n21 VBN.n20 0.595283
R101 VBN.n23 VBN.n22 0.595283
R102 VBN.n24 VBN.n23 0.595283
R103 VBN.n25 VBN.n24 0.595283
R104 VBN.n28 VBN.n27 0.595283
R105 VBN.n30 VBN.n29 0.595283
R106 VBN.n32 VBN.n31 0.595283
R107 VBN.n34 VBN.n33 0.595283
R108 VBN.n36 VBN.n35 0.595283
R109 VBN.n15 VBN.n14 0.595283
R110 VBN.n13 VBN.n12 0.595283
R111 VBN.n9 VBN.n8 0.595283
R112 VBN.n7 VBN.n6 0.595283
R113 VBN.n4 VBN.n3 0.595283
R114 VBN.n2 VBN.n1 0.595283
R115 VBN.n1 VBN.n0 0.595283
R116 VBN.n11 VBN 0.491587
R117 VBN VBN.n32 0.401587
R118 VBN VBN.n2 0.401587
R119 VBN VBN.n21 0.39963
R120 VBN.n22 VBN 0.196152
R121 VBN.n3 VBN 0.194196
R122 VBN VBN.n10 0.104196
R123 VB2.n6 VB2.t7 45.65
R124 VB2.n0 VB2.t6 45.65
R125 VB2.n11 VB2.t13 45.2508
R126 VB2.n10 VB2.t12 45.2508
R127 VB2.n9 VB2.t11 45.2508
R128 VB2.n8 VB2.t10 45.2508
R129 VB2.n7 VB2.t9 45.2508
R130 VB2.n6 VB2.t8 45.2508
R131 VB2.n0 VB2.t5 45.2508
R132 VB2.n1 VB2.t4 45.2508
R133 VB2.n2 VB2.t3 45.2508
R134 VB2.n3 VB2.t2 45.2508
R135 VB2.n4 VB2.t1 45.2508
R136 VB2.n5 VB2.t0 45.2508
R137 VB2 VB2.n12 13.7062
R138 VB2 VB2.n11 10.0355
R139 VB2 VB2.n5 10.0355
R140 VB2.n12 VB2 9.01336
R141 VB2.n12 VB2 4.81871
R142 VB2.n7 VB2.n6 0.39963
R143 VB2.n8 VB2.n7 0.39963
R144 VB2.n9 VB2.n8 0.39963
R145 VB2.n11 VB2.n10 0.39963
R146 VB2.n5 VB2.n4 0.39963
R147 VB2.n3 VB2.n2 0.39963
R148 VB2.n2 VB2.n1 0.39963
R149 VB2.n1 VB2.n0 0.39963
R150 VB2.n10 VB2 0.248978
R151 VB2.n4 VB2 0.248978
R152 VB2 VB2.n9 0.151152
R153 VB2 VB2.n3 0.151152
R154 VREF.n31 VREF.t44 57.4425
R155 VREF.n0 VREF.t43 57.4425
R156 VREF.n49 VREF.t63 57.0825
R157 VREF.n48 VREF.t62 57.0825
R158 VREF.n47 VREF.t61 57.0825
R159 VREF.n46 VREF.t60 57.0825
R160 VREF.n45 VREF.t59 57.0825
R161 VREF.n44 VREF.t58 57.0825
R162 VREF.n43 VREF.t57 57.0825
R163 VREF.n42 VREF.t56 57.0825
R164 VREF.n41 VREF.t55 57.0825
R165 VREF.n40 VREF.t54 57.0825
R166 VREF.n39 VREF.t53 57.0825
R167 VREF.n38 VREF.t52 57.0825
R168 VREF.n37 VREF.t51 57.0825
R169 VREF.n36 VREF.t50 57.0825
R170 VREF.n35 VREF.t49 57.0825
R171 VREF.n34 VREF.t48 57.0825
R172 VREF.n33 VREF.t47 57.0825
R173 VREF.n32 VREF.t46 57.0825
R174 VREF.n31 VREF.t45 57.0825
R175 VREF.n22 VREF.t20 57.0825
R176 VREF.n21 VREF.t21 57.0825
R177 VREF.n20 VREF.t22 57.0825
R178 VREF.n19 VREF.t23 57.0825
R179 VREF.n18 VREF.t24 57.0825
R180 VREF.n17 VREF.t25 57.0825
R181 VREF.n16 VREF.t26 57.0825
R182 VREF.n15 VREF.t27 57.0825
R183 VREF.n14 VREF.t28 57.0825
R184 VREF.n13 VREF.t29 57.0825
R185 VREF.n12 VREF.t30 57.0825
R186 VREF.n11 VREF.t31 57.0825
R187 VREF.n10 VREF.t32 57.0825
R188 VREF.n9 VREF.t33 57.0825
R189 VREF.n8 VREF.t34 57.0825
R190 VREF.n7 VREF.t35 57.0825
R191 VREF.n6 VREF.t36 57.0825
R192 VREF.n5 VREF.t37 57.0825
R193 VREF.n4 VREF.t38 57.0825
R194 VREF.n3 VREF.t39 57.0825
R195 VREF.n2 VREF.t40 57.0825
R196 VREF.n1 VREF.t41 57.0825
R197 VREF.n0 VREF.t42 57.0825
R198 VREF.n51 VREF.t8 47.329
R199 VREF.n23 VREF.t7 47.329
R200 VREF.n61 VREF.t19 46.9298
R201 VREF.n60 VREF.t18 46.9298
R202 VREF.n59 VREF.t17 46.9298
R203 VREF.n58 VREF.t16 46.9298
R204 VREF.n57 VREF.t15 46.9298
R205 VREF.n56 VREF.t14 46.9298
R206 VREF.n55 VREF.t13 46.9298
R207 VREF.n54 VREF.t12 46.9298
R208 VREF.n53 VREF.t11 46.9298
R209 VREF.n52 VREF.t10 46.9298
R210 VREF.n51 VREF.t9 46.9298
R211 VREF.n29 VREF.t0 46.9298
R212 VREF.n28 VREF.t1 46.9298
R213 VREF.n27 VREF.t2 46.9298
R214 VREF.n26 VREF.t3 46.9298
R215 VREF.n25 VREF.t4 46.9298
R216 VREF.n24 VREF.t5 46.9298
R217 VREF.n23 VREF.t6 46.9298
R218 VREF.n30 VREF 11.0801
R219 VREF VREF.n49 9.73811
R220 VREF VREF.n22 9.73811
R221 VREF VREF.n61 9.63637
R222 VREF VREF.n29 9.63637
R223 VREF.n30 VREF 8.86871
R224 VREF.n50 VREF 7.88836
R225 VREF.n62 VREF 7.85621
R226 VREF VREF.n30 7.85621
R227 VREF VREF.n62 7.85621
R228 VREF.n62 VREF.n50 6.93693
R229 VREF.n50 VREF 5.83121
R230 VREF.n52 VREF.n51 0.39963
R231 VREF.n53 VREF.n52 0.39963
R232 VREF.n54 VREF.n53 0.39963
R233 VREF.n55 VREF.n54 0.39963
R234 VREF.n56 VREF.n55 0.39963
R235 VREF.n58 VREF.n57 0.39963
R236 VREF.n59 VREF.n58 0.39963
R237 VREF.n60 VREF.n59 0.39963
R238 VREF.n61 VREF.n60 0.39963
R239 VREF.n29 VREF.n28 0.39963
R240 VREF.n28 VREF.n27 0.39963
R241 VREF.n26 VREF.n25 0.39963
R242 VREF.n25 VREF.n24 0.39963
R243 VREF.n24 VREF.n23 0.39963
R244 VREF.n32 VREF.n31 0.3605
R245 VREF.n33 VREF.n32 0.3605
R246 VREF.n34 VREF.n33 0.3605
R247 VREF.n35 VREF.n34 0.3605
R248 VREF.n36 VREF.n35 0.3605
R249 VREF.n37 VREF.n36 0.3605
R250 VREF.n38 VREF.n37 0.3605
R251 VREF.n39 VREF.n38 0.3605
R252 VREF.n40 VREF.n39 0.3605
R253 VREF.n42 VREF.n41 0.3605
R254 VREF.n43 VREF.n42 0.3605
R255 VREF.n44 VREF.n43 0.3605
R256 VREF.n45 VREF.n44 0.3605
R257 VREF.n46 VREF.n45 0.3605
R258 VREF.n47 VREF.n46 0.3605
R259 VREF.n48 VREF.n47 0.3605
R260 VREF.n49 VREF.n48 0.3605
R261 VREF.n22 VREF.n21 0.3605
R262 VREF.n21 VREF.n20 0.3605
R263 VREF.n20 VREF.n19 0.3605
R264 VREF.n19 VREF.n18 0.3605
R265 VREF.n18 VREF.n17 0.3605
R266 VREF.n17 VREF.n16 0.3605
R267 VREF.n16 VREF.n15 0.3605
R268 VREF.n15 VREF.n14 0.3605
R269 VREF.n14 VREF.n13 0.3605
R270 VREF.n13 VREF.n12 0.3605
R271 VREF.n11 VREF.n10 0.3605
R272 VREF.n10 VREF.n9 0.3605
R273 VREF.n9 VREF.n8 0.3605
R274 VREF.n8 VREF.n7 0.3605
R275 VREF.n7 VREF.n6 0.3605
R276 VREF.n6 VREF.n5 0.3605
R277 VREF.n5 VREF.n4 0.3605
R278 VREF.n4 VREF.n3 0.3605
R279 VREF.n3 VREF.n2 0.3605
R280 VREF.n2 VREF.n1 0.3605
R281 VREF.n1 VREF.n0 0.3605
R282 VREF.n57 VREF 0.247022
R283 VREF.n27 VREF 0.247022
R284 VREF VREF.n11 0.223543
R285 VREF VREF.n40 0.221587
R286 VREF VREF.n56 0.153109
R287 VREF VREF.n26 0.153109
R288 VREF.n41 VREF 0.139413
R289 VREF.n12 VREF 0.137457
R290 INN INN.t0 1.2823
R291 VBP.n0 VBP.t0 25.0446
R292 VBP.n20 VBP.t21 24.4498
R293 VBP.n19 VBP.t20 24.4498
R294 VBP.n18 VBP.t19 24.4498
R295 VBP.n17 VBP.t18 24.4498
R296 VBP.n16 VBP.t17 24.4498
R297 VBP.n15 VBP.t16 24.4498
R298 VBP.n14 VBP.t15 24.4498
R299 VBP.n13 VBP.t14 24.4498
R300 VBP.n12 VBP.t13 24.4498
R301 VBP.n11 VBP.t12 24.4498
R302 VBP.n10 VBP.t11 24.4498
R303 VBP.n9 VBP.t10 24.4498
R304 VBP.n8 VBP.t9 24.4498
R305 VBP.n7 VBP.t8 24.4498
R306 VBP.n6 VBP.t7 24.4498
R307 VBP.n5 VBP.t6 24.4498
R308 VBP.n4 VBP.t5 24.4498
R309 VBP.n3 VBP.t4 24.4498
R310 VBP.n2 VBP.t3 24.4498
R311 VBP.n1 VBP.t2 24.4498
R312 VBP.n0 VBP.t1 24.4498
R313 VBP.n21 VBP 15.5384
R314 VBP VBP.n20 10.4503
R315 VBP VBP.n21 7.18121
R316 VBP.n21 VBP 4.70621
R317 VBP.n1 VBP.n0 0.595283
R318 VBP.n2 VBP.n1 0.595283
R319 VBP.n3 VBP.n2 0.595283
R320 VBP.n4 VBP.n3 0.595283
R321 VBP.n5 VBP.n4 0.595283
R322 VBP.n6 VBP.n5 0.595283
R323 VBP.n7 VBP.n6 0.595283
R324 VBP.n8 VBP.n7 0.595283
R325 VBP.n9 VBP.n8 0.595283
R326 VBP.n10 VBP.n9 0.595283
R327 VBP.n12 VBP.n11 0.595283
R328 VBP.n13 VBP.n12 0.595283
R329 VBP.n14 VBP.n13 0.595283
R330 VBP.n15 VBP.n14 0.595283
R331 VBP.n16 VBP.n15 0.595283
R332 VBP.n17 VBP.n16 0.595283
R333 VBP.n18 VBP.n17 0.595283
R334 VBP.n19 VBP.n18 0.595283
R335 VBP.n20 VBP.n19 0.595283
R336 VBP VBP.n10 0.462239
R337 VBP.n11 VBP 0.133543
R338 INP INP.t0 1.2823
R339 VDD.t75 VDD.n57 490.897
R340 VDD.t90 VDD.n58 490.897
R341 VDD.n161 VDD.t99 490.897
R342 VDD.t96 VDD.n160 490.897
R343 VDD.n76 VDD.t87 482.726
R344 VDD.t84 VDD.n69 482.726
R345 VDD.t72 VDD.n116 482.726
R346 VDD.t93 VDD.n117 482.726
R347 VDD.n245 VDD.n4 434.175
R348 VDD.n243 VDD.n4 434.175
R349 VDD.n245 VDD.n5 434.175
R350 VDD.n243 VDD.n5 434.175
R351 VDD.n102 VDD.t105 406.473
R352 VDD.t102 VDD.n100 406.473
R353 VDD.n47 VDD.t111 370.091
R354 VDD.t108 VDD.n46 370.091
R355 VDD.n150 VDD.t117 367.702
R356 VDD.t114 VDD.n148 367.702
R357 VDD.t81 VDD.n4 356.781
R358 VDD.t78 VDD.n5 356.781
R359 VDD.t123 VDD.n23 317.307
R360 VDD.t120 VDD.n24 317.307
R361 VDD.n137 VDD.n117 249.726
R362 VDD.n139 VDD.n117 249.726
R363 VDD.n139 VDD.n116 249.726
R364 VDD.n137 VDD.n116 249.726
R365 VDD.n73 VDD.n69 233.625
R366 VDD.n74 VDD.n69 233.625
R367 VDD.n76 VDD.n74 233.625
R368 VDD.n76 VDD.n73 233.625
R369 VDD.t190 VDD.t75 166.667
R370 VDD.t190 VDD.t90 166.667
R371 VDD.t99 VDD.t188 166.667
R372 VDD.t188 VDD.t96 166.667
R373 VDD.t42 VDD.t81 166.667
R374 VDD.t40 VDD.t42 166.667
R375 VDD.t38 VDD.t40 166.667
R376 VDD.t36 VDD.t38 166.667
R377 VDD.t34 VDD.t36 166.667
R378 VDD.t32 VDD.t34 166.667
R379 VDD.t30 VDD.t32 166.667
R380 VDD.t28 VDD.t30 166.667
R381 VDD.t26 VDD.t28 166.667
R382 VDD.t24 VDD.t26 166.667
R383 VDD.t22 VDD.t24 166.667
R384 VDD.t20 VDD.t18 166.667
R385 VDD.t18 VDD.t16 166.667
R386 VDD.t16 VDD.t14 166.667
R387 VDD.t14 VDD.t12 166.667
R388 VDD.t12 VDD.t10 166.667
R389 VDD.t10 VDD.t8 166.667
R390 VDD.t8 VDD.t6 166.667
R391 VDD.t6 VDD.t4 166.667
R392 VDD.t4 VDD.t2 166.667
R393 VDD.t2 VDD.t0 166.667
R394 VDD.t0 VDD.t78 166.667
R395 VDD.n172 VDD.n24 156.976
R396 VDD.n170 VDD.n24 156.976
R397 VDD.n170 VDD.n23 156.976
R398 VDD.n172 VDD.n23 156.976
R399 VDD.t87 VDD.t56 150.327
R400 VDD.t56 VDD.t166 150.327
R401 VDD.t166 VDD.t168 150.327
R402 VDD.t168 VDD.t134 150.327
R403 VDD.t134 VDD.t136 150.327
R404 VDD.t136 VDD.t170 150.327
R405 VDD.t170 VDD.t142 150.327
R406 VDD.t142 VDD.t138 150.327
R407 VDD.t140 VDD.t144 150.327
R408 VDD.t144 VDD.t146 150.327
R409 VDD.t146 VDD.t172 150.327
R410 VDD.t172 VDD.t174 150.327
R411 VDD.t174 VDD.t148 150.327
R412 VDD.t148 VDD.t62 150.327
R413 VDD.t62 VDD.t176 150.327
R414 VDD.t176 VDD.t84 150.327
R415 VDD.t150 VDD.t72 150.327
R416 VDD.t48 VDD.t150 150.327
R417 VDD.t46 VDD.t48 150.327
R418 VDD.t180 VDD.t46 150.327
R419 VDD.t178 VDD.t180 150.327
R420 VDD.t156 VDD.t178 150.327
R421 VDD.t158 VDD.t156 150.327
R422 VDD.t152 VDD.t158 150.327
R423 VDD.t50 VDD.t152 150.327
R424 VDD.t52 VDD.t54 150.327
R425 VDD.t54 VDD.t160 150.327
R426 VDD.t160 VDD.t162 150.327
R427 VDD.t162 VDD.t131 150.327
R428 VDD.t131 VDD.t129 150.327
R429 VDD.t129 VDD.t60 150.327
R430 VDD.t60 VDD.t58 150.327
R431 VDD.t58 VDD.t164 150.327
R432 VDD.t164 VDD.t93 150.327
R433 VDD.n150 VDD.n145 132.038
R434 VDD.n150 VDD.n147 132.038
R435 VDD.n148 VDD.n145 132.038
R436 VDD.n148 VDD.n147 132.038
R437 VDD.n102 VDD.n65 125.475
R438 VDD.n102 VDD.n66 125.475
R439 VDD.n100 VDD.n65 125.475
R440 VDD.n100 VDD.n66 125.475
R441 VDD.n47 VDD.n43 124.6
R442 VDD.n47 VDD.n45 124.6
R443 VDD.n46 VDD.n43 124.6
R444 VDD.n46 VDD.n45 124.6
R445 VDD.n227 VDD.n221 120.862
R446 VDD.n225 VDD.n224 120.862
R447 VDD.n190 VDD.n184 120.862
R448 VDD.n187 VDD.n185 120.862
R449 VDD.n110 VDD.n57 115.501
R450 VDD.n111 VDD.n57 115.501
R451 VDD.n110 VDD.n58 115.501
R452 VDD.n111 VDD.n58 115.501
R453 VDD.n161 VDD.n33 115.501
R454 VDD.n161 VDD.n34 115.501
R455 VDD.n160 VDD.n33 115.501
R456 VDD.n160 VDD.n34 115.501
R457 VDD.t105 VDD.t192 112.361
R458 VDD.t66 VDD.t102 112.361
R459 VDD.n234 VDD.n229 106.576
R460 VDD.n232 VDD.n231 106.576
R461 VDD.n13 VDD.n8 106.576
R462 VDD.n10 VDD.n9 106.576
R463 VDD.n224 VDD.n223 102.594
R464 VDD.n227 VDD.n226 102.594
R465 VDD.n188 VDD.n184 102.594
R466 VDD.n189 VDD.n185 102.594
R467 VDD.t111 VDD.t127 102.302
R468 VDD.t127 VDD.t108 102.302
R469 VDD.t117 VDD.t68 101.653
R470 VDD.t125 VDD.t114 101.653
R471 VDD.n231 VDD.n230 91.2621
R472 VDD.n234 VDD.n233 91.2621
R473 VDD.n11 VDD.n8 91.2621
R474 VDD.n12 VDD.n9 91.2621
R475 VDD.t64 VDD.t123 87.7198
R476 VDD.t182 VDD.t64 87.7198
R477 VDD.t184 VDD.t186 87.7198
R478 VDD.t186 VDD.t120 87.7198
R479 VDD.n244 VDD.t22 83.3338
R480 VDD.n244 VDD.t20 83.3338
R481 VDD.n25 VDD.t122 80.6719
R482 VDD.n169 VDD.t119 80.6719
R483 VDD.t138 VDD.n75 75.1639
R484 VDD.n75 VDD.t140 75.1639
R485 VDD.n138 VDD.t50 75.1639
R486 VDD.n138 VDD.t52 75.1639
R487 VDD.n146 VDD.t113 64.3772
R488 VDD.n144 VDD.t116 64.3772
R489 VDD.n44 VDD.t107 63.7254
R490 VDD.n42 VDD.t110 63.7254
R491 VDD.t192 VDD.n101 56.1803
R492 VDD.n101 VDD.t66 56.1803
R493 VDD.n99 VDD.t101 54.6004
R494 VDD.n64 VDD.t104 54.6004
R495 VDD.t68 VDD.n149 50.8264
R496 VDD.n149 VDD.t125 50.8264
R497 VDD.n171 VDD.t182 43.8601
R498 VDD.n171 VDD.t184 43.8601
R499 VDD.n71 VDD.t86 32.6164
R500 VDD.n94 VDD.t83 32.6164
R501 VDD.n118 VDD.t71 32.6164
R502 VDD.n119 VDD.t92 32.6164
R503 VDD.n55 VDD.t74 27.9583
R504 VDD.n108 VDD.t89 27.9583
R505 VDD.n32 VDD.t98 27.9583
R506 VDD.n159 VDD.t95 27.9583
R507 VDD.n242 VDD.t77 25.6511
R508 VDD.n6 VDD.t80 25.6511
R509 VDD.n236 VDD 11.093
R510 VDD.n181 VDD 11.093
R511 VDD.n237 VDD 10.5659
R512 VDD.n192 VDD 10.5659
R513 VDD VDD.n93 9.55336
R514 VDD VDD.n136 9.55336
R515 VDD.n121 VDD 9.55336
R516 VDD.n27 VDD 9.47621
R517 VDD.n61 VDD 9.28978
R518 VDD.n79 VDD 9.0005
R519 VDD.n81 VDD 9.0005
R520 VDD.n83 VDD 9.0005
R521 VDD.n85 VDD 9.0005
R522 VDD.n87 VDD 9.0005
R523 VDD.n89 VDD 9.0005
R524 VDD.n91 VDD 9.0005
R525 VDD.n93 VDD 9.0005
R526 VDD.n77 VDD 9.0005
R527 VDD.n61 VDD 9.0005
R528 VDD VDD.n107 9.0005
R529 VDD.n121 VDD 9.0005
R530 VDD.n123 VDD 9.0005
R531 VDD.n125 VDD 9.0005
R532 VDD.n127 VDD 9.0005
R533 VDD.n130 VDD 9.0005
R534 VDD.n132 VDD 9.0005
R535 VDD.n134 VDD 9.0005
R536 VDD.n136 VDD 9.0005
R537 VDD VDD.n31 9.0005
R538 VDD.n164 VDD 9.0005
R539 VDD.n104 VDD 9.0005
R540 VDD.n50 VDD 9.0005
R541 VDD VDD.n40 9.0005
R542 VDD.n152 VDD 9.0005
R543 VDD.n29 VDD 9.0005
R544 VDD.n27 VDD 9.0005
R545 VDD VDD.n167 9.0005
R546 VDD.n198 VDD 9.0005
R547 VDD.n200 VDD 9.0005
R548 VDD.n202 VDD 9.0005
R549 VDD.n204 VDD 9.0005
R550 VDD.n206 VDD 9.0005
R551 VDD.n209 VDD 9.0005
R552 VDD.n211 VDD 9.0005
R553 VDD.n213 VDD 9.0005
R554 VDD.n215 VDD 9.0005
R555 VDD.n217 VDD 9.0005
R556 VDD VDD.n240 9.0005
R557 VDD.n196 VDD 9.0005
R558 VDD VDD.n14 5.76371
R559 VDD.n15 VDD 5.76371
R560 VDD VDD.n166 5.60621
R561 VDD.n96 VDD 5.53421
R562 VDD.n105 VDD 5.49371
R563 VDD VDD.n39 5.49371
R564 VDD VDD.n142 5.49371
R565 VDD VDD.n6 5.358
R566 VDD VDD.n242 5.358
R567 VDD.n16 VDD 5.3105
R568 VDD VDD.n106 5.26871
R569 VDD.n165 VDD 5.26871
R570 VDD VDD.n239 5.26871
R571 VDD VDD.n194 5.26871
R572 VDD VDD.n70 5.15621
R573 VDD VDD.n96 5.13693
R574 VDD VDD.n62 5.13693
R575 VDD.n53 VDD 5.13693
R576 VDD VDD.n38 5.13693
R577 VDD.n156 VDD 5.13693
R578 VDD VDD.n37 5.13693
R579 VDD VDD.n20 5.13693
R580 VDD.n174 VDD 5.13693
R581 VDD VDD.n68 4.93121
R582 VDD VDD.n54 4.93121
R583 VDD.n113 VDD 4.93121
R584 VDD VDD.n114 4.93121
R585 VDD.n141 VDD 4.93121
R586 VDD VDD.n157 4.93121
R587 VDD VDD.n30 4.93121
R588 VDD VDD.n218 4.85086
R589 VDD VDD.n235 4.85086
R590 VDD.n236 VDD 4.85086
R591 VDD VDD.n237 4.85086
R592 VDD.n238 VDD 4.85086
R593 VDD VDD.n1 4.85086
R594 VDD VDD.n0 4.85086
R595 VDD VDD.n7 4.85086
R596 VDD.n193 VDD 4.85086
R597 VDD VDD.n192 4.85086
R598 VDD.n181 VDD 4.85086
R599 VDD VDD.n180 4.85086
R600 VDD.n246 VDD.n2 4.718
R601 VDD.n246 VDD.n3 4.718
R602 VDD.n180 VDD 4.62653
R603 VDD VDD.n95 4.5005
R604 VDD.n72 VDD 4.5005
R605 VDD.n56 VDD 4.5005
R606 VDD VDD.n112 4.5005
R607 VDD.n115 VDD 4.5005
R608 VDD VDD.n140 4.5005
R609 VDD.n158 VDD 4.5005
R610 VDD.n36 VDD 4.5005
R611 VDD.n67 VDD 4.5005
R612 VDD.n97 VDD 4.5005
R613 VDD.n41 VDD 4.5005
R614 VDD VDD.n52 4.5005
R615 VDD.n143 VDD 4.5005
R616 VDD VDD.n155 4.5005
R617 VDD.n22 VDD 4.5005
R618 VDD VDD.n173 4.5005
R619 VDD.n14 VDD 4.5005
R620 VDD.n15 VDD 4.5005
R621 VDD.n179 VDD.n17 4.5005
R622 VDD.n177 VDD.n19 4.5005
R623 VDD.n2 VDD 4.5005
R624 VDD VDD.n246 4.5005
R625 VDD.n3 VDD 4.5005
R626 VDD.n175 VDD.n174 4.09883
R627 VDD VDD.t133 3.57
R628 VDD VDD.t155 3.57
R629 VDD VDD.n118 3.098
R630 VDD VDD.n71 2.868
R631 VDD.n228 VDD.n220 2.6483
R632 VDD.n222 VDD.n220 2.6483
R633 VDD.n222 VDD.n219 2.6483
R634 VDD.n191 VDD.n183 2.6483
R635 VDD.n186 VDD.n183 2.6483
R636 VDD.n186 VDD.n182 2.6483
R637 VDD VDD.n115 2.463
R638 VDD.n140 VDD 2.463
R639 VDD VDD.n228 2.4449
R640 VDD VDD.n182 2.4449
R641 VDD.n17 VDD.n16 2.3396
R642 VDD.t76 VDD 2.30246
R643 VDD VDD.t91 2.30246
R644 VDD VDD.t100 2.30246
R645 VDD VDD.t97 2.30246
R646 VDD.n176 VDD.n175 2.24472
R647 VDD.n178 VDD.n177 2.23795
R648 VDD.n18 VDD.n17 2.23795
R649 VDD.n95 VDD 2.233
R650 VDD.n72 VDD 2.233
R651 VDD VDD.t88 2.2105
R652 VDD VDD.t85 2.2105
R653 VDD VDD.t73 2.2105
R654 VDD VDD.t94 2.2105
R655 VDD VDD.n59 1.5705
R656 VDD.n162 VDD 1.5705
R657 VDD VDD.t103 1.56579
R658 VDD VDD.t106 1.56579
R659 VDD VDD.n169 1.398
R660 VDD VDD.n25 1.398
R661 VDD VDD.n60 1.39246
R662 VDD.n163 VDD 1.39246
R663 VDD.n173 VDD.n21 1.3905
R664 VDD.n195 VDD.n2 1.3905
R665 VDD VDD.t109 1.32721
R666 VDD.t112 VDD 1.32721
R667 VDD VDD.n78 1.3005
R668 VDD VDD.n80 1.3005
R669 VDD VDD.n82 1.3005
R670 VDD VDD.n84 1.3005
R671 VDD VDD.n86 1.3005
R672 VDD VDD.n88 1.3005
R673 VDD VDD.n90 1.3005
R674 VDD VDD.n92 1.3005
R675 VDD VDD.n120 1.3005
R676 VDD VDD.n122 1.3005
R677 VDD VDD.n124 1.3005
R678 VDD VDD.n126 1.3005
R679 VDD VDD.n128 1.3005
R680 VDD VDD.n129 1.3005
R681 VDD VDD.n131 1.3005
R682 VDD VDD.n133 1.3005
R683 VDD VDD.n135 1.3005
R684 VDD.n151 VDD.n143 1.23425
R685 VDD.n48 VDD.n41 1.228
R686 VDD VDD.t115 1.22779
R687 VDD VDD.t118 1.22779
R688 VDD.n194 VDD.n193 1.21514
R689 VDD.n239 VDD.n238 1.21514
R690 VDD.n99 VDD 1.198
R691 VDD VDD.n144 1.198
R692 VDD VDD.n146 1.198
R693 VDD VDD.n236 1.13836
R694 VDD.n237 VDD 1.13836
R695 VDD.n192 VDD 1.13836
R696 VDD VDD.n181 1.13836
R697 VDD VDD.n42 1.098
R698 VDD VDD.n44 1.098
R699 VDD VDD.n72 1.0955
R700 VDD.n140 VDD 1.0955
R701 VDD.n168 VDD 1.0905
R702 VDD.n241 VDD 1.0905
R703 VDD VDD.t124 0.976457
R704 VDD VDD.t121 0.976457
R705 VDD VDD.t79 0.976457
R706 VDD VDD.t82 0.976457
R707 VDD VDD.n179 0.97175
R708 VDD VDD.n63 0.959123
R709 VDD.n240 VDD.n217 0.939071
R710 VDD.n217 VDD.n215 0.939071
R711 VDD.n215 VDD.n213 0.939071
R712 VDD.n213 VDD.n211 0.939071
R713 VDD.n211 VDD.n209 0.939071
R714 VDD.n209 VDD 0.939071
R715 VDD VDD.n206 0.939071
R716 VDD.n206 VDD.n204 0.939071
R717 VDD.n204 VDD.n202 0.939071
R718 VDD.n202 VDD.n200 0.939071
R719 VDD.n200 VDD.n198 0.939071
R720 VDD.n198 VDD.n196 0.939071
R721 VDD VDD.n154 0.93425
R722 VDD VDD.n51 0.928
R723 VDD.n78 VDD.t57 0.9105
R724 VDD.n78 VDD.t167 0.9105
R725 VDD.n80 VDD.t169 0.9105
R726 VDD.n80 VDD.t135 0.9105
R727 VDD.n82 VDD.t137 0.9105
R728 VDD.n82 VDD.t171 0.9105
R729 VDD.n84 VDD.t143 0.9105
R730 VDD.n84 VDD.t139 0.9105
R731 VDD.n86 VDD.t141 0.9105
R732 VDD.n86 VDD.t145 0.9105
R733 VDD.n88 VDD.t147 0.9105
R734 VDD.n88 VDD.t173 0.9105
R735 VDD.n90 VDD.t175 0.9105
R736 VDD.n90 VDD.t149 0.9105
R737 VDD.n92 VDD.t63 0.9105
R738 VDD.n92 VDD.t177 0.9105
R739 VDD.n60 VDD.t76 0.9105
R740 VDD.n60 VDD.t191 0.9105
R741 VDD.n120 VDD.t151 0.9105
R742 VDD.n120 VDD.t49 0.9105
R743 VDD.n122 VDD.t47 0.9105
R744 VDD.n122 VDD.t181 0.9105
R745 VDD.n124 VDD.t179 0.9105
R746 VDD.n124 VDD.t157 0.9105
R747 VDD.n126 VDD.t159 0.9105
R748 VDD.n126 VDD.t153 0.9105
R749 VDD.n128 VDD.t51 0.9105
R750 VDD.n128 VDD.t53 0.9105
R751 VDD.n129 VDD.t55 0.9105
R752 VDD.n129 VDD.t161 0.9105
R753 VDD.n131 VDD.t163 0.9105
R754 VDD.n131 VDD.t132 0.9105
R755 VDD.n133 VDD.t130 0.9105
R756 VDD.n133 VDD.t61 0.9105
R757 VDD.n135 VDD.t59 0.9105
R758 VDD.n135 VDD.t165 0.9105
R759 VDD.t100 VDD.n163 0.9105
R760 VDD.n163 VDD.t189 0.9105
R761 VDD.n169 VDD 0.8455
R762 VDD.n25 VDD 0.8455
R763 VDD VDD.n6 0.8455
R764 VDD.n242 VDD 0.8455
R765 VDD.n98 VDD 0.8405
R766 VDD VDD.n49 0.835314
R767 VDD VDD.n59 0.826152
R768 VDD.n109 VDD 0.826152
R769 VDD VDD.n162 0.826152
R770 VDD.n35 VDD 0.826152
R771 VDD VDD.n103 0.826152
R772 VDD.n98 VDD 0.826152
R773 VDD VDD.n48 0.826152
R774 VDD.n51 VDD 0.826152
R775 VDD VDD.n151 0.826152
R776 VDD.n154 VDD 0.826152
R777 VDD VDD.n21 0.826152
R778 VDD.n168 VDD 0.826152
R779 VDD VDD.n195 0.826152
R780 VDD.n241 VDD 0.826152
R781 VDD.n14 VDD 0.8105
R782 VDD VDD.n15 0.8105
R783 VDD VDD.n234 0.788
R784 VDD.n231 VDD 0.788
R785 VDD.n8 VDD 0.788
R786 VDD.n9 VDD 0.788
R787 VDD.n173 VDD 0.763
R788 VDD VDD.n22 0.763
R789 VDD VDD.n153 0.742457
R790 VDD VDD.n109 0.7155
R791 VDD.n35 VDD 0.7155
R792 VDD VDD.n69 0.7005
R793 VDD VDD.n76 0.7005
R794 VDD VDD.n58 0.7005
R795 VDD VDD.n57 0.7005
R796 VDD VDD.n117 0.7005
R797 VDD.n116 VDD 0.7005
R798 VDD.n160 VDD 0.7005
R799 VDD VDD.n161 0.7005
R800 VDD VDD.n144 0.68925
R801 VDD.n146 VDD 0.68925
R802 VDD VDD.n42 0.683
R803 VDD.n44 VDD 0.683
R804 VDD VDD.n0 0.68126
R805 VDD VDD.n1 0.68126
R806 VDD.n95 VDD.n94 0.6255
R807 VDD.n108 VDD.n56 0.6255
R808 VDD.n112 VDD.n55 0.6255
R809 VDD.n119 VDD.n115 0.6255
R810 VDD.n159 VDD.n158 0.6255
R811 VDD.n36 VDD.n32 0.6255
R812 VDD.n67 VDD.n64 0.6255
R813 VDD VDD.n28 0.612457
R814 VDD VDD.n26 0.612457
R815 VDD VDD.n197 0.612457
R816 VDD VDD.n199 0.612457
R817 VDD VDD.n201 0.612457
R818 VDD VDD.n203 0.612457
R819 VDD VDD.n205 0.612457
R820 VDD VDD.n207 0.612457
R821 VDD VDD.n208 0.612457
R822 VDD VDD.n210 0.612457
R823 VDD VDD.n212 0.612457
R824 VDD VDD.n214 0.612457
R825 VDD VDD.n216 0.612457
R826 VDD.n63 VDD.t193 0.607167
R827 VDD.n63 VDD.t67 0.607167
R828 VDD VDD.n99 0.5955
R829 VDD.n167 VDD 0.580679
R830 VDD.n240 VDD 0.575857
R831 VDD.n196 VDD 0.575857
R832 VDD VDD.n102 0.573227
R833 VDD.n100 VDD 0.573227
R834 VDD.n228 VDD.n227 0.573227
R835 VDD.n224 VDD.n222 0.573227
R836 VDD.n184 VDD.n183 0.573227
R837 VDD.n185 VDD.n182 0.573227
R838 VDD VDD.n67 0.563
R839 VDD.n97 VDD 0.563
R840 VDD.n143 VDD 0.563
R841 VDD.n155 VDD 0.563
R842 VDD.n93 VDD.n91 0.553357
R843 VDD.n91 VDD.n89 0.553357
R844 VDD.n89 VDD.n87 0.553357
R845 VDD.n85 VDD.n83 0.553357
R846 VDD.n83 VDD.n81 0.553357
R847 VDD.n81 VDD.n79 0.553357
R848 VDD.n79 VDD.n77 0.553357
R849 VDD.n136 VDD.n134 0.553357
R850 VDD.n134 VDD.n132 0.553357
R851 VDD.n132 VDD.n130 0.553357
R852 VDD.n130 VDD 0.553357
R853 VDD VDD.n127 0.553357
R854 VDD.n127 VDD.n125 0.553357
R855 VDD.n125 VDD.n123 0.553357
R856 VDD.n123 VDD.n121 0.553357
R857 VDD.n40 VDD 0.548536
R858 VDD.n112 VDD 0.5455
R859 VDD VDD.n56 0.5455
R860 VDD VDD.n36 0.5455
R861 VDD.n158 VDD 0.5455
R862 VDD.n152 VDD 0.542107
R863 VDD VDD.n104 0.538893
R864 VDD.n107 VDD 0.527643
R865 VDD VDD.n164 0.527643
R866 VDD VDD.n47 0.5255
R867 VDD.n46 VDD 0.5255
R868 VDD.n77 VDD 0.521214
R869 VDD.n103 VDD.n64 0.5155
R870 VDD.n49 VDD.t112 0.492392
R871 VDD.n49 VDD.t128 0.492392
R872 VDD.n153 VDD.t69 0.485833
R873 VDD.n153 VDD.t126 0.485833
R874 VDD VDD.n150 0.485115
R875 VDD.n148 VDD 0.485115
R876 VDD.n104 VDD 0.476214
R877 VDD VDD.n152 0.476214
R878 VDD.n167 VDD.n29 0.476214
R879 VDD.n107 VDD 0.473
R880 VDD.n94 VDD 0.4705
R881 VDD VDD.n71 0.4705
R882 VDD VDD.n108 0.4705
R883 VDD VDD.n55 0.4705
R884 VDD VDD.n119 0.4705
R885 VDD.n118 VDD 0.4705
R886 VDD VDD.n159 0.4705
R887 VDD VDD.n32 0.4705
R888 VDD.n41 VDD 0.463
R889 VDD.n52 VDD 0.463
R890 VDD VDD.n24 0.4205
R891 VDD VDD.n23 0.4205
R892 VDD VDD.n4 0.4205
R893 VDD VDD.n5 0.4205
R894 VDD.n166 VDD.n165 0.4037
R895 VDD.n45 VDD 0.39425
R896 VDD.t127 VDD.n45 0.39425
R897 VDD.n43 VDD 0.39425
R898 VDD.t127 VDD.n43 0.39425
R899 VDD.n232 VDD 0.39425
R900 VDD.n229 VDD 0.39425
R901 VDD VDD.n13 0.39425
R902 VDD.n10 VDD 0.39425
R903 VDD.n225 VDD.n220 0.371088
R904 VDD.n221 VDD.n219 0.371088
R905 VDD.n191 VDD.n190 0.371088
R906 VDD.n187 VDD.n186 0.371088
R907 VDD.n28 VDD.t185 0.3645
R908 VDD.n28 VDD.t187 0.3645
R909 VDD.n26 VDD.t65 0.3645
R910 VDD.n26 VDD.t183 0.3645
R911 VDD.n197 VDD.t43 0.3645
R912 VDD.n197 VDD.t41 0.3645
R913 VDD.n199 VDD.t39 0.3645
R914 VDD.n199 VDD.t37 0.3645
R915 VDD.n201 VDD.t35 0.3645
R916 VDD.n201 VDD.t33 0.3645
R917 VDD.n203 VDD.t31 0.3645
R918 VDD.n203 VDD.t29 0.3645
R919 VDD.n205 VDD.t27 0.3645
R920 VDD.n205 VDD.t25 0.3645
R921 VDD.n207 VDD.t23 0.3645
R922 VDD.n207 VDD.t21 0.3645
R923 VDD.n208 VDD.t19 0.3645
R924 VDD.n208 VDD.t17 0.3645
R925 VDD.n210 VDD.t15 0.3645
R926 VDD.n210 VDD.t13 0.3645
R927 VDD.n212 VDD.t11 0.3645
R928 VDD.n212 VDD.t9 0.3645
R929 VDD.n214 VDD.t7 0.3645
R930 VDD.n214 VDD.t5 0.3645
R931 VDD.n216 VDD.t3 0.3645
R932 VDD.n216 VDD.t1 0.3645
R933 VDD.n141 VDD 0.35582
R934 VDD VDD.n111 0.3505
R935 VDD.n111 VDD.t190 0.3505
R936 VDD.n110 VDD 0.3505
R937 VDD.t190 VDD.n110 0.3505
R938 VDD VDD.n34 0.3505
R939 VDD.t188 VDD.n34 0.3505
R940 VDD.n33 VDD 0.3505
R941 VDD.t188 VDD.n33 0.3505
R942 VDD.n66 VDD 0.3505
R943 VDD.n101 VDD.n66 0.3505
R944 VDD VDD.n65 0.3505
R945 VDD.n101 VDD.n65 0.3505
R946 VDD.n147 VDD 0.3505
R947 VDD.n149 VDD.n147 0.3505
R948 VDD.n145 VDD 0.3505
R949 VDD.n149 VDD.n145 0.3505
R950 VDD.n233 VDD.t70 0.338172
R951 VDD.n230 VDD.t70 0.338172
R952 VDD.n12 VDD.t45 0.338172
R953 VDD.t45 VDD.n11 0.338172
R954 VDD.n114 VDD.n113 0.32954
R955 VDD.n226 VDD.t44 0.315577
R956 VDD.n223 VDD.t44 0.315577
R957 VDD.n189 VDD.t154 0.315577
R958 VDD.t154 VDD.n188 0.315577
R959 VDD VDD.n172 0.3005
R960 VDD.n172 VDD.n171 0.3005
R961 VDD.n170 VDD 0.3005
R962 VDD.n171 VDD.n170 0.3005
R963 VDD VDD.n97 0.2905
R964 VDD.n52 VDD 0.2905
R965 VDD.n155 VDD 0.2905
R966 VDD VDD.n22 0.2905
R967 VDD VDD.n3 0.2905
R968 VDD.n164 VDD.n31 0.289786
R969 VDD.n87 VDD 0.276929
R970 VDD VDD.n85 0.276929
R971 VDD VDD.n27 0.238357
R972 VDD.n29 VDD 0.238357
R973 VDD.n174 VDD.n20 0.22154
R974 VDD.n50 VDD.n40 0.219071
R975 VDD.n235 VDD 0.20354
R976 VDD.n16 VDD 0.176
R977 VDD.n156 VDD.n141 0.17006
R978 VDD.n157 VDD.n156 0.15998
R979 VDD.n113 VDD.n54 0.1589
R980 VDD VDD.n219 0.1499
R981 VDD VDD.n191 0.1499
R982 VDD VDD.n61 0.145143
R983 VDD VDD.n31 0.145143
R984 VDD.n74 VDD 0.137457
R985 VDD.n75 VDD.n74 0.137457
R986 VDD.n73 VDD 0.137457
R987 VDD.n75 VDD.n73 0.137457
R988 VDD.n53 VDD.n38 0.13514
R989 VDD.n180 VDD.n7 0.13226
R990 VDD.n193 VDD.n7 0.13226
R991 VDD.n238 VDD.n218 0.13226
R992 VDD.n235 VDD.n218 0.13226
R993 VDD VDD.n139 0.1265
R994 VDD.n139 VDD.n138 0.1265
R995 VDD.n137 VDD 0.1265
R996 VDD.n138 VDD.n137 0.1265
R997 VDD VDD.n50 0.109786
R998 VDD.n166 VDD.n20 0.10202
R999 VDD.n39 VDD 0.1013
R1000 VDD.n194 VDD.n0 0.10094
R1001 VDD.n239 VDD.n1 0.10094
R1002 VDD.n39 VDD.n38 0.09482
R1003 VDD.n142 VDD.n37 0.09338
R1004 VDD.n105 VDD.n62 0.09266
R1005 VDD.n165 VDD.n30 0.09014
R1006 VDD.n106 VDD.n54 0.09014
R1007 VDD.n70 VDD.n68 0.0887
R1008 VDD.n109 VDD 0.0805
R1009 VDD.n59 VDD 0.0805
R1010 VDD VDD.n35 0.0805
R1011 VDD.n162 VDD 0.0805
R1012 VDD.n103 VDD 0.0805
R1013 VDD VDD.n98 0.0805
R1014 VDD.n48 VDD 0.0805
R1015 VDD.n51 VDD 0.0805
R1016 VDD.n151 VDD 0.0805
R1017 VDD.n154 VDD 0.0805
R1018 VDD VDD.n168 0.0805
R1019 VDD VDD.n21 0.0805
R1020 VDD.n195 VDD 0.0805
R1021 VDD VDD.n241 0.0805
R1022 VDD.n243 VDD 0.0712865
R1023 VDD.n244 VDD.n243 0.0712865
R1024 VDD.n246 VDD.n245 0.0712865
R1025 VDD.n245 VDD.n244 0.0712865
R1026 VDD.n142 VDD.n30 0.06206
R1027 VDD.n230 VDD.n229 0.0573702
R1028 VDD.n233 VDD.n232 0.0573702
R1029 VDD.n13 VDD.n12 0.0573702
R1030 VDD.n11 VDD.n10 0.0573702
R1031 VDD.n223 VDD.n221 0.0568398
R1032 VDD.n226 VDD.n225 0.0568398
R1033 VDD.n190 VDD.n189 0.0568398
R1034 VDD.n188 VDD.n187 0.0568398
R1035 VDD.n178 VDD.n18 0.0536955
R1036 VDD.n175 VDD.n19 0.053
R1037 VDD.n96 VDD.n68 0.0419
R1038 VDD.n70 VDD.n62 0.03434
R1039 VDD.n179 VDD.n178 0.0270978
R1040 VDD.n19 VDD.n18 0.0270978
R1041 VDD.n114 VDD.n53 0.02606
R1042 VDD.n106 VDD.n105 0.0257
R1043 VDD.n176 VDD.n17 0.0135648
R1044 VDD.n177 VDD.n176 0.0135648
R1045 VDD.n157 VDD.n37 0.00446
R1046 VSS.n235 VSS.n40 29246
R1047 VSS.n294 VSS.n288 29246
R1048 VSS.n294 VSS.n293 24989.3
R1049 VSS.n296 VSS.n43 13337
R1050 VSS.n237 VSS.n236 10836.2
R1051 VSS.n289 VSS.n287 10836.2
R1052 VSS.n68 VSS.n57 8712.12
R1053 VSS.n69 VSS.n68 8208.81
R1054 VSS.n236 VSS.n42 8018.86
R1055 VSS.t215 VSS.n6 7376.49
R1056 VSS.n78 VSS.n77 5814.65
R1057 VSS.n292 VSS.n289 4933.79
R1058 VSS.n339 VSS.n338 4805.01
R1059 VSS.t137 VSS.n6 4059.18
R1060 VSS.n252 VSS.n7 4059.18
R1061 VSS.n270 VSS.t175 4059.18
R1062 VSS.t215 VSS.n270 3823.99
R1063 VSS.t240 VSS.n7 3420.64
R1064 VSS.n338 VSS.n7 3040.57
R1065 VSS.n286 VSS.n285 2760.02
R1066 VSS.n270 VSS.n57 2637.23
R1067 VSS.n329 VSS.n328 1993.1
R1068 VSS.t240 VSS.n6 1830.55
R1069 VSS.n236 VSS.n40 1792.36
R1070 VSS.n289 VSS.n288 1792.36
R1071 VSS.n295 VSS.n294 1444.14
R1072 VSS.n284 VSS.n57 1375.09
R1073 VSS.n324 VSS.t105 1370.62
R1074 VSS.t108 VSS.n327 1370.62
R1075 VSS.n235 VSS.n42 1359.35
R1076 VSS.n237 VSS.n235 1099.61
R1077 VSS.n294 VSS.n287 1099.61
R1078 VSS.n338 VSS.n337 635.87
R1079 VSS.t8 VSS.n43 613.646
R1080 VSS.t234 VSS.n296 613.646
R1081 VSS.n77 VSS.t114 573.529
R1082 VSS.t120 VSS.n339 573.529
R1083 VSS.t117 VSS.n69 573.529
R1084 VSS.t123 VSS.n78 573.529
R1085 VSS.n67 VSS.t126 573.529
R1086 VSS.n203 VSS.n98 515.958
R1087 VSS.n203 VSS.n200 515.958
R1088 VSS.n200 VSS.n99 515.958
R1089 VSS.n99 VSS.n98 515.958
R1090 VSS.n198 VSS.n95 481.639
R1091 VSS.n100 VSS.n95 481.639
R1092 VSS.n101 VSS.n100 481.639
R1093 VSS.n198 VSS.n101 481.639
R1094 VSS.n287 VSS.n286 461.389
R1095 VSS.t105 VSS.t217 424.837
R1096 VSS.n328 VSS.t108 406.25
R1097 VSS.n337 VSS.t99 364.565
R1098 VSS.n329 VSS.t111 364.565
R1099 VSS.t8 VSS.n42 346.967
R1100 VSS.n263 VSS.n79 346.598
R1101 VSS.n263 VSS.n80 346.598
R1102 VSS.n268 VSS.n80 346.598
R1103 VSS.n268 VSS.n79 346.598
R1104 VSS.n295 VSS.n54 313.308
R1105 VSS.n238 VSS.n237 309.76
R1106 VSS.n244 VSS.n217 274.75
R1107 VSS.n234 VSS.n217 274.75
R1108 VSS.n234 VSS.n216 274.75
R1109 VSS.n244 VSS.n216 274.75
R1110 VSS.n293 VSS.n292 273.365
R1111 VSS.n145 VSS.n123 267.361
R1112 VSS.n145 VSS.n120 267.361
R1113 VSS.n123 VSS.n119 267.264
R1114 VSS.n120 VSS.n119 267.264
R1115 VSS.n285 VSS.n56 266.805
R1116 VSS.t234 VSS.n295 264.726
R1117 VSS.n237 VSS.n26 219.25
R1118 VSS.n162 VSS.n107 215.639
R1119 VSS.n162 VSS.n108 215.639
R1120 VSS.n150 VSS.n108 215.639
R1121 VSS.n150 VSS.n107 215.639
R1122 VSS.t217 VSS.n323 212.418
R1123 VSS.n323 VSS.t238 212.418
R1124 VSS.n284 VSS.t129 210.072
R1125 VSS.n241 VSS.n90 206.306
R1126 VSS.n241 VSS.n91 206.306
R1127 VSS.n250 VSS.n91 206.306
R1128 VSS.n250 VSS.n90 206.306
R1129 VSS.n159 VSS.n110 206.306
R1130 VSS.n159 VSS.n111 206.306
R1131 VSS.n147 VSS.n111 206.306
R1132 VSS.n147 VSS.n110 206.306
R1133 VSS.t240 VSS.t114 177.839
R1134 VSS.t240 VSS.t120 177.839
R1135 VSS.t215 VSS.t117 177.839
R1136 VSS.t215 VSS.t123 177.839
R1137 VSS.t129 VSS.t236 177.839
R1138 VSS.t126 VSS.t212 177.839
R1139 VSS.n254 VSS.n87 160.222
R1140 VSS.n254 VSS.n88 160.222
R1141 VSS.n260 VSS.n88 160.222
R1142 VSS.n260 VSS.n87 160.222
R1143 VSS.n137 VSS.n132 160.222
R1144 VSS.n138 VSS.n132 160.222
R1145 VSS.n138 VSS.n131 160.222
R1146 VSS.n137 VSS.n131 160.222
R1147 VSS.t84 VSS.n238 152.929
R1148 VSS.n58 VSS.n56 143.112
R1149 VSS.n282 VSS.n56 143.112
R1150 VSS.n59 VSS.n58 143.112
R1151 VSS.n282 VSS.n59 143.112
R1152 VSS.t102 VSS.n109 139.925
R1153 VSS.n253 VSS.t96 139.925
R1154 VSS.n298 VSS.n53 134.29
R1155 VSS.n299 VSS.n53 134.29
R1156 VSS.n299 VSS.n52 134.29
R1157 VSS.n298 VSS.n52 134.29
R1158 VSS.n307 VSS.n44 134.29
R1159 VSS.n307 VSS.n45 134.29
R1160 VSS.n47 VSS.n44 134.29
R1161 VSS.n324 VSS.n27 129.404
R1162 VSS.n327 VSS.n27 129.404
R1163 VSS.n327 VSS.n28 129.404
R1164 VSS.n324 VSS.n28 129.404
R1165 VSS.n76 VSS.n66 125.612
R1166 VSS.n271 VSS.n66 125.612
R1167 VSS.n271 VSS.n65 125.612
R1168 VSS.n76 VSS.n65 125.612
R1169 VSS.n330 VSS.n9 123.668
R1170 VSS.n330 VSS.n10 123.668
R1171 VSS.n336 VSS.n10 123.668
R1172 VSS.n336 VSS.n9 123.668
R1173 VSS.n286 VSS.n55 113.916
R1174 VSS.n160 VSS.n109 113.136
R1175 VSS.t245 VSS.t99 113.043
R1176 VSS.t111 VSS.t211 113.043
R1177 VSS.n8 VSS.n5 111.028
R1178 VSS.n340 VSS.n5 111.028
R1179 VSS.n340 VSS.n4 111.028
R1180 VSS.n8 VSS.n4 111.028
R1181 VSS.n161 VSS.t78 106.635
R1182 VSS.t69 VSS.n89 106.635
R1183 VSS.n253 VSS.n252 104.814
R1184 VSS.t4 VSS.t60 90.2494
R1185 VSS.t236 VSS.n283 88.9198
R1186 VSS.n283 VSS.t212 88.9198
R1187 VSS.n285 VSS.n284 88.5111
R1188 VSS.t201 VSS.t207 79.0658
R1189 VSS.t187 VSS.t185 79.0658
R1190 VSS.t185 VSS.t183 79.0658
R1191 VSS.t183 VSS.t177 79.0658
R1192 VSS.t177 VSS.t84 79.0658
R1193 VSS.n275 VSS.t128 67.5149
R1194 VSS.n61 VSS.t125 67.5149
R1195 VSS.n149 VSS.t4 62.6806
R1196 VSS.n293 VSS.n54 57.3669
R1197 VSS.n25 VSS.t245 56.5222
R1198 VSS.t211 VSS.n25 56.5222
R1199 VSS.n63 VSS.t116 54.4791
R1200 VSS.n74 VSS.t122 54.4791
R1201 VSS.t31 VSS.t81 53.0575
R1202 VSS.t28 VSS.t29 53.0575
R1203 VSS.t232 VSS.t233 53.0575
R1204 VSS.t50 VSS.t49 53.0575
R1205 VSS.t47 VSS.t46 53.0575
R1206 VSS.t44 VSS.t219 53.0575
R1207 VSS.t242 VSS.t1 53.0575
R1208 VSS.t16 VSS.t0 53.0575
R1209 VSS.t52 VSS.t56 53.0575
R1210 VSS.t243 VSS.t244 53.0575
R1211 VSS.t9 VSS.t58 53.0575
R1212 VSS.t43 VSS.t42 53.0575
R1213 VSS.t40 VSS.t39 53.0575
R1214 VSS.t37 VSS.t36 53.0575
R1215 VSS.t33 VSS.t34 53.0575
R1216 VSS.t228 VSS.t230 53.0575
R1217 VSS.t23 VSS.t24 53.0575
R1218 VSS.t20 VSS.t21 53.0575
R1219 VSS.t66 VSS.t18 53.0575
R1220 VSS.n149 VSS.n55 50.7167
R1221 VSS.n325 VSS.t104 49.1345
R1222 VSS.n326 VSS.t107 49.1345
R1223 VSS.n68 VSS.n67 46.6831
R1224 VSS.t87 VSS.t78 46.2953
R1225 VSS.t63 VSS.t69 46.2953
R1226 VSS.n249 VSS.t68 46.233
R1227 VSS.n240 VSS.t65 46.233
R1228 VSS.n112 VSS.t80 46.233
R1229 VSS.n158 VSS.t77 46.233
R1230 VSS.t197 VSS.t22 45.255
R1231 VSS.t45 VSS.t173 44.2146
R1232 VSS.t139 VSS.t38 44.2146
R1233 VSS.t193 VSS.t19 44.2146
R1234 VSS.t189 VSS.n242 43.6945
R1235 VSS.n148 VSS.t214 43.4344
R1236 VSS.t165 VSS.t15 42.134
R1237 VSS.t147 VSS.t14 42.134
R1238 VSS.n23 VSS.t98 41.4434
R1239 VSS.n331 VSS.t110 41.4434
R1240 VSS.n259 VSS.t92 41.415
R1241 VSS.n255 VSS.t95 41.415
R1242 VSS.n129 VSS.t101 41.415
R1243 VSS.n136 VSS.t89 41.415
R1244 VSS.t161 VSS.t11 41.0936
R1245 VSS.t151 VSS.t2 41.0936
R1246 VSS.t157 VSS.t12 40.0533
R1247 VSS.t155 VSS.t220 40.0533
R1248 VSS.n243 VSS.t191 39.5332
R1249 VSS.n243 VSS.t189 39.5332
R1250 VSS.n122 VSS.t26 36.6722
R1251 VSS.t232 VSS.n134 36.6722
R1252 VSS.n201 VSS.t228 36.6722
R1253 VSS.n133 VSS.t102 36.1521
R1254 VSS.t51 VSS.t90 36.1521
R1255 VSS.t32 VSS.t93 36.1521
R1256 VSS.n202 VSS.t96 36.1521
R1257 VSS.t171 VSS.t10 35.892
R1258 VSS.t41 VSS.t141 35.892
R1259 VSS.t60 VSS.n148 35.3718
R1260 VSS.n242 VSS.t187 35.3718
R1261 VSS.n2 VSS.t113 34.9256
R1262 VSS.n15 VSS.t119 34.9256
R1263 VSS.t203 VSS.t30 34.8517
R1264 VSS.t175 VSS.t45 34.8517
R1265 VSS.t38 VSS.t137 34.8517
R1266 VSS.t19 VSS.t195 34.8517
R1267 VSS.t17 VSS.t159 34.0714
R1268 VSS.t235 VSS.t153 34.0714
R1269 VSS.t131 VSS.t27 33.8113
R1270 VSS.t179 VSS.t48 33.8113
R1271 VSS.t133 VSS.t35 33.8113
R1272 VSS.t22 VSS.t199 33.8113
R1273 VSS.n161 VSS.n160 33.2912
R1274 VSS.n251 VSS.n89 33.2912
R1275 VSS.n121 VSS.t3 28.8697
R1276 VSS.n135 VSS.t181 28.3496
R1277 VSS.t135 VSS.n261 28.3496
R1278 VSS.n199 VSS.t57 26.529
R1279 VSS.n199 VSS.t13 26.529
R1280 VSS.t15 VSS.t222 24.7084
R1281 VSS.t14 VSS.t225 24.7084
R1282 VSS.t27 VSS.t53 23.6681
R1283 VSS.t221 VSS.t163 23.1479
R1284 VSS.t7 VSS.t149 23.1479
R1285 VSS.n328 VSS.n26 22.6277
R1286 VSS.n269 VSS.t169 22.1076
R1287 VSS.n262 VSS.t143 22.1076
R1288 VSS.t53 VSS.t205 21.5874
R1289 VSS.t10 VSS.n269 21.0672
R1290 VSS.n262 VSS.t41 21.0672
R1291 VSS.t26 VSS.t131 19.2467
R1292 VSS.t49 VSS.t179 19.2467
R1293 VSS.t34 VSS.t133 19.2467
R1294 VSS.t199 VSS.t23 19.2467
R1295 VSS.n328 VSS.t238 18.5871
R1296 VSS.t29 VSS.t203 18.2063
R1297 VSS.t175 VSS.t46 18.2063
R1298 VSS.t137 VSS.t37 18.2063
R1299 VSS.t195 VSS.t20 18.2063
R1300 VSS.t219 VSS.t171 17.166
R1301 VSS.t141 VSS.t40 17.166
R1302 VSS.t191 VSS.t66 17.166
R1303 VSS.t231 VSS.n133 16.9059
R1304 VSS.t233 VSS.t51 16.9059
R1305 VSS.t48 VSS.n135 16.9059
R1306 VSS.n261 VSS.t35 16.9059
R1307 VSS.t230 VSS.t32 16.9059
R1308 VSS.n202 VSS.t229 16.9059
R1309 VSS.n197 VSS.t74 16.4048
R1310 VSS.n209 VSS.t71 16.4048
R1311 VSS.n233 VSS.t83 16.4048
R1312 VSS.n218 VSS.t62 16.4048
R1313 VSS.n106 VSS.t86 16.4048
R1314 VSS.n118 VSS.t59 16.4048
R1315 VSS.n122 VSS.t25 16.3857
R1316 VSS.n134 VSS.t231 16.3857
R1317 VSS.t229 VSS.n201 16.3857
R1318 VSS.t167 VSS.t242 16.1257
R1319 VSS.t145 VSS.t43 16.1257
R1320 VSS.t163 VSS.t16 15.0853
R1321 VSS.t149 VSS.t9 15.0853
R1322 VSS.t11 VSS.t221 14.8252
R1323 VSS.t2 VSS.t7 14.8252
R1324 VSS.t159 VSS.t52 14.045
R1325 VSS.t153 VSS.t243 14.045
R1326 VSS.t57 VSS.t157 13.0047
R1327 VSS.t13 VSS.t155 13.0047
R1328 VSS.t222 VSS.t167 12.2244
R1329 VSS.t225 VSS.t145 12.2244
R1330 VSS.n146 VSS.t81 11.9643
R1331 VSS.t56 VSS.t161 11.9643
R1332 VSS.t244 VSS.t151 11.9643
R1333 VSS.t0 VSS.t165 10.924
R1334 VSS.t58 VSS.t147 10.924
R1335 VSS.t3 VSS.t209 10.6639
R1336 VSS VSS.n304 10.5016
R1337 VSS.n301 VSS 10.5
R1338 VSS.t90 VSS.t75 10.1437
R1339 VSS.t93 VSS.t72 10.1437
R1340 VSS VSS.n308 9.89259
R1341 VSS.n291 VSS 9.89208
R1342 VSS.t1 VSS.t169 9.88366
R1343 VSS.t42 VSS.t143 9.88366
R1344 VSS.n72 VSS 9.21907
R1345 VSS VSS.n13 9.21907
R1346 VSS.n21 VSS 9.21907
R1347 VSS.n278 VSS 9.0005
R1348 VSS.n72 VSS 9.0005
R1349 VSS VSS.n73 9.0005
R1350 VSS.n13 VSS 9.0005
R1351 VSS.n17 VSS 9.0005
R1352 VSS.n21 VSS 9.0005
R1353 VSS VSS.n22 9.0005
R1354 VSS.n187 VSS 9.0005
R1355 VSS.n185 VSS 9.0005
R1356 VSS.n183 VSS 9.0005
R1357 VSS.n181 VSS 9.0005
R1358 VSS.n179 VSS 9.0005
R1359 VSS.n177 VSS 9.0005
R1360 VSS.n175 VSS 9.0005
R1361 VSS.n173 VSS 9.0005
R1362 VSS.n171 VSS 9.0005
R1363 VSS.n169 VSS 9.0005
R1364 VSS.n167 VSS 9.0005
R1365 VSS.n94 VSS 9.0005
R1366 VSS.n210 VSS 9.0005
R1367 VSS.n188 VSS 9.0005
R1368 VSS.n221 VSS 9.0005
R1369 VSS.n223 VSS 9.0005
R1370 VSS.n226 VSS 9.0005
R1371 VSS.n228 VSS 9.0005
R1372 VSS VSS.n231 9.0005
R1373 VSS.n219 VSS 9.0005
R1374 VSS.n116 VSS 9.0005
R1375 VSS.n105 VSS 9.0005
R1376 VSS.n164 VSS 9.0005
R1377 VSS VSS.n117 9.0005
R1378 VSS.n30 VSS 9.0005
R1379 VSS.t209 VSS.t31 8.84333
R1380 VSS.t173 VSS.t44 8.84333
R1381 VSS.t39 VSS.t139 8.84333
R1382 VSS.t18 VSS.t193 8.84333
R1383 VSS.n252 VSS.n251 8.32316
R1384 VSS.t205 VSS.t28 7.803
R1385 VSS.t181 VSS.t47 7.803
R1386 VSS.t36 VSS.t135 7.803
R1387 VSS.t21 VSS.t197 7.803
R1388 VSS.t25 VSS.t87 6.76266
R1389 VSS.t75 VSS.t50 6.76266
R1390 VSS.t72 VSS.t33 6.76266
R1391 VSS.t24 VSS.t63 6.76266
R1392 VSS VSS.n197 5.6605
R1393 VSS VSS.n113 5.47913
R1394 VSS.n279 VSS 5.38121
R1395 VSS VSS.n0 5.38121
R1396 VSS VSS.n230 5.38121
R1397 VSS VSS.n212 5.38121
R1398 VSS.n165 VSS 5.38121
R1399 VSS.n141 VSS 5.30813
R1400 VSS.n18 VSS 5.26871
R1401 VSS VSS.n19 5.26871
R1402 VSS.n211 VSS 5.26871
R1403 VSS.n189 VSS 5.26871
R1404 VSS.n31 VSS 5.26871
R1405 VSS.t207 VSS.n146 5.20216
R1406 VSS VSS.n49 5.11507
R1407 VSS.n280 VSS 5.07233
R1408 VSS.n229 VSS 5.06461
R1409 VSS.n246 VSS 5.06461
R1410 VSS VSS.n92 5.06461
R1411 VSS.n206 VSS 5.06461
R1412 VSS.n194 VSS 5.06461
R1413 VSS VSS.n190 5.06461
R1414 VSS.n154 VSS 5.06461
R1415 VSS VSS.n113 5.06461
R1416 VSS VSS.n213 5.04371
R1417 VSS VSS.n247 5.04371
R1418 VSS VSS.n103 5.04371
R1419 VSS VSS.n155 5.04371
R1420 VSS.n302 VSS 5.01157
R1421 VSS VSS.n301 5.01157
R1422 VSS VSS.n49 5.01157
R1423 VSS.n310 VSS 5.01157
R1424 VSS VSS.n309 5.01157
R1425 VSS VSS.n39 5.01157
R1426 VSS VSS.n303 5.01157
R1427 VSS.n304 VSS 5.01157
R1428 VSS.n290 VSS 5.01157
R1429 VSS.n320 VSS 4.96175
R1430 VSS VSS.n321 4.96175
R1431 VSS.t12 VSS.t17 4.94208
R1432 VSS.t220 VSS.t235 4.94208
R1433 VSS VSS.n280 4.93121
R1434 VSS.n273 VSS 4.93121
R1435 VSS VSS.n62 4.93121
R1436 VSS.n342 VSS 4.93121
R1437 VSS VSS.n1 4.93121
R1438 VSS VSS.n334 4.93121
R1439 VSS.n333 VSS 4.93121
R1440 VSS VSS.n207 4.93121
R1441 VSS.n97 VSS 4.93121
R1442 VSS.n191 VSS 4.93121
R1443 VSS VSS.n195 4.93121
R1444 VSS VSS.n256 4.93121
R1445 VSS VSS.n84 4.93121
R1446 VSS.n265 VSS 4.93121
R1447 VSS VSS.n266 4.93121
R1448 VSS VSS.n83 4.93121
R1449 VSS.n140 VSS 4.93121
R1450 VSS VSS.n141 4.93121
R1451 VSS.t30 VSS.n121 4.682
R1452 VSS.n64 VSS 4.5005
R1453 VSS VSS.n272 4.5005
R1454 VSS.n3 VSS 4.5005
R1455 VSS VSS.n341 4.5005
R1456 VSS VSS.n332 4.5005
R1457 VSS.n335 VSS 4.5005
R1458 VSS.n239 VSS 4.5005
R1459 VSS.n248 VSS 4.5005
R1460 VSS VSS.n102 4.5005
R1461 VSS VSS.n96 4.5005
R1462 VSS.n208 VSS 4.5005
R1463 VSS.n196 VSS 4.5005
R1464 VSS.n157 VSS 4.5005
R1465 VSS.n156 VSS 4.5005
R1466 VSS VSS.n245 4.5005
R1467 VSS VSS.n215 4.5005
R1468 VSS VSS.n193 4.5005
R1469 VSS VSS.n205 4.5005
R1470 VSS.n204 VSS 4.5005
R1471 VSS.n192 VSS 4.5005
R1472 VSS.n152 VSS 4.5005
R1473 VSS VSS.n153 4.5005
R1474 VSS.n313 VSS.n312 4.5005
R1475 VSS.n37 VSS.n36 4.5005
R1476 VSS.n257 VSS 4.5005
R1477 VSS.n258 VSS 4.5005
R1478 VSS VSS.n264 4.5005
R1479 VSS.n267 VSS 4.5005
R1480 VSS.n130 VSS 4.5005
R1481 VSS VSS.n139 4.5005
R1482 VSS.n142 VSS 4.5005
R1483 VSS VSS.n128 4.5005
R1484 VSS VSS.n319 4.5005
R1485 VSS.n322 VSS 4.5005
R1486 VSS.n316 VSS.n34 4.5005
R1487 VSS.n34 VSS.n33 4.5005
R1488 VSS.n281 VSS 4.5005
R1489 VSS VSS.n60 4.5005
R1490 VSS.n85 VSS.t227 4.2135
R1491 VSS.n82 VSS.t224 4.2135
R1492 VSS.n86 VSS.t226 4.10325
R1493 VSS.n81 VSS.t223 4.10325
R1494 VSS.n144 VSS.t54 4.10212
R1495 VSS.n124 VSS.t5 4.10212
R1496 VSS.n125 VSS.t55 3.8985
R1497 VSS.n127 VSS.t6 3.8985
R1498 VSS.n312 VSS.n310 3.51359
R1499 VSS.n193 VSS.n192 3.4505
R1500 VSS.n205 VSS.n204 3.4505
R1501 VSS.n196 VSS.n102 3.34425
R1502 VSS.n208 VSS.n96 3.34425
R1503 VSS.n54 VSS.n52 3.33211
R1504 VSS VSS.t115 3.28446
R1505 VSS VSS.t121 3.28446
R1506 VSS VSS.n218 3.0005
R1507 VSS VSS.n233 3.0005
R1508 VSS.n33 VSS 2.8744
R1509 VSS.n297 VSS.n51 2.6483
R1510 VSS.n300 VSS.n51 2.6483
R1511 VSS.n297 VSS.n50 2.6483
R1512 VSS.n306 VSS.n305 2.6483
R1513 VSS.n306 VSS.n46 2.6483
R1514 VSS.n48 VSS.n46 2.6483
R1515 VSS.t100 VSS 2.61167
R1516 VSS VSS.t112 2.61167
R1517 VSS.n308 VSS.t8 2.49329
R1518 VSS.n292 VSS.n291 2.49281
R1519 VSS VSS.n50 2.4449
R1520 VSS.n305 VSS 2.4449
R1521 VSS VSS.n81 2.3755
R1522 VSS.n245 VSS 2.3655
R1523 VSS VSS.n215 2.3655
R1524 VSS.n264 VSS 2.33287
R1525 VSS VSS.n267 2.33287
R1526 VSS.n308 VSS.n40 2.30519
R1527 VSS.n291 VSS.n288 2.3047
R1528 VSS.n315 VSS.n314 2.24472
R1529 VSS.n118 VSS 2.2405
R1530 VSS VSS.n106 2.2405
R1531 VSS.n311 VSS.n37 2.23795
R1532 VSS.n313 VSS.n38 2.23795
R1533 VSS.n318 VSS.n317 2.23795
R1534 VSS.n35 VSS.n34 2.23795
R1535 VSS.n318 VSS.n32 2.23795
R1536 VSS VSS.n12 2.19246
R1537 VSS VSS.n124 2.168
R1538 VSS.n143 VSS.n142 2.12537
R1539 VSS.n128 VSS.n126 2.12537
R1540 VSS VSS.n82 2.02912
R1541 VSS.n85 VSS 2.02912
R1542 VSS VSS.t85 2.00766
R1543 VSS VSS.t64 2.00766
R1544 VSS VSS.t88 2.00766
R1545 VSS VSS.t61 2.00766
R1546 VSS VSS.t97 1.99496
R1547 VSS VSS.t94 1.99496
R1548 VSS VSS.t91 1.99496
R1549 VSS VSS.t103 1.99496
R1550 VSS VSS.n81 1.98175
R1551 VSS.n86 VSS 1.98175
R1552 VSS VSS.t76 1.9157
R1553 VSS VSS.t73 1.9157
R1554 VSS VSS.t106 1.89293
R1555 VSS VSS.t109 1.89293
R1556 VSS VSS.t67 1.8455
R1557 VSS VSS.t70 1.8455
R1558 VSS VSS.t79 1.8455
R1559 VSS VSS.t82 1.8455
R1560 VSS VSS.n20 1.79267
R1561 VSS VSS.n276 1.7605
R1562 VSS.n193 VSS 1.7255
R1563 VSS.n205 VSS 1.7255
R1564 VSS.t118 VSS 1.68846
R1565 VSS VSS.t124 1.68846
R1566 VSS.n102 VSS 1.67175
R1567 VSS VSS.n96 1.67175
R1568 VSS VSS.n152 1.6055
R1569 VSS.n153 VSS 1.6055
R1570 VSS.n303 VSS 1.56398
R1571 VSS VSS.n302 1.5638
R1572 VSS VSS.n70 1.5355
R1573 VSS VSS.n315 1.44425
R1574 VSS.n192 VSS 1.43925
R1575 VSS.n316 VSS 1.39175
R1576 VSS VSS.n220 1.35246
R1577 VSS VSS.n222 1.35246
R1578 VSS VSS.n224 1.35246
R1579 VSS VSS.n225 1.35246
R1580 VSS VSS.n227 1.35246
R1581 VSS VSS.n115 1.35246
R1582 VSS VSS.n114 1.35246
R1583 VSS VSS.n104 1.35246
R1584 VSS VSS.n14 1.348
R1585 VSS VSS.t130 1.28946
R1586 VSS VSS.t127 1.28946
R1587 VSS VSS.n186 1.2605
R1588 VSS VSS.n184 1.2605
R1589 VSS VSS.n182 1.2605
R1590 VSS VSS.n180 1.2605
R1591 VSS VSS.n178 1.2605
R1592 VSS VSS.n176 1.2605
R1593 VSS VSS.n174 1.2605
R1594 VSS VSS.n172 1.2605
R1595 VSS VSS.n170 1.2605
R1596 VSS VSS.n168 1.2605
R1597 VSS VSS.n166 1.2605
R1598 VSS VSS.n93 1.2605
R1599 VSS VSS.n29 1.2605
R1600 VSS.n309 VSS 1.24121
R1601 VSS VSS.n290 1.24121
R1602 VSS.n248 VSS 1.233
R1603 VSS.n239 VSS 1.233
R1604 VSS VSS.n156 1.233
R1605 VSS.n157 VSS 1.233
R1606 VSS.n127 VSS 1.21662
R1607 VSS VSS.n125 1.21662
R1608 VSS.n256 VSS.n31 1.17248
R1609 VSS VSS.n124 1.16925
R1610 VSS VSS.n144 1.16925
R1611 VSS VSS.n322 1.16925
R1612 VSS VSS.n196 1.158
R1613 VSS VSS.n71 1.14246
R1614 VSS VSS.n23 1.1205
R1615 VSS VSS.n325 1.1205
R1616 VSS.n326 VSS 1.1205
R1617 VSS VSS.n335 1.0955
R1618 VSS.n12 VSS.t115 1.0925
R1619 VSS.n12 VSS.t241 1.0925
R1620 VSS.n245 VSS.n214 1.078
R1621 VSS.n152 VSS.n151 1.078
R1622 VSS.n277 VSS 0.9655
R1623 VSS.n210 VSS.n94 0.939071
R1624 VSS.n167 VSS.n94 0.939071
R1625 VSS.n169 VSS.n167 0.939071
R1626 VSS.n171 VSS.n169 0.939071
R1627 VSS.n173 VSS.n171 0.939071
R1628 VSS.n175 VSS.n173 0.939071
R1629 VSS.n179 VSS.n177 0.939071
R1630 VSS.n181 VSS.n179 0.939071
R1631 VSS.n183 VSS.n181 0.939071
R1632 VSS.n185 VSS.n183 0.939071
R1633 VSS.n187 VSS.n185 0.939071
R1634 VSS.n188 VSS.n187 0.939071
R1635 VSS.n231 VSS.n228 0.939071
R1636 VSS.n228 VSS.n226 0.939071
R1637 VSS.n226 VSS 0.939071
R1638 VSS VSS.n223 0.939071
R1639 VSS.n223 VSS.n221 0.939071
R1640 VSS.n221 VSS.n219 0.939071
R1641 VSS.n164 VSS.n105 0.939071
R1642 VSS VSS.n105 0.939071
R1643 VSS.n116 VSS 0.939071
R1644 VSS.n117 VSS.n116 0.939071
R1645 VSS.n301 VSS 0.887643
R1646 VSS.n290 VSS 0.886036
R1647 VSS.n304 VSS 0.886036
R1648 VSS.n309 VSS 0.886036
R1649 VSS VSS.n274 0.879957
R1650 VSS VSS.n75 0.8405
R1651 VSS.n20 VSS.t100 0.8195
R1652 VSS.n20 VSS.t246 0.8195
R1653 VSS VSS.n240 0.7855
R1654 VSS VSS.n249 0.7855
R1655 VSS VSS.n158 0.7855
R1656 VSS VSS.n112 0.7855
R1657 VSS.n232 VSS 0.778
R1658 VSS.n163 VSS 0.778
R1659 VSS.n258 VSS 0.723
R1660 VSS VSS.n257 0.723
R1661 VSS.n139 VSS 0.723
R1662 VSS VSS.n130 0.723
R1663 VSS VSS.n61 0.7205
R1664 VSS VSS.n275 0.7205
R1665 VSS.n276 VSS 0.704848
R1666 VSS VSS.n277 0.704848
R1667 VSS VSS.n70 0.704848
R1668 VSS.n75 VSS 0.704848
R1669 VSS.n14 VSS 0.704848
R1670 VSS VSS.n16 0.704848
R1671 VSS VSS.n11 0.704848
R1672 VSS.n24 VSS 0.704848
R1673 VSS VSS.n214 0.704848
R1674 VSS.n232 VSS 0.704848
R1675 VSS.n151 VSS 0.704848
R1676 VSS VSS.n163 0.704848
R1677 VSS.n255 VSS 0.703
R1678 VSS VSS.n259 0.703
R1679 VSS VSS.n136 0.703
R1680 VSS VSS.n129 0.703
R1681 VSS VSS.n19 0.6989
R1682 VSS.n279 VSS.n273 0.68666
R1683 VSS.n334 VSS.n18 0.68594
R1684 VSS.n186 VSS.t180 0.6557
R1685 VSS.n186 VSS.t182 0.6557
R1686 VSS.n184 VSS.t176 0.6557
R1687 VSS.n184 VSS.t174 0.6557
R1688 VSS.n182 VSS.t172 0.6557
R1689 VSS.n182 VSS.t170 0.6557
R1690 VSS.n180 VSS.t168 0.6557
R1691 VSS.n180 VSS.t166 0.6557
R1692 VSS.n178 VSS.t164 0.6557
R1693 VSS.n178 VSS.t162 0.6557
R1694 VSS.n176 VSS.t160 0.6557
R1695 VSS.n176 VSS.t158 0.6557
R1696 VSS.n174 VSS.t156 0.6557
R1697 VSS.n174 VSS.t154 0.6557
R1698 VSS.n172 VSS.t152 0.6557
R1699 VSS.n172 VSS.t150 0.6557
R1700 VSS.n170 VSS.t148 0.6557
R1701 VSS.n170 VSS.t146 0.6557
R1702 VSS.n168 VSS.t144 0.6557
R1703 VSS.n168 VSS.t142 0.6557
R1704 VSS.n166 VSS.t140 0.6557
R1705 VSS.n166 VSS.t138 0.6557
R1706 VSS.n93 VSS.t136 0.6557
R1707 VSS.n93 VSS.t134 0.6557
R1708 VSS.n220 VSS.t200 0.6557
R1709 VSS.n220 VSS.t198 0.6557
R1710 VSS.n222 VSS.t196 0.6557
R1711 VSS.n222 VSS.t194 0.6557
R1712 VSS.n224 VSS.t192 0.6557
R1713 VSS.n224 VSS.t190 0.6557
R1714 VSS.n225 VSS.t188 0.6557
R1715 VSS.n225 VSS.t186 0.6557
R1716 VSS.n227 VSS.t184 0.6557
R1717 VSS.n227 VSS.t178 0.6557
R1718 VSS.n115 VSS.t202 0.6557
R1719 VSS.n115 VSS.t208 0.6557
R1720 VSS.n114 VSS.t210 0.6557
R1721 VSS.n114 VSS.t204 0.6557
R1722 VSS.n104 VSS.t206 0.6557
R1723 VSS.n104 VSS.t132 0.6557
R1724 VSS.n16 VSS 0.653
R1725 VSS VSS.n4 0.6505
R1726 VSS.n77 VSS.n4 0.6505
R1727 VSS VSS.n5 0.6505
R1728 VSS.n339 VSS.n5 0.6505
R1729 VSS.n24 VSS 0.6355
R1730 VSS VSS.n342 0.6341
R1731 VSS.n29 VSS.t218 0.632932
R1732 VSS.n29 VSS.t239 0.632932
R1733 VSS.n74 VSS.n64 0.6255
R1734 VSS.n272 VSS.n63 0.6255
R1735 VSS.n15 VSS.n3 0.6255
R1736 VSS.n341 VSS.n2 0.6255
R1737 VSS.n332 VSS.n331 0.6255
R1738 VSS.n240 VSS.n239 0.6255
R1739 VSS.n249 VSS.n248 0.6255
R1740 VSS.n209 VSS.n208 0.6255
R1741 VSS.n158 VSS.n157 0.6255
R1742 VSS.n156 VSS.n112 0.6255
R1743 VSS.n257 VSS.n255 0.6255
R1744 VSS.n259 VSS.n258 0.6255
R1745 VSS.n136 VSS.n130 0.6255
R1746 VSS.n139 VSS.n129 0.6255
R1747 VSS.n281 VSS.n61 0.6255
R1748 VSS.n275 VSS.n60 0.6255
R1749 VSS.n230 VSS.n37 0.6251
R1750 VSS VSS.n74 0.5955
R1751 VSS VSS.n63 0.5955
R1752 VSS.n336 VSS 0.578278
R1753 VSS.n337 VSS.n336 0.578278
R1754 VSS VSS.n330 0.578278
R1755 VSS.n330 VSS.n329 0.578278
R1756 VSS VSS.n210 0.556571
R1757 VSS VSS.n188 0.556571
R1758 VSS.n22 VSS 0.550143
R1759 VSS.n231 VSS 0.550143
R1760 VSS.n71 VSS.t118 0.5465
R1761 VSS.n71 VSS.t216 0.5465
R1762 VSS VSS.n326 0.54425
R1763 VSS.n325 VSS 0.54425
R1764 VSS VSS.n30 0.542107
R1765 VSS VSS.n209 0.533
R1766 VSS.n197 VSS 0.533
R1767 VSS.n218 VSS 0.533
R1768 VSS.n233 VSS 0.533
R1769 VSS VSS.n118 0.533
R1770 VSS VSS.n106 0.533
R1771 VSS VSS.n324 0.5205
R1772 VSS.n327 VSS 0.5205
R1773 VSS VSS.n150 0.5205
R1774 VSS.n150 VSS.n149 0.5205
R1775 VSS VSS.n162 0.5205
R1776 VSS.n162 VSS.n161 0.5205
R1777 VSS VSS.n216 0.5205
R1778 VSS.n216 VSS.n89 0.5205
R1779 VSS VSS.n217 0.5205
R1780 VSS.n238 VSS.n217 0.5205
R1781 VSS VSS.n101 0.5205
R1782 VSS.n134 VSS.n101 0.5205
R1783 VSS VSS.n95 0.5205
R1784 VSS.n201 VSS.n95 0.5205
R1785 VSS.n117 VSS 0.514786
R1786 VSS.n22 VSS 0.4955
R1787 VSS.n219 VSS 0.4955
R1788 VSS VSS.n164 0.4955
R1789 VSS.n332 VSS 0.4855
R1790 VSS.n335 VSS 0.4855
R1791 VSS.n319 VSS 0.4855
R1792 VSS.n322 VSS 0.4855
R1793 VSS VSS.n60 0.4855
R1794 VSS VSS.n281 0.4855
R1795 VSS.n278 VSS 0.476214
R1796 VSS.n30 VSS 0.476214
R1797 VSS.n195 VSS.n194 0.4757
R1798 VSS.n207 VSS.n206 0.4757
R1799 VSS.n305 VSS.n45 0.473227
R1800 VSS.n46 VSS.n44 0.473227
R1801 VSS.n44 VSS.n43 0.473227
R1802 VSS.n53 VSS.n51 0.473227
R1803 VSS.n296 VSS.n53 0.473227
R1804 VSS.n52 VSS.n50 0.473227
R1805 VSS VSS.n65 0.473227
R1806 VSS.n69 VSS.n65 0.473227
R1807 VSS VSS.n66 0.473227
R1808 VSS.n78 VSS.n66 0.473227
R1809 VSS.n45 VSS.n41 0.471002
R1810 VSS.n331 VSS 0.4705
R1811 VSS VSS.n175 0.469786
R1812 VSS.n177 VSS 0.469786
R1813 VSS VSS.n17 0.460143
R1814 VSS VSS.n278 0.456929
R1815 VSS.n73 VSS 0.4505
R1816 VSS.n274 VSS.t237 0.41
R1817 VSS.n274 VSS.t213 0.41
R1818 VSS VSS.n15 0.408
R1819 VSS VSS.n2 0.408
R1820 VSS VSS.n131 0.4005
R1821 VSS.n131 VSS.n109 0.4005
R1822 VSS VSS.n132 0.4005
R1823 VSS.n135 VSS.n132 0.4005
R1824 VSS.n260 VSS 0.4005
R1825 VSS.n261 VSS.n260 0.4005
R1826 VSS VSS.n254 0.4005
R1827 VSS.n254 VSS.n253 0.4005
R1828 VSS VSS.n59 0.4005
R1829 VSS.n67 VSS.n59 0.4005
R1830 VSS VSS.n56 0.4005
R1831 VSS VSS.n64 0.3855
R1832 VSS.n272 VSS 0.3855
R1833 VSS VSS.n3 0.3855
R1834 VSS.n341 VSS 0.3855
R1835 VSS.n147 VSS 0.371929
R1836 VSS.n148 VSS.n147 0.371929
R1837 VSS.n159 VSS 0.371929
R1838 VSS.n160 VSS.n159 0.371929
R1839 VSS.n250 VSS 0.371929
R1840 VSS.n251 VSS.n250 0.371929
R1841 VSS.n241 VSS 0.371929
R1842 VSS.n242 VSS.n241 0.371929
R1843 VSS.n73 VSS 0.366929
R1844 VSS.n17 VSS 0.366929
R1845 VSS.n141 VSS.n140 0.35474
R1846 VSS.n266 VSS.n83 0.35474
R1847 VSS.n265 VSS.n84 0.35474
R1848 VSS.n229 VSS.n213 0.3497
R1849 VSS VSS.n8 0.347167
R1850 VSS.t240 VSS.n8 0.347167
R1851 VSS VSS.n340 0.347167
R1852 VSS.n340 VSS.t240 0.347167
R1853 VSS.n76 VSS 0.347167
R1854 VSS.t215 VSS.n76 0.347167
R1855 VSS VSS.n271 0.347167
R1856 VSS.n271 VSS.t215 0.347167
R1857 VSS VSS.n99 0.347167
R1858 VSS.n133 VSS.n99 0.347167
R1859 VSS VSS.n203 0.347167
R1860 VSS.n203 VSS.n202 0.347167
R1861 VSS VSS.n86 0.3355
R1862 VSS.n144 VSS 0.3355
R1863 VSS.n155 VSS.n154 0.33386
R1864 VSS.n246 VSS.n213 0.33386
R1865 VSS.n23 VSS.n11 0.3105
R1866 VSS.n307 VSS.n306 0.306382
R1867 VSS.t8 VSS.n307 0.306382
R1868 VSS.n48 VSS.n47 0.306382
R1869 VSS.n298 VSS.n297 0.306382
R1870 VSS.t234 VSS.n298 0.306382
R1871 VSS.n300 VSS.n299 0.306382
R1872 VSS.n299 VSS.t234 0.306382
R1873 VSS VSS.n28 0.306382
R1874 VSS.n323 VSS.n28 0.306382
R1875 VSS VSS.n9 0.306382
R1876 VSS.n25 VSS.n9 0.306382
R1877 VSS VSS.n10 0.306382
R1878 VSS.n25 VSS.n10 0.306382
R1879 VSS VSS.n27 0.306382
R1880 VSS.n27 VSS.n26 0.306382
R1881 VSS.n282 VSS 0.306382
R1882 VSS.n283 VSS.n282 0.306382
R1883 VSS VSS.n58 0.306382
R1884 VSS.n283 VSS.n58 0.306382
R1885 VSS.n266 VSS 0.30596
R1886 VSS VSS.n265 0.30596
R1887 VSS.n47 VSS.n41 0.305119
R1888 VSS VSS.n215 0.2905
R1889 VSS.n204 VSS 0.2905
R1890 VSS.n153 VSS 0.2905
R1891 VSS.n319 VSS 0.2905
R1892 VSS.t214 VSS.t201 0.260583
R1893 VSS.n137 VSS 0.248119
R1894 VSS.t232 VSS.n137 0.248119
R1895 VSS VSS.n138 0.248119
R1896 VSS.n138 VSS.t232 0.248119
R1897 VSS VSS.n87 0.248119
R1898 VSS.t228 VSS.n87 0.248119
R1899 VSS VSS.n88 0.248119
R1900 VSS.t228 VSS.n88 0.248119
R1901 VSS.n191 VSS 0.24188
R1902 VSS VSS.n97 0.24188
R1903 VSS VSS.n21 0.238357
R1904 VSS.n320 VSS.n318 0.22874
R1905 VSS.n140 VSS.n83 0.21002
R1906 VSS.n256 VSS.n84 0.21002
R1907 VSS.n126 VSS.n120 0.2005
R1908 VSS.n120 VSS.n55 0.2005
R1909 VSS.n143 VSS.n123 0.2005
R1910 VSS.n123 VSS.n122 0.2005
R1911 VSS VSS.n110 0.17981
R1912 VSS.t28 VSS.n110 0.17981
R1913 VSS VSS.n111 0.17981
R1914 VSS.t28 VSS.n111 0.17981
R1915 VSS VSS.n90 0.17981
R1916 VSS.t21 VSS.n90 0.17981
R1917 VSS VSS.n91 0.17981
R1918 VSS.t21 VSS.n91 0.17981
R1919 VSS.n189 VSS.n165 0.1769
R1920 VSS.n212 VSS.n211 0.1769
R1921 VSS.n268 VSS 0.173833
R1922 VSS.n269 VSS.n268 0.173833
R1923 VSS VSS.n263 0.173833
R1924 VSS.n263 VSS.n262 0.173833
R1925 VSS.n145 VSS 0.168242
R1926 VSS.n146 VSS.n145 0.168242
R1927 VSS VSS.n119 0.168242
R1928 VSS.n146 VSS.n119 0.168242
R1929 VSS VSS.n24 0.1605
R1930 VSS VSS.n11 0.1605
R1931 VSS VSS.n300 0.1499
R1932 VSS VSS.n48 0.1499
R1933 VSS VSS.n107 0.144944
R1934 VSS.n121 VSS.n107 0.144944
R1935 VSS VSS.n108 0.144944
R1936 VSS.n121 VSS.n108 0.144944
R1937 VSS.n321 VSS.n320 0.14162
R1938 VSS.n334 VSS.n333 0.14162
R1939 VSS.n155 VSS.n113 0.13082
R1940 VSS VSS.n79 0.118682
R1941 VSS.n199 VSS.n79 0.118682
R1942 VSS VSS.n80 0.118682
R1943 VSS.n199 VSS.n80 0.118682
R1944 VSS.n273 VSS.n62 0.11282
R1945 VSS.n342 VSS.n1 0.11282
R1946 VSS VSS.n72 0.109786
R1947 VSS.n13 VSS 0.109786
R1948 VSS VSS.n244 0.106622
R1949 VSS.n244 VSS.n243 0.106622
R1950 VSS.n234 VSS 0.106622
R1951 VSS.n243 VSS.n234 0.106622
R1952 VSS.n230 VSS.n229 0.10634
R1953 VSS.n333 VSS.n19 0.10634
R1954 VSS.n321 VSS.n31 0.10454
R1955 VSS.n302 VSS.n49 0.10418
R1956 VSS.n303 VSS.n39 0.104
R1957 VSS.n310 VSS.n39 0.104
R1958 VSS.n18 VSS.n1 0.08618
R1959 VSS.n264 VSS.n85 0.0857632
R1960 VSS.n267 VSS.n82 0.0857632
R1961 VSS.n142 VSS.n125 0.0857632
R1962 VSS.n128 VSS.n127 0.0857632
R1963 VSS.n280 VSS.n279 0.08546
R1964 VSS.n190 VSS.n189 0.08474
R1965 VSS.n211 VSS.n92 0.08474
R1966 VSS.n62 VSS.n0 0.08402
R1967 VSS.n75 VSS 0.0805
R1968 VSS.n70 VSS 0.0805
R1969 VSS.n16 VSS 0.0805
R1970 VSS.n14 VSS 0.0805
R1971 VSS VSS.n214 0.0805
R1972 VSS VSS.n232 0.0805
R1973 VSS.n151 VSS 0.0805
R1974 VSS.n163 VSS 0.0805
R1975 VSS.n277 VSS 0.0805
R1976 VSS.n276 VSS 0.0805
R1977 VSS.n165 VSS.n103 0.07106
R1978 VSS.n247 VSS.n212 0.07106
R1979 VSS.n198 VSS 0.0558191
R1980 VSS.n199 VSS.n198 0.0558191
R1981 VSS VSS.n100 0.0558191
R1982 VSS.n199 VSS.n100 0.0558191
R1983 VSS.n98 VSS 0.0541082
R1984 VSS.n199 VSS.n98 0.0541082
R1985 VSS.n200 VSS 0.0541082
R1986 VSS.n200 VSS.n199 0.0541082
R1987 VSS.n317 VSS.n35 0.0536955
R1988 VSS.n35 VSS.n32 0.0536955
R1989 VSS.n311 VSS.n38 0.0536955
R1990 VSS.n315 VSS.n36 0.053
R1991 VSS.n312 VSS.n311 0.0270978
R1992 VSS.n38 VSS.n36 0.0270978
R1993 VSS.n317 VSS.n316 0.0270978
R1994 VSS.n33 VSS.n32 0.0270978
R1995 VSS.n318 VSS.n34 0.0257
R1996 VSS VSS.n0 0.0257
R1997 VSS.n154 VSS.n103 0.02354
R1998 VSS.n195 VSS.n190 0.02354
R1999 VSS.n207 VSS.n92 0.02354
R2000 VSS.n247 VSS.n246 0.02354
R2001 VSS.n314 VSS.n313 0.0135648
R2002 VSS.n314 VSS.n37 0.0135648
R2003 VSS.n194 VSS.n191 0.00824
R2004 VSS.n206 VSS.n97 0.00824
R2005 VSS.t8 VSS.n41 0.00207056
R2006 VSS VSS.n143 0.00175
R2007 VSS.n126 VSS 0.00175
R2008 i2.0.n0 i2.0.t1 0.485833
R2009 i2.0.n0 i2.0.t3 0.485833
R2010 i2.0 i2.0.n0 0.742457
R2011 i2.0.n2 i2.0 0.238357
R2012 i2.0 i2.0.n2 0.68675
R2013 i2.0 i2.0.n3 0.032
R2014 i2.0.n3 i2.0 0.331571
R2015 i2.0 i2.0.n5 0.768714
R2016 i2.0.n5 i2.0 0.148357
R2017 i2.0 i2.0.n9 0.329196
R2018 i2.0.t10 i2.0.n9 66.8888
R2019 i2.0.t11 i2.0.n9 66.5757
R2020 i2.0.n5 i2.0 4.59371
R2021 i2.0 i2.0.n6 0.0787609
R2022 i2.0.n6 i2.0.n7 0.313543
R2023 i2.0.n7 i2.0.n8 0.313543
R2024 i2.0.t6 i2.0.n8 79.9245
R2025 i2.0.t7 i2.0.n8 79.6114
R2026 i2.0.t8 i2.0.n7 79.6114
R2027 i2.0.t9 i2.0.n6 79.6114
R2028 i2.0 i2.0.n3 5.68336
R2029 i2.0 i2.0.n4 1.14246
R2030 i2.0.t0 i2.0.n4 0.5465
R2031 i2.0.n4 i2.0.t5 0.5465
R2032 i2.0 i2.0.n2 9.0005
R2033 i2.0 i2.0.n1 0.742457
R2034 i2.0.t2 i2.0.n1 0.485833
R2035 i2.0.n1 i2.0.t4 0.485833
R2036 i1.0.t0 i1.0.n0 1.0925
R2037 i1.0.n0 i1.0.t3 1.0925
R2038 i1.0 i1.0.n0 2.19246
R2039 i1.0 i1.0.n1 0.19175
R2040 i1.0.n1 i1.0 0.156393
R2041 i1.0 i1.0.n5 0.835314
R2042 i1.0.t1 i1.0.n5 0.492392
R2043 i1.0.n5 i1.0.t2 0.492392
R2044 i1.0 i1.0.n1 4.59371
R2045 i1.0 i1.0.n2 0.656214
R2046 i1.0.n2 i1.0 0.100143
R2047 i1.0.t6 i1.0 54.0252
R2048 i1.0.n2 i1.0 4.59371
R2049 i1.0 i1.0.n3 0.425345
R2050 i1.0.n3 i1.0 1.91999
R2051 i1.0 i1.0.n4 0.391804
R2052 i1.0.t4 i1.0.n4 63.6298
R2053 i1.0.t5 i1.0.n4 63.3168
R2054 i1.0.n3 i1.0 4.59082
R2055 nm.0 nm.0.n0 1.5755
R2056 nm.0.t0 nm.0.n0 0.8195
R2057 nm.0.n0 nm.0.t1 0.8195
R2058 nd.0.n0 nd.0.t5 0.607167
R2059 nd.0.n0 nd.0.t4 0.607167
R2060 nd.0 nd.0.n0 0.959123
R2061 nd.0.n2 nd.0 0.238357
R2062 nd.0 nd.0.n2 0.689964
R2063 nd.0.n3 nd.0 4.5005
R2064 nd.0.n3 nd.0 0.0905
R2065 nd.0 nd.0.n3 6.47407
R2066 nd.0 nd.0.n5 1.78121
R2067 nd.0.n5 nd.0 0.0937143
R2068 nd.0.t6 nd.0 63.2128
R2069 nd.0.n5 nd.0 4.70621
R2070 nd.0.t7 nd.0 34.4736
R2071 nd.0 nd.0.n4 1.79267
R2072 nd.0.t0 nd.0.n4 0.8195
R2073 nd.0.n4 nd.0.t2 0.8195
R2074 nd.0 nd.0.n2 9.0005
R2075 nd.0 nd.0.n1 0.959123
R2076 nd.0.t3 nd.0.n1 0.607167
R2077 nd.0.n1 nd.0.t1 0.607167
R2078 d3.0.t1 d3.0.n0 0.9105
R2079 d3.0.n0 d3.0.t6 0.9105
R2080 d3.0 d3.0.n0 1.51767
R2081 d3.0 d3.0.n2 10.1448
R2082 d3.0.n2 d3.0 0.572643
R2083 d3.0 d3.0.n4 0.572643
R2084 d3.0.n4 d3.0.n6 1.14479
R2085 d3.0.n6 d3.0 1.07729
R2086 d3.0.n8 d3.0 3.80621
R2087 d3.0 d3.0.n8 5.00514
R2088 d3.0.n9 d3.0 1.47767
R2089 d3.0.t2 d3.0.n9 0.632932
R2090 d3.0.n9 d3.0.t0 0.632932
R2091 d3.0 d3.0.n8 7.51871
R2092 d3.0.n7 d3.0 2.11871
R2093 d3.0 d3.0.n7 1.0355
R2094 d3.0.t11 d3.0 40.9895
R2095 d3.0.n7 d3.0 5.94371
R2096 d3.0.t10 d3.0 54.0878
R2097 d3.0 d3.0.n6 9.0005
R2098 d3.0.n5 d3.0 1.51767
R2099 d3.0.t8 d3.0.n5 0.9105
R2100 d3.0.n5 d3.0.t7 0.9105
R2101 d3.0 d3.0.n4 9.0005
R2102 d3.0.n3 d3.0 1.51767
R2103 d3.0.t3 d3.0.n3 0.9105
R2104 d3.0.n3 d3.0.t9 0.9105
R2105 d3.0 d3.0.n2 9.0005
R2106 d3.0.n1 d3.0 1.51767
R2107 d3.0.t5 d3.0.n1 0.9105
R2108 d3.0.n1 d3.0.t4 0.9105
R2109 n3a.0.n0 n3a.0.t0 0.9105
R2110 n3a.0.n0 n3a.0.t5 0.9105
R2111 n3a.0 n3a.0.n0 1.51767
R2112 n3a.0 n3a.0.n9 9.0005
R2113 n3a.0.n9 n3a.0 0.781571
R2114 n3a.0 n3a.0.n8 0.329196
R2115 n3a.0.t13 n3a.0.n8 48.5084
R2116 n3a.0.t2 n3a.0.n8 48.1954
R2117 n3a.0 n3a.0.n7 1.47767
R2118 n3a.0.t1 n3a.0.n7 0.632932
R2119 n3a.0.n7 n3a.0.t3 0.632932
R2120 n3a.0.n9 n3a.0.n2 1.14479
R2121 n3a.0 n3a.0.n2 1.14479
R2122 n3a.0.n5 n3a.0 1.14479
R2123 n3a.0 n3a.0.n5 10.1448
R2124 n3a.0 n3a.0.n6 1.51767
R2125 n3a.0.t4 n3a.0.n6 0.9105
R2126 n3a.0.n6 n3a.0.t12 0.9105
R2127 n3a.0 n3a.0.n5 9.0005
R2128 n3a.0 n3a.0.n4 1.51767
R2129 n3a.0.t11 n3a.0.n4 0.9105
R2130 n3a.0.n4 n3a.0.t10 0.9105
R2131 n3a.0 n3a.0.n3 1.51767
R2132 n3a.0.t9 n3a.0.n3 0.9105
R2133 n3a.0.n3 n3a.0.t8 0.9105
R2134 n3a.0 n3a.0.n2 9.0005
R2135 n3a.0 n3a.0.n1 1.51767
R2136 n3a.0.t7 n3a.0.n1 0.9105
R2137 n3a.0.n1 n3a.0.t6 0.9105
R2138 sb.0 sb.0.t1 3.57
R2139 sb.0.n1 sb.0 1.42282
R2140 sb.0 sb.0.n1 0.309071
R2141 sb.0.n2 sb.0 0.879957
R2142 sb.0.t4 sb.0.n2 0.424852
R2143 sb.0.n2 sb.0.t3 0.424852
R2144 sb.0 sb.0.n1 9.0005
R2145 sb.0.n0 sb.0 0.879957
R2146 sb.0.t2 sb.0.n0 0.424852
R2147 sb.0.n0 sb.0.t0 0.424852
R2148 d2b.0.n0 d2b.0.t9 0.9105
R2149 d2b.0.n0 d2b.0.t11 0.9105
R2150 d2b.0 d2b.0.n0 1.51767
R2151 d2b.0 d2b.0.n30 9.0005
R2152 d2b.0.n30 d2b.0.n7 1.14479
R2153 d2b.0.n7 d2b.0 0.714071
R2154 d2b.0 d2b.0.n29 0.0487143
R2155 d2b.0 d2b.0.n29 0.746214
R2156 d2b.0.n28 d2b.0.n27 0.3605
R2157 d2b.0.n27 d2b.0.n26 0.3605
R2158 d2b.0.n26 d2b.0.n25 0.3605
R2159 d2b.0.n25 d2b.0 1.48354
R2160 d2b.0 d2b.0.n24 0.317457
R2161 d2b.0.n24 d2b.0.n23 0.3605
R2162 d2b.0.n23 d2b.0.n22 0.3605
R2163 d2b.0.n22 d2b.0.n21 0.3605
R2164 d2b.0.n21 d2b.0 11.1781
R2165 d2b.0.n28 d2b.0.t24 32.6125
R2166 d2b.0.n28 d2b.0.t4 31.5325
R2167 d2b.0.n27 d2b.0.t6 31.5325
R2168 d2b.0.n26 d2b.0.t23 31.5325
R2169 d2b.0.n25 d2b.0.t22 31.5325
R2170 d2b.0.n24 d2b.0.t21 31.5325
R2171 d2b.0.n23 d2b.0.t20 31.5325
R2172 d2b.0.n22 d2b.0.t8 31.5325
R2173 d2b.0.n21 d2b.0.t10 31.5325
R2174 d2b.0.n29 d2b.0.n20 5.08871
R2175 d2b.0 d2b.0.n20 0.119429
R2176 d2b.0 d2b.0.n19 1.39246
R2177 d2b.0.t13 d2b.0.n19 0.9105
R2178 d2b.0.n19 d2b.0.t19 0.9105
R2179 d2b.0.n20 d2b.0 0.109786
R2180 d2b.0 d2b.0.n8 0.993714
R2181 d2b.0.n8 d2b.0 0.993714
R2182 d2b.0 d2b.0.n17 1.16246
R2183 d2b.0.n17 d2b.0 0.309071
R2184 d2b.0 d2b.0.n18 0.879957
R2185 d2b.0.t17 d2b.0.n18 0.424852
R2186 d2b.0.n18 d2b.0.t16 0.424852
R2187 d2b.0 d2b.0.n17 9.0005
R2188 d2b.0 d2b.0.n16 0.879957
R2189 d2b.0.t3 d2b.0.n16 0.424852
R2190 d2b.0.n16 d2b.0.t18 0.424852
R2191 d2b.0 d2b.0.n8 10.7812
R2192 d2b.0.n15 d2b.0.n14 1.0805
R2193 d2b.0.n14 d2b.0.n13 0.3605
R2194 d2b.0.n13 d2b.0.n12 1.0805
R2195 d2b.0.n12 d2b.0 0.223543
R2196 d2b.0 d2b.0.n11 0.137457
R2197 d2b.0.n11 d2b.0.n10 1.0805
R2198 d2b.0.n10 d2b.0.n9 0.3605
R2199 d2b.0.n9 d2b.0 10.4581
R2200 d2b.0.n15 d2b.0.t32 31.8925
R2201 d2b.0.n15 d2b.0.t31 31.5325
R2202 d2b.0.n14 d2b.0.t30 31.5325
R2203 d2b.0.n13 d2b.0.t29 31.5325
R2204 d2b.0.n12 d2b.0.t28 31.5325
R2205 d2b.0.n11 d2b.0.t27 31.5325
R2206 d2b.0.n10 d2b.0.t26 31.5325
R2207 d2b.0.n9 d2b.0.t25 31.5325
R2208 d2b.0 d2b.0.n7 9.0005
R2209 d2b.0.n6 d2b.0 1.51767
R2210 d2b.0.t14 d2b.0.n6 0.9105
R2211 d2b.0.n6 d2b.0.t12 0.9105
R2212 d2b.0 d2b.0.n30 0.868357
R2213 d2b.0.n2 d2b.0 0.276929
R2214 d2b.0.n4 d2b.0.n2 0.553357
R2215 d2b.0 d2b.0.n4 10.1448
R2216 d2b.0.n5 d2b.0 1.51767
R2217 d2b.0.t5 d2b.0.n5 0.9105
R2218 d2b.0.n5 d2b.0.t7 0.9105
R2219 d2b.0 d2b.0.n4 9.0005
R2220 d2b.0.n3 d2b.0 1.51767
R2221 d2b.0.t2 d2b.0.n3 0.9105
R2222 d2b.0.n3 d2b.0.t1 0.9105
R2223 d2b.0 d2b.0.n2 9.0005
R2224 d2b.0.n1 d2b.0 1.51767
R2225 d2b.0.t0 d2b.0.n1 0.9105
R2226 d2b.0.n1 d2b.0.t15 0.9105
R2227 rlb_m1.0 rlb_m1.0.t0 3.57
R2228 rlb_m1.0 rlb_m1.0.t1 3.57
R2229 rla_m1.0 rla_m1.0.t0 3.57
R2230 rla_m1.0 rla_m1.0.t1 3.57
R2231 sa.0 sa.0.t0 3.57
R2232 sa.0.n1 sa.0 1.38746
R2233 sa.0 sa.0.n1 0.309071
R2234 sa.0.n2 sa.0 0.879957
R2235 sa.0.t3 sa.0.n2 0.424852
R2236 sa.0.n2 sa.0.t2 0.424852
R2237 sa.0 sa.0.n1 9.0005
R2238 sa.0.n0 sa.0 0.879957
R2239 sa.0.t4 sa.0.n0 0.424852
R2240 sa.0.n0 sa.0.t1 0.424852
R2241 d2a.0.n0 d2a.0.t4 0.9105
R2242 d2a.0.n0 d2a.0.t5 0.9105
R2243 d2a.0 d2a.0.n0 1.51767
R2244 d2a.0 d2a.0.n30 9.0005
R2245 d2a.0 d2a.0.n30 10.1448
R2246 d2a.0 d2a.0.n29 1.51767
R2247 d2a.0.t16 d2a.0.n29 0.9105
R2248 d2a.0.n29 d2a.0.t18 0.9105
R2249 d2a.0 d2a.0.n30 1.16407
R2250 d2a.0.n2 d2a.0 0.572643
R2251 d2a.0.n4 d2a.0.n2 1.14479
R2252 d2a.0.n6 d2a.0.n4 0.553357
R2253 d2a.0.n28 d2a.0 0.0487143
R2254 d2a.0 d2a.0.n6 0.714071
R2255 d2a.0.n28 d2a.0 0.746214
R2256 d2a.0 d2a.0.n20 10.4581
R2257 d2a.0.n20 d2a.0.n21 0.3605
R2258 d2a.0.n21 d2a.0 1.75746
R2259 d2a.0 d2a.0.n22 0.0435435
R2260 d2a.0.n22 d2a.0.n23 0.3605
R2261 d2a.0.n23 d2a.0.n24 0.3605
R2262 d2a.0.n24 d2a.0.n25 0.3605
R2263 d2a.0.n25 d2a.0.n26 1.8005
R2264 d2a.0.n26 d2a.0.n27 0.3605
R2265 d2a.0.t20 d2a.0.n27 31.8925
R2266 d2a.0.t17 d2a.0.n27 31.5325
R2267 d2a.0.t15 d2a.0.n26 31.5325
R2268 d2a.0.t21 d2a.0.n25 31.5325
R2269 d2a.0.t22 d2a.0.n24 31.5325
R2270 d2a.0.t23 d2a.0.n23 31.5325
R2271 d2a.0.t24 d2a.0.n22 31.5325
R2272 d2a.0.t13 d2a.0.n21 31.5325
R2273 d2a.0.t11 d2a.0.n20 31.5325
R2274 d2a.0.n28 d2a.0 5.17871
R2275 d2a.0 d2a.0.n7 0.3155
R2276 d2a.0.n7 d2a.0 1.89371
R2277 d2a.0.n18 d2a.0 1.32639
R2278 d2a.0 d2a.0.n18 0.309071
R2279 d2a.0 d2a.0.n19 0.879957
R2280 d2a.0.t0 d2a.0.n19 0.424852
R2281 d2a.0.n19 d2a.0.t9 0.424852
R2282 d2a.0 d2a.0.n18 9.0005
R2283 d2a.0 d2a.0.n17 0.879957
R2284 d2a.0.t8 d2a.0.n17 0.424852
R2285 d2a.0.n17 d2a.0.t10 0.424852
R2286 d2a.0 d2a.0.n7 5.04371
R2287 d2a.0.n16 d2a.0 5.04371
R2288 d2a.0 d2a.0.n16 0.151571
R2289 d2a.0 d2a.0.n15 1.39246
R2290 d2a.0.t6 d2a.0.n15 0.9105
R2291 d2a.0.n15 d2a.0.t19 0.9105
R2292 d2a.0.n16 d2a.0 0.431214
R2293 d2a.0 d2a.0.n8 10.0981
R2294 d2a.0.n8 d2a.0.n9 1.0805
R2295 d2a.0.n9 d2a.0.n10 0.3605
R2296 d2a.0.n10 d2a.0 0.677457
R2297 d2a.0 d2a.0.n11 0.403543
R2298 d2a.0.n11 d2a.0.n12 0.3605
R2299 d2a.0.n12 d2a.0.n13 1.0805
R2300 d2a.0.n13 d2a.0.n14 0.3605
R2301 d2a.0.t25 d2a.0.n14 32.6125
R2302 d2a.0.t26 d2a.0.n14 31.5325
R2303 d2a.0.t27 d2a.0.n13 31.5325
R2304 d2a.0.t28 d2a.0.n12 31.5325
R2305 d2a.0.t29 d2a.0.n11 31.5325
R2306 d2a.0.t30 d2a.0.n10 31.5325
R2307 d2a.0.t31 d2a.0.n9 31.5325
R2308 d2a.0.t32 d2a.0.n8 31.5325
R2309 d2a.0 d2a.0.n6 9.0005
R2310 d2a.0 d2a.0.n5 1.51767
R2311 d2a.0.t7 d2a.0.n5 0.9105
R2312 d2a.0.n5 d2a.0.t1 0.9105
R2313 d2a.0 d2a.0.n4 9.0005
R2314 d2a.0 d2a.0.n3 1.51767
R2315 d2a.0.t12 d2a.0.n3 0.9105
R2316 d2a.0.n3 d2a.0.t14 0.9105
R2317 d2a.0 d2a.0.n2 9.0005
R2318 d2a.0 d2a.0.n1 1.51767
R2319 d2a.0.t2 d2a.0.n1 0.9105
R2320 d2a.0.n1 d2a.0.t3 0.9105
R2321 ts.0.t8 ts.0.n0 0.6557
R2322 ts.0.n0 ts.0.t2 0.6557
R2323 ts.0 ts.0.n0 1.35246
R2324 ts.0 ts.0.n6 9.0005
R2325 ts.0.n6 ts.0 0.871571
R2326 ts.0.t9 ts.0 3.57
R2327 ts.0.t0 ts.0 3.57
R2328 ts.0.n6 ts.0.n2 0.939071
R2329 ts.0 ts.0.n2 0.469786
R2330 ts.0.n4 ts.0 0.469786
R2331 ts.0 ts.0.n4 9.93907
R2332 ts.0 ts.0.n5 1.35246
R2333 ts.0.t1 ts.0.n5 0.6557
R2334 ts.0.n5 ts.0.t3 0.6557
R2335 ts.0 ts.0.n4 9.0005
R2336 ts.0 ts.0.n3 1.35246
R2337 ts.0.t4 ts.0.n3 0.6557
R2338 ts.0.n3 ts.0.t5 0.6557
R2339 ts.0 ts.0.n2 9.0005
R2340 ts.0 ts.0.n1 1.35246
R2341 ts.0.t6 ts.0.n1 0.6557
R2342 ts.0.n1 ts.0.t7 0.6557
R2343 tn.0.t46 tn.0.n0 0.6557
R2344 tn.0.n0 tn.0.t36 0.6557
R2345 tn.0 tn.0.n0 1.35246
R2346 tn.0 tn.0.n49 9.0005
R2347 tn.0.n49 tn.0 1.30229
R2348 tn.0 tn.0.n11 0.842643
R2349 tn.0.n11 tn.0.n13 0.617643
R2350 tn.0.n13 tn.0.n15 0.617643
R2351 tn.0.n15 tn.0.n17 0.617643
R2352 tn.0.n17 tn.0.n19 0.617643
R2353 tn.0.n19 tn.0.n21 0.617643
R2354 tn.0.n21 tn.0.n23 0.617643
R2355 tn.0.n23 tn.0.n25 0.617643
R2356 tn.0.n25 tn.0.n27 0.617643
R2357 tn.0.n27 tn.0.n29 0.617643
R2358 tn.0.n29 tn.0 0.309071
R2359 tn.0 tn.0.n31 0.309071
R2360 tn.0.n31 tn.0.n33 0.617643
R2361 tn.0.n33 tn.0.n35 0.617643
R2362 tn.0.n35 tn.0.n37 0.617643
R2363 tn.0.n37 tn.0.n39 0.617643
R2364 tn.0.n39 tn.0.n41 0.617643
R2365 tn.0.n41 tn.0.n43 0.617643
R2366 tn.0.n43 tn.0.n45 0.617643
R2367 tn.0.n45 tn.0.n47 0.617643
R2368 tn.0 tn.0.n47 9.61764
R2369 tn.0.n48 tn.0 0.6305
R2370 tn.0.t22 tn.0.n48 0.345342
R2371 tn.0.n48 tn.0.t20 0.345342
R2372 tn.0 tn.0.n47 9.0005
R2373 tn.0.n46 tn.0 0.6305
R2374 tn.0.t14 tn.0.n46 0.345342
R2375 tn.0.n46 tn.0.t21 0.345342
R2376 tn.0 tn.0.n45 9.0005
R2377 tn.0.n44 tn.0 0.6305
R2378 tn.0.t26 tn.0.n44 0.345342
R2379 tn.0.n44 tn.0.t13 0.345342
R2380 tn.0 tn.0.n43 9.0005
R2381 tn.0.n42 tn.0 0.6305
R2382 tn.0.t12 tn.0.n42 0.345342
R2383 tn.0.n42 tn.0.t25 0.345342
R2384 tn.0 tn.0.n41 9.0005
R2385 tn.0.n40 tn.0 0.6305
R2386 tn.0.t4 tn.0.n40 0.345342
R2387 tn.0.n40 tn.0.t47 0.345342
R2388 tn.0 tn.0.n39 9.0005
R2389 tn.0.n38 tn.0 0.6305
R2390 tn.0.t49 tn.0.n38 0.345342
R2391 tn.0.n38 tn.0.t1 0.345342
R2392 tn.0 tn.0.n37 9.0005
R2393 tn.0.n36 tn.0 0.6305
R2394 tn.0.t0 tn.0.n36 0.345342
R2395 tn.0.n36 tn.0.t9 0.345342
R2396 tn.0 tn.0.n35 9.0005
R2397 tn.0.n34 tn.0 0.6305
R2398 tn.0.t5 tn.0.n34 0.345342
R2399 tn.0.n34 tn.0.t10 0.345342
R2400 tn.0 tn.0.n33 9.0005
R2401 tn.0.n32 tn.0 0.6305
R2402 tn.0.t31 tn.0.n32 0.345342
R2403 tn.0.n32 tn.0.t32 0.345342
R2404 tn.0 tn.0.n31 9.0005
R2405 tn.0.n30 tn.0 0.6305
R2406 tn.0.t33 tn.0.n30 0.345342
R2407 tn.0.n30 tn.0.t6 0.345342
R2408 tn.0 tn.0.n29 9.0005
R2409 tn.0.n28 tn.0 0.6305
R2410 tn.0.t48 tn.0.n28 0.345342
R2411 tn.0.n28 tn.0.t7 0.345342
R2412 tn.0 tn.0.n27 9.0005
R2413 tn.0.n26 tn.0 0.6305
R2414 tn.0.t51 tn.0.n26 0.345342
R2415 tn.0.n26 tn.0.t50 0.345342
R2416 tn.0 tn.0.n25 9.0005
R2417 tn.0.n24 tn.0 0.6305
R2418 tn.0.t3 tn.0.n24 0.345342
R2419 tn.0.n24 tn.0.t2 0.345342
R2420 tn.0 tn.0.n23 9.0005
R2421 tn.0.n22 tn.0 0.6305
R2422 tn.0.t8 tn.0.n22 0.345342
R2423 tn.0.n22 tn.0.t34 0.345342
R2424 tn.0 tn.0.n21 9.0005
R2425 tn.0.n20 tn.0 0.6305
R2426 tn.0.t24 tn.0.n20 0.345342
R2427 tn.0.n20 tn.0.t11 0.345342
R2428 tn.0 tn.0.n19 9.0005
R2429 tn.0.n18 tn.0 0.6305
R2430 tn.0.t18 tn.0.n18 0.345342
R2431 tn.0.n18 tn.0.t23 0.345342
R2432 tn.0 tn.0.n17 9.0005
R2433 tn.0.n16 tn.0 0.6305
R2434 tn.0.t30 tn.0.n16 0.345342
R2435 tn.0.n16 tn.0.t17 0.345342
R2436 tn.0 tn.0.n15 9.0005
R2437 tn.0.n14 tn.0 0.6305
R2438 tn.0.t16 tn.0.n14 0.345342
R2439 tn.0.n14 tn.0.t29 0.345342
R2440 tn.0 tn.0.n13 9.0005
R2441 tn.0.n12 tn.0 0.6305
R2442 tn.0.t28 tn.0.n12 0.345342
R2443 tn.0.n12 tn.0.t15 0.345342
R2444 tn.0 tn.0.n11 9.0005
R2445 tn.0.n10 tn.0 0.6305
R2446 tn.0.t19 tn.0.n10 0.345342
R2447 tn.0.n10 tn.0.t27 0.345342
R2448 tn.0.n49 tn.0.n2 0.939071
R2449 tn.0.n2 tn.0.n4 0.939071
R2450 tn.0 tn.0.n4 0.469786
R2451 tn.0.n6 tn.0 0.469786
R2452 tn.0.n8 tn.0.n6 0.939071
R2453 tn.0 tn.0.n8 9.93907
R2454 tn.0 tn.0.n9 1.35246
R2455 tn.0.t35 tn.0.n9 0.6557
R2456 tn.0.n9 tn.0.t37 0.6557
R2457 tn.0 tn.0.n8 9.0005
R2458 tn.0 tn.0.n7 1.35246
R2459 tn.0.t38 tn.0.n7 0.6557
R2460 tn.0.n7 tn.0.t39 0.6557
R2461 tn.0 tn.0.n6 9.0005
R2462 tn.0 tn.0.n5 1.35246
R2463 tn.0.t40 tn.0.n5 0.6557
R2464 tn.0.n5 tn.0.t41 0.6557
R2465 tn.0 tn.0.n4 9.0005
R2466 tn.0 tn.0.n3 1.35246
R2467 tn.0.t42 tn.0.n3 0.6557
R2468 tn.0.n3 tn.0.t43 0.6557
R2469 tn.0 tn.0.n2 9.0005
R2470 tn.0 tn.0.n1 1.35246
R2471 tn.0.t44 tn.0.n1 0.6557
R2472 tn.0.n1 tn.0.t45 0.6557
R2473 ob.0.t22 ob.0 1.19252
R2474 ob.0 ob.0.n28 9.0005
R2475 ob.0.n28 ob.0 0.566214
R2476 ob.0 ob.0.n27 4.98907
R2477 ob.0 ob.0.n27 0.654607
R2478 ob.0.n26 ob.0 5.38121
R2479 ob.0.n26 ob.0 0.431214
R2480 ob.0.n24 ob.0.n25 0.39963
R2481 ob.0.n25 ob.0 0.151152
R2482 ob.0.t29 ob.0.n25 40.4328
R2483 ob.0.t30 ob.0.n24 40.4328
R2484 ob.0.t31 ob.0.n24 40.832
R2485 ob.0 ob.0.n26 3.35621
R2486 ob.0.t5 ob.0 3.57
R2487 ob.0.n27 ob.0 0.0953214
R2488 ob.0 ob.0.n18 1.23157
R2489 ob.0.n18 ob.0.n20 0.617643
R2490 ob.0.n20 ob.0 0.309071
R2491 ob.0 ob.0.n22 0.309071
R2492 ob.0 ob.0.n22 9.61764
R2493 ob.0 ob.0.n23 0.792457
R2494 ob.0.t8 ob.0.n23 0.362889
R2495 ob.0.n23 ob.0.t9 0.362889
R2496 ob.0 ob.0.n22 9.0005
R2497 ob.0 ob.0.n21 0.792457
R2498 ob.0.t12 ob.0.n21 0.362889
R2499 ob.0.n21 ob.0.t7 0.362889
R2500 ob.0 ob.0.n20 9.0005
R2501 ob.0 ob.0.n19 0.792457
R2502 ob.0.t10 ob.0.n19 0.362889
R2503 ob.0.n19 ob.0.t11 0.362889
R2504 ob.0 ob.0.n18 9.0005
R2505 ob.0 ob.0.n17 0.792457
R2506 ob.0.t25 ob.0.n17 0.362889
R2507 ob.0.n17 ob.0.t6 0.362889
R2508 ob.0.n28 ob.0.n1 1.27336
R2509 ob.0.n1 ob.0.n3 1.27336
R2510 ob.0.n3 ob.0.n5 1.27336
R2511 ob.0.n5 ob.0.n7 1.27336
R2512 ob.0 ob.0.n7 1.27336
R2513 ob.0.n10 ob.0 1.27336
R2514 ob.0.n12 ob.0.n10 1.27336
R2515 ob.0.n14 ob.0.n12 1.27336
R2516 ob.0.n16 ob.0.n14 1.27336
R2517 ob.0 ob.0.n16 10.2734
R2518 ob.0 ob.0.t13 1.19252
R2519 ob.0 ob.0.n16 9.0005
R2520 ob.0 ob.0.n15 0.847674
R2521 ob.0.t14 ob.0.n15 0.345342
R2522 ob.0.n15 ob.0.t15 0.345342
R2523 ob.0 ob.0.n14 9.0005
R2524 ob.0 ob.0.n13 0.847674
R2525 ob.0.t16 ob.0.n13 0.345342
R2526 ob.0.n13 ob.0.t17 0.345342
R2527 ob.0 ob.0.n12 9.0005
R2528 ob.0 ob.0.n11 0.847674
R2529 ob.0.t18 ob.0.n11 0.345342
R2530 ob.0.n11 ob.0.t3 0.345342
R2531 ob.0 ob.0.n10 9.0005
R2532 ob.0 ob.0.n9 0.847674
R2533 ob.0.t0 ob.0.n9 0.345342
R2534 ob.0.n9 ob.0.t28 0.345342
R2535 ob.0 ob.0.n8 0.847674
R2536 ob.0.t2 ob.0.n8 0.345342
R2537 ob.0.n8 ob.0.t24 0.345342
R2538 ob.0 ob.0.n7 9.0005
R2539 ob.0 ob.0.n6 0.847674
R2540 ob.0.t23 ob.0.n6 0.345342
R2541 ob.0.n6 ob.0.t1 0.345342
R2542 ob.0 ob.0.n5 9.0005
R2543 ob.0 ob.0.n4 0.847674
R2544 ob.0.t4 ob.0.n4 0.345342
R2545 ob.0.n4 ob.0.t27 0.345342
R2546 ob.0 ob.0.n3 9.0005
R2547 ob.0 ob.0.n2 0.847674
R2548 ob.0.t26 ob.0.n2 0.345342
R2549 ob.0.n2 ob.0.t19 0.345342
R2550 ob.0 ob.0.n1 9.0005
R2551 ob.0 ob.0.n0 0.847674
R2552 ob.0.t20 ob.0.n0 0.345342
R2553 ob.0.n0 ob.0.t21 0.345342
R2554 oa.0.n0 oa.0.t22 0.345342
R2555 oa.0.n0 oa.0.t23 0.345342
R2556 oa.0 oa.0.n0 0.847674
R2557 oa.0 oa.0.n2 10.2734
R2558 oa.0.n2 oa.0.n4 1.27336
R2559 oa.0.n4 oa.0.n6 1.27336
R2560 oa.0.n6 oa.0.n8 1.27336
R2561 oa.0 oa.0.n8 0.636929
R2562 oa.0.n10 oa.0 0.636929
R2563 oa.0.n12 oa.0.n10 1.27336
R2564 oa.0.n14 oa.0.n12 1.27336
R2565 oa.0.n16 oa.0.n14 1.27336
R2566 oa.0.n18 oa.0.n16 1.27336
R2567 oa.0 oa.0.n18 0.894071
R2568 oa.0 oa.0.n19 0.114607
R2569 oa.0.n19 oa.0 2.34371
R2570 oa.0.n24 oa.0 1.3955
R2571 oa.0.n26 oa.0.n24 0.617643
R2572 oa.0 oa.0.n26 0.309071
R2573 oa.0.n28 oa.0 0.309071
R2574 oa.0 oa.0.n28 9.61764
R2575 oa.0 oa.0.n29 0.792457
R2576 oa.0.t26 oa.0.n29 0.362889
R2577 oa.0.n29 oa.0.t11 0.362889
R2578 oa.0 oa.0.n28 9.0005
R2579 oa.0 oa.0.n27 0.792457
R2580 oa.0.t12 oa.0.n27 0.362889
R2581 oa.0.n27 oa.0.t13 0.362889
R2582 oa.0 oa.0.n26 9.0005
R2583 oa.0 oa.0.n25 0.792457
R2584 oa.0.t8 oa.0.n25 0.362889
R2585 oa.0.n25 oa.0.t9 0.362889
R2586 oa.0 oa.0.n24 9.0005
R2587 oa.0 oa.0.n23 0.792457
R2588 oa.0.t10 oa.0.n23 0.362889
R2589 oa.0.n23 oa.0.t7 0.362889
R2590 oa.0.n19 oa.0 4.59371
R2591 oa.0.n22 oa.0 5.60621
R2592 oa.0.n22 oa.0 2.79371
R2593 oa.0.t2 oa.0 3.57
R2594 oa.0 oa.0.n22 0.543714
R2595 oa.0 oa.0.n20 0.151152
R2596 oa.0.n20 oa.0.n21 0.39963
R2597 oa.0.t29 oa.0.n21 40.832
R2598 oa.0.t30 oa.0.n21 40.4328
R2599 oa.0.t31 oa.0.n20 40.4328
R2600 oa.0 oa.0.n18 9.0005
R2601 oa.0.n17 oa.0 0.847674
R2602 oa.0.t14 oa.0.n17 0.345342
R2603 oa.0.n17 oa.0.t15 0.345342
R2604 oa.0 oa.0.n16 9.0005
R2605 oa.0.n15 oa.0 0.847674
R2606 oa.0.t16 oa.0.n15 0.345342
R2607 oa.0.n15 oa.0.t17 0.345342
R2608 oa.0 oa.0.n14 9.0005
R2609 oa.0.n13 oa.0 0.847674
R2610 oa.0.t18 oa.0.n13 0.345342
R2611 oa.0.n13 oa.0.t19 0.345342
R2612 oa.0 oa.0.n12 9.0005
R2613 oa.0.n11 oa.0 0.847674
R2614 oa.0.t25 oa.0.n11 0.345342
R2615 oa.0.n11 oa.0.t3 0.345342
R2616 oa.0 oa.0.n10 9.0005
R2617 oa.0.n9 oa.0 0.847674
R2618 oa.0.t28 oa.0.n9 0.345342
R2619 oa.0.n9 oa.0.t27 0.345342
R2620 oa.0 oa.0.n8 9.0005
R2621 oa.0.n7 oa.0 0.847674
R2622 oa.0.t5 oa.0.n7 0.345342
R2623 oa.0.n7 oa.0.t24 0.345342
R2624 oa.0 oa.0.n6 9.0005
R2625 oa.0.n5 oa.0 0.847674
R2626 oa.0.t6 oa.0.n5 0.345342
R2627 oa.0.n5 oa.0.t0 0.345342
R2628 oa.0 oa.0.n4 9.0005
R2629 oa.0.n3 oa.0 0.847674
R2630 oa.0.t1 oa.0.n3 0.345342
R2631 oa.0.n3 oa.0.t4 0.345342
R2632 oa.0 oa.0.n2 9.0005
R2633 oa.0.n1 oa.0 0.847674
R2634 oa.0.t20 oa.0.n1 0.345342
R2635 oa.0.n1 oa.0.t21 0.345342
R2636 fa.0.t59 fa.0.n0 0.6557
R2637 fa.0.n0 fa.0.t47 0.6557
R2638 fa.0 fa.0.n0 1.47767
R2639 fa.0 fa.0.n2 10.9162
R2640 fa.0.n2 fa.0.n4 1.91621
R2641 fa.0 fa.0.n4 1.91621
R2642 fa.0.n7 fa.0 1.91621
R2643 fa.0.n9 fa.0.n7 1.91621
R2644 fa.0.n11 fa.0.n9 1.91621
R2645 fa.0 fa.0.n11 1.25086
R2646 fa.0.n62 fa.0 7.63121
R2647 fa.0 fa.0.n62 1.30871
R2648 fa.0 fa.0.n56 1.31193
R2649 fa.0.n56 fa.0.n58 0.617643
R2650 fa.0.n58 fa.0 0.309071
R2651 fa.0 fa.0.n60 0.309071
R2652 fa.0 fa.0.n60 9.61764
R2653 fa.0.n61 fa.0 0.792457
R2654 fa.0.t15 fa.0.n61 0.362889
R2655 fa.0.n61 fa.0.t45 0.362889
R2656 fa.0 fa.0.n60 9.0005
R2657 fa.0.n59 fa.0 0.792457
R2658 fa.0.t13 fa.0.n59 0.362889
R2659 fa.0.n59 fa.0.t14 0.362889
R2660 fa.0 fa.0.n58 9.0005
R2661 fa.0.n57 fa.0 0.792457
R2662 fa.0.t11 fa.0.n57 0.362889
R2663 fa.0.n57 fa.0.t12 0.362889
R2664 fa.0 fa.0.n56 9.0005
R2665 fa.0.n55 fa.0 0.792457
R2666 fa.0.t9 fa.0.n55 0.362889
R2667 fa.0.n55 fa.0.t10 0.362889
R2668 fa.0.n62 fa.0 0.768714
R2669 fa.0 fa.0.n13 1.12229
R2670 fa.0.n13 fa.0.n15 1.14479
R2671 fa.0.n15 fa.0.n17 1.14479
R2672 fa.0.n17 fa.0.n19 1.14479
R2673 fa.0.n19 fa.0.n21 1.14479
R2674 fa.0.n21 fa.0.n23 1.14479
R2675 fa.0.n23 fa.0.n25 1.14479
R2676 fa.0.n25 fa.0.n27 1.14479
R2677 fa.0.n27 fa.0.n29 1.14479
R2678 fa.0.n29 fa.0.n31 1.14479
R2679 fa.0.n31 fa.0.n33 1.14479
R2680 fa.0.n33 fa.0 0.572643
R2681 fa.0 fa.0.n35 0.572643
R2682 fa.0.n35 fa.0.n37 1.14479
R2683 fa.0.n37 fa.0.n39 1.14479
R2684 fa.0.n39 fa.0.n41 1.14479
R2685 fa.0.n41 fa.0.n43 1.14479
R2686 fa.0.n43 fa.0.n45 1.14479
R2687 fa.0.n45 fa.0.n47 1.14479
R2688 fa.0.n47 fa.0.n49 1.14479
R2689 fa.0.n49 fa.0.n51 1.14479
R2690 fa.0.n51 fa.0.n53 1.14479
R2691 fa.0 fa.0.n53 10.1448
R2692 fa.0.n54 fa.0 0.737674
R2693 fa.0.t36 fa.0.n54 0.379667
R2694 fa.0.n54 fa.0.t37 0.379667
R2695 fa.0 fa.0.n53 9.0005
R2696 fa.0.n52 fa.0 0.737674
R2697 fa.0.t34 fa.0.n52 0.379667
R2698 fa.0.n52 fa.0.t35 0.379667
R2699 fa.0 fa.0.n51 9.0005
R2700 fa.0.n50 fa.0 0.737674
R2701 fa.0.t32 fa.0.n50 0.379667
R2702 fa.0.n50 fa.0.t33 0.379667
R2703 fa.0 fa.0.n49 9.0005
R2704 fa.0.n48 fa.0 0.737674
R2705 fa.0.t30 fa.0.n48 0.379667
R2706 fa.0.n48 fa.0.t31 0.379667
R2707 fa.0 fa.0.n47 9.0005
R2708 fa.0.n46 fa.0 0.737674
R2709 fa.0.t28 fa.0.n46 0.379667
R2710 fa.0.n46 fa.0.t29 0.379667
R2711 fa.0 fa.0.n45 9.0005
R2712 fa.0.n44 fa.0 0.737674
R2713 fa.0.t26 fa.0.n44 0.379667
R2714 fa.0.n44 fa.0.t27 0.379667
R2715 fa.0 fa.0.n43 9.0005
R2716 fa.0.n42 fa.0 0.737674
R2717 fa.0.t60 fa.0.n42 0.379667
R2718 fa.0.n42 fa.0.t8 0.379667
R2719 fa.0 fa.0.n41 9.0005
R2720 fa.0.n40 fa.0 0.737674
R2721 fa.0.t38 fa.0.n40 0.379667
R2722 fa.0.n40 fa.0.t43 0.379667
R2723 fa.0 fa.0.n39 9.0005
R2724 fa.0.n38 fa.0 0.737674
R2725 fa.0.t65 fa.0.n38 0.379667
R2726 fa.0.n38 fa.0.t2 0.379667
R2727 fa.0 fa.0.n37 9.0005
R2728 fa.0.n36 fa.0 0.737674
R2729 fa.0.t64 fa.0.n36 0.379667
R2730 fa.0.n36 fa.0.t7 0.379667
R2731 fa.0 fa.0.n35 9.0005
R2732 fa.0.n34 fa.0 0.737674
R2733 fa.0.t4 fa.0.n34 0.379667
R2734 fa.0.n34 fa.0.t40 0.379667
R2735 fa.0 fa.0.n33 9.0005
R2736 fa.0.n32 fa.0 0.737674
R2737 fa.0.t63 fa.0.n32 0.379667
R2738 fa.0.n32 fa.0.t44 0.379667
R2739 fa.0 fa.0.n31 9.0005
R2740 fa.0.n30 fa.0 0.737674
R2741 fa.0.t0 fa.0.n30 0.379667
R2742 fa.0.n30 fa.0.t39 0.379667
R2743 fa.0 fa.0.n29 9.0005
R2744 fa.0.n28 fa.0 0.737674
R2745 fa.0.t42 fa.0.n28 0.379667
R2746 fa.0.n28 fa.0.t5 0.379667
R2747 fa.0 fa.0.n27 9.0005
R2748 fa.0.n26 fa.0 0.737674
R2749 fa.0.t41 fa.0.n26 0.379667
R2750 fa.0.n26 fa.0.t62 0.379667
R2751 fa.0 fa.0.n25 9.0005
R2752 fa.0.n24 fa.0 0.737674
R2753 fa.0.t1 fa.0.n24 0.379667
R2754 fa.0.n24 fa.0.t6 0.379667
R2755 fa.0 fa.0.n23 9.0005
R2756 fa.0.n22 fa.0 0.737674
R2757 fa.0.t3 fa.0.n22 0.379667
R2758 fa.0.n22 fa.0.t61 0.379667
R2759 fa.0 fa.0.n21 9.0005
R2760 fa.0.n20 fa.0 0.737674
R2761 fa.0.t24 fa.0.n20 0.379667
R2762 fa.0.n20 fa.0.t25 0.379667
R2763 fa.0 fa.0.n19 9.0005
R2764 fa.0.n18 fa.0 0.737674
R2765 fa.0.t22 fa.0.n18 0.379667
R2766 fa.0.n18 fa.0.t23 0.379667
R2767 fa.0 fa.0.n17 9.0005
R2768 fa.0.n16 fa.0 0.737674
R2769 fa.0.t20 fa.0.n16 0.379667
R2770 fa.0.n16 fa.0.t21 0.379667
R2771 fa.0 fa.0.n15 9.0005
R2772 fa.0.n14 fa.0 0.737674
R2773 fa.0.t18 fa.0.n14 0.379667
R2774 fa.0.n14 fa.0.t19 0.379667
R2775 fa.0 fa.0.n13 9.0005
R2776 fa.0.n12 fa.0 0.737674
R2777 fa.0.t16 fa.0.n12 0.379667
R2778 fa.0.n12 fa.0.t17 0.379667
R2779 fa.0 fa.0.n11 9.0005
R2780 fa.0 fa.0.n10 1.47767
R2781 fa.0.t46 fa.0.n10 0.6557
R2782 fa.0.n10 fa.0.t48 0.6557
R2783 fa.0 fa.0.n9 9.0005
R2784 fa.0 fa.0.n8 1.47767
R2785 fa.0.t49 fa.0.n8 0.6557
R2786 fa.0.n8 fa.0.t50 0.6557
R2787 fa.0 fa.0.n7 9.0005
R2788 fa.0 fa.0.n6 1.47767
R2789 fa.0.t51 fa.0.n6 0.6557
R2790 fa.0.n6 fa.0.t52 0.6557
R2791 fa.0 fa.0.n5 1.47767
R2792 fa.0.t53 fa.0.n5 0.6557
R2793 fa.0.n5 fa.0.t54 0.6557
R2794 fa.0 fa.0.n4 9.0005
R2795 fa.0 fa.0.n3 1.47767
R2796 fa.0.t55 fa.0.n3 0.6557
R2797 fa.0.n3 fa.0.t56 0.6557
R2798 fa.0 fa.0.n2 9.0005
R2799 fa.0 fa.0.n1 1.47767
R2800 fa.0.t57 fa.0.n1 0.6557
R2801 fa.0.n1 fa.0.t58 0.6557
R2802 fb.0.n0 fb.0.t50 0.6557
R2803 fb.0.n0 fb.0.t51 0.6557
R2804 fb.0 fb.0.n0 1.47767
R2805 fb.0 fb.0.n60 9.0005
R2806 fb.0.n60 fb.0 1.73943
R2807 fb.0 fb.0.n59 7.63121
R2808 fb.0 fb.0.n59 1.30871
R2809 fb.0.n53 fb.0 1.148
R2810 fb.0.n55 fb.0.n53 0.617643
R2811 fb.0 fb.0.n55 0.309071
R2812 fb.0.n57 fb.0 0.309071
R2813 fb.0 fb.0.n57 9.61764
R2814 fb.0.n58 fb.0 0.792457
R2815 fb.0.t5 fb.0.n58 0.362889
R2816 fb.0.n58 fb.0.t6 0.362889
R2817 fb.0 fb.0.n57 9.0005
R2818 fb.0.n56 fb.0 0.792457
R2819 fb.0.t7 fb.0.n56 0.362889
R2820 fb.0.n56 fb.0.t8 0.362889
R2821 fb.0 fb.0.n55 9.0005
R2822 fb.0.n54 fb.0 0.792457
R2823 fb.0.t9 fb.0.n54 0.362889
R2824 fb.0.n54 fb.0.t10 0.362889
R2825 fb.0 fb.0.n53 9.0005
R2826 fb.0.n52 fb.0 0.792457
R2827 fb.0.t11 fb.0.n52 0.362889
R2828 fb.0.n52 fb.0.t38 0.362889
R2829 fb.0.n59 fb.0 0.656214
R2830 fb.0.n10 fb.0 0.826571
R2831 fb.0.n12 fb.0.n10 1.14479
R2832 fb.0.n14 fb.0.n12 1.14479
R2833 fb.0.n16 fb.0.n14 1.14479
R2834 fb.0.n18 fb.0.n16 1.14479
R2835 fb.0.n20 fb.0.n18 1.14479
R2836 fb.0.n22 fb.0.n20 1.14479
R2837 fb.0.n24 fb.0.n22 1.14479
R2838 fb.0.n26 fb.0.n24 1.14479
R2839 fb.0.n28 fb.0.n26 1.14479
R2840 fb.0.n30 fb.0.n28 1.14479
R2841 fb.0 fb.0.n30 1.14479
R2842 fb.0.n33 fb.0 1.14479
R2843 fb.0.n35 fb.0.n33 1.14479
R2844 fb.0.n37 fb.0.n35 1.14479
R2845 fb.0.n39 fb.0.n37 1.14479
R2846 fb.0.n41 fb.0.n39 1.14479
R2847 fb.0.n43 fb.0.n41 1.14479
R2848 fb.0.n45 fb.0.n43 1.14479
R2849 fb.0.n47 fb.0.n45 1.14479
R2850 fb.0.n49 fb.0.n47 1.14479
R2851 fb.0.n51 fb.0.n49 1.14479
R2852 fb.0 fb.0.n51 10.1448
R2853 fb.0 fb.0.t12 1.11684
R2854 fb.0 fb.0.n51 9.0005
R2855 fb.0 fb.0.n50 0.737674
R2856 fb.0.t13 fb.0.n50 0.379667
R2857 fb.0.n50 fb.0.t14 0.379667
R2858 fb.0 fb.0.n49 9.0005
R2859 fb.0 fb.0.n48 0.737674
R2860 fb.0.t15 fb.0.n48 0.379667
R2861 fb.0.n48 fb.0.t16 0.379667
R2862 fb.0 fb.0.n47 9.0005
R2863 fb.0 fb.0.n46 0.737674
R2864 fb.0.t17 fb.0.n46 0.379667
R2865 fb.0.n46 fb.0.t18 0.379667
R2866 fb.0 fb.0.n45 9.0005
R2867 fb.0 fb.0.n44 0.737674
R2868 fb.0.t19 fb.0.n44 0.379667
R2869 fb.0.n44 fb.0.t20 0.379667
R2870 fb.0 fb.0.n43 9.0005
R2871 fb.0 fb.0.n42 0.737674
R2872 fb.0.t21 fb.0.n42 0.379667
R2873 fb.0.n42 fb.0.t55 0.379667
R2874 fb.0 fb.0.n41 9.0005
R2875 fb.0 fb.0.n40 0.737674
R2876 fb.0.t54 fb.0.n40 0.379667
R2877 fb.0.n40 fb.0.t53 0.379667
R2878 fb.0 fb.0.n39 9.0005
R2879 fb.0 fb.0.n38 0.737674
R2880 fb.0.t52 fb.0.n38 0.379667
R2881 fb.0.n38 fb.0.t62 0.379667
R2882 fb.0 fb.0.n37 9.0005
R2883 fb.0 fb.0.n36 0.737674
R2884 fb.0.t61 fb.0.n36 0.379667
R2885 fb.0.n36 fb.0.t60 0.379667
R2886 fb.0 fb.0.n35 9.0005
R2887 fb.0 fb.0.n34 0.737674
R2888 fb.0.t36 fb.0.n34 0.379667
R2889 fb.0.n34 fb.0.t35 0.379667
R2890 fb.0 fb.0.n33 9.0005
R2891 fb.0 fb.0.n32 0.737674
R2892 fb.0.t34 fb.0.n32 0.379667
R2893 fb.0.n32 fb.0.t58 0.379667
R2894 fb.0 fb.0.n31 0.737674
R2895 fb.0.t57 fb.0.n31 0.379667
R2896 fb.0.n31 fb.0.t56 0.379667
R2897 fb.0 fb.0.n30 9.0005
R2898 fb.0 fb.0.n29 0.737674
R2899 fb.0.t3 fb.0.n29 0.379667
R2900 fb.0.n29 fb.0.t63 0.379667
R2901 fb.0 fb.0.n28 9.0005
R2902 fb.0 fb.0.n27 0.737674
R2903 fb.0.t2 fb.0.n27 0.379667
R2904 fb.0.n27 fb.0.t1 0.379667
R2905 fb.0 fb.0.n26 9.0005
R2906 fb.0 fb.0.n25 0.737674
R2907 fb.0.t0 fb.0.n25 0.379667
R2908 fb.0.n25 fb.0.t37 0.379667
R2909 fb.0 fb.0.n24 9.0005
R2910 fb.0 fb.0.n23 0.737674
R2911 fb.0.t39 fb.0.n23 0.379667
R2912 fb.0.n23 fb.0.t4 0.379667
R2913 fb.0 fb.0.n22 9.0005
R2914 fb.0 fb.0.n21 0.737674
R2915 fb.0.t59 fb.0.n21 0.379667
R2916 fb.0.n21 fb.0.t22 0.379667
R2917 fb.0 fb.0.n20 9.0005
R2918 fb.0 fb.0.n19 0.737674
R2919 fb.0.t23 fb.0.n19 0.379667
R2920 fb.0.n19 fb.0.t24 0.379667
R2921 fb.0 fb.0.n18 9.0005
R2922 fb.0 fb.0.n17 0.737674
R2923 fb.0.t25 fb.0.n17 0.379667
R2924 fb.0.n17 fb.0.t26 0.379667
R2925 fb.0 fb.0.n16 9.0005
R2926 fb.0 fb.0.n15 0.737674
R2927 fb.0.t27 fb.0.n15 0.379667
R2928 fb.0.n15 fb.0.t28 0.379667
R2929 fb.0 fb.0.n14 9.0005
R2930 fb.0 fb.0.n13 0.737674
R2931 fb.0.t29 fb.0.n13 0.379667
R2932 fb.0.n13 fb.0.t30 0.379667
R2933 fb.0 fb.0.n12 9.0005
R2934 fb.0 fb.0.n11 0.737674
R2935 fb.0.t31 fb.0.n11 0.379667
R2936 fb.0.n11 fb.0.t32 0.379667
R2937 fb.0 fb.0.n10 9.0005
R2938 fb.0.t33 fb.0 1.11684
R2939 fb.0.n60 fb.0.n2 1.91621
R2940 fb.0.n2 fb.0.n4 1.91621
R2941 fb.0 fb.0.n4 0.958357
R2942 fb.0.n6 fb.0 0.958357
R2943 fb.0.n8 fb.0.n6 1.91621
R2944 fb.0 fb.0.n8 10.9162
R2945 fb.0.n9 fb.0 1.47767
R2946 fb.0.t40 fb.0.n9 0.6557
R2947 fb.0.n9 fb.0.t41 0.6557
R2948 fb.0 fb.0.n8 9.0005
R2949 fb.0.n7 fb.0 1.47767
R2950 fb.0.t42 fb.0.n7 0.6557
R2951 fb.0.n7 fb.0.t43 0.6557
R2952 fb.0 fb.0.n6 9.0005
R2953 fb.0.n5 fb.0 1.47767
R2954 fb.0.t44 fb.0.n5 0.6557
R2955 fb.0.n5 fb.0.t45 0.6557
R2956 fb.0 fb.0.n4 9.0005
R2957 fb.0.n3 fb.0 1.47767
R2958 fb.0.t46 fb.0.n3 0.6557
R2959 fb.0.n3 fb.0.t47 0.6557
R2960 fb.0 fb.0.n2 9.0005
R2961 fb.0.n1 fb.0 1.47767
R2962 fb.0.t48 fb.0.n1 0.6557
R2963 fb.0.n1 fb.0.t49 0.6557
R2964 gn.0.t0 gn.0 1.2823
R2965 gn.0.n5 gn.0.n2 9.0005
R2966 gn.0 gn.0.n0 0.985824
R2967 gn.0.n1 gn.0.n0 1.21457
R2968 gn.0.n1 gn.0 0.08675
R2969 gn.0 gn.0.n2 0.21275
R2970 gn.0.n3 gn.0.n2 0.447521
R2971 gn.0 gn.0.n3 10.4681
R2972 gn.0.n36 gn.0 4.58118
R2973 gn.0.n36 gn.0 0.075987
R2974 gn.0.n27 gn.0.n28 0.39963
R2975 gn.0.n28 gn.0.n29 1.19789
R2976 gn.0.n29 gn.0.n30 0.39963
R2977 gn.0.n30 gn.0.n31 1.19789
R2978 gn.0.n31 gn.0.n32 0.39963
R2979 gn.0.n32 gn.0 0.95137
R2980 gn.0 gn.0.n33 0.247022
R2981 gn.0.n33 gn.0.n34 0.39963
R2982 gn.0.n34 gn.0.n35 1.19789
R2983 gn.0.n35 gn.0 12.8294
R2984 gn.0.t1 gn.0.n35 46.9298
R2985 gn.0.t2 gn.0.n34 46.9298
R2986 gn.0.t3 gn.0.n33 46.9298
R2987 gn.0.t4 gn.0.n32 46.9298
R2988 gn.0.t5 gn.0.n31 46.9298
R2989 gn.0.t6 gn.0.n30 46.9298
R2990 gn.0.t7 gn.0.n29 46.9298
R2991 gn.0.t8 gn.0.n28 46.9298
R2992 gn.0.t9 gn.0.n27 46.9298
R2993 gn.0.t10 gn.0.n27 48.1272
R2994 gn.0 gn.0.n36 0.264023
R2995 gn.0.n6 gn.0.n7 0.3605
R2996 gn.0.n7 gn.0.n8 1.0805
R2997 gn.0.n8 gn.0.n9 0.3605
R2998 gn.0.n9 gn.0.n10 1.0805
R2999 gn.0.n10 gn.0.n11 0.3605
R3000 gn.0.n11 gn.0.n12 1.0805
R3001 gn.0.n12 gn.0.n13 0.3605
R3002 gn.0.n13 gn.0.n14 1.0805
R3003 gn.0.n14 gn.0.n15 0.3605
R3004 gn.0.n15 gn.0.n16 1.0805
R3005 gn.0.n16 gn.0.n17 0.3605
R3006 gn.0.n17 gn.0.n18 1.0805
R3007 gn.0.n18 gn.0.n19 0.3605
R3008 gn.0.n19 gn.0.n20 1.0805
R3009 gn.0.n20 gn.0.n21 0.3605
R3010 gn.0.n21 gn.0 0.941587
R3011 gn.0 gn.0.n22 0.139413
R3012 gn.0.n22 gn.0.n23 0.3605
R3013 gn.0.n23 gn.0.n24 1.0805
R3014 gn.0.n24 gn.0.n25 0.3605
R3015 gn.0.n25 gn.0.n26 1.0805
R3016 gn.0.n26 gn.0 18.3781
R3017 gn.0.t11 gn.0.n26 57.0825
R3018 gn.0.t12 gn.0.n25 57.0825
R3019 gn.0.t13 gn.0.n24 57.0825
R3020 gn.0.t14 gn.0.n23 57.0825
R3021 gn.0.t15 gn.0.n22 57.0825
R3022 gn.0.t16 gn.0.n21 57.0825
R3023 gn.0.t17 gn.0.n20 57.0825
R3024 gn.0.t18 gn.0.n19 57.0825
R3025 gn.0.t19 gn.0.n18 57.0825
R3026 gn.0.t20 gn.0.n17 57.0825
R3027 gn.0.t21 gn.0.n16 57.0825
R3028 gn.0.t22 gn.0.n15 57.0825
R3029 gn.0.t23 gn.0.n14 57.0825
R3030 gn.0.t24 gn.0.n13 57.0825
R3031 gn.0.t25 gn.0.n12 57.0825
R3032 gn.0.t26 gn.0.n11 57.0825
R3033 gn.0.t27 gn.0.n10 57.0825
R3034 gn.0.t28 gn.0.n9 57.0825
R3035 gn.0.t29 gn.0.n8 57.0825
R3036 gn.0.t30 gn.0.n7 57.0825
R3037 gn.0.t31 gn.0.n6 57.0825
R3038 gn.0.t32 gn.0.n6 58.1625
R3039 gn.0.n4 gn.0.t33 0.033
R3040 gn.0.n5 gn.0.n1 9.03728
R3041 gn.0.n4 gn.0.n5 0.0189805
R3042 gn.0.n3 gn.0.n4 4.45525
R3043 gn.0.n0 gn.0.t34 2.12852
R3044 gp.0.t0 gp.0 1.2823
R3045 gp.0.n3 gp.0.n0 9.0005
R3046 gp.0 gp.0.n2 10.4681
R3047 gp.0.n2 gp.0.n0 0.447521
R3048 gp.0.n0 gp.0 0.21275
R3049 gp.0 gp.0.n4 0.08675
R3050 gp.0.n4 gp.0.n5 1.21457
R3051 gp.0.n5 gp.0 0.985824
R3052 gp.0.n6 gp.0 1.33121
R3053 gp.0 gp.0.n6 0.177286
R3054 gp.0 gp.0.n36 17.2981
R3055 gp.0.n36 gp.0.n35 0.3605
R3056 gp.0.n35 gp.0.n34 1.0805
R3057 gp.0.n34 gp.0.n33 0.3605
R3058 gp.0.n33 gp.0.n32 1.0805
R3059 gp.0.n32 gp.0 0.319413
R3060 gp.0 gp.0.n31 0.041587
R3061 gp.0.n31 gp.0.n30 1.0805
R3062 gp.0.n30 gp.0.n29 0.3605
R3063 gp.0.n29 gp.0.n28 1.0805
R3064 gp.0.n28 gp.0.n27 0.3605
R3065 gp.0.n27 gp.0.n26 1.0805
R3066 gp.0.n26 gp.0.n25 0.3605
R3067 gp.0.n25 gp.0.n24 1.0805
R3068 gp.0.n24 gp.0.n23 0.3605
R3069 gp.0.n23 gp.0.n22 1.0805
R3070 gp.0.n22 gp.0.n21 0.3605
R3071 gp.0.n21 gp.0.n20 1.0805
R3072 gp.0.n20 gp.0.n19 0.3605
R3073 gp.0.n19 gp.0.n18 1.0805
R3074 gp.0.n18 gp.0.n17 0.3605
R3075 gp.0.n17 gp.0.n16 1.0805
R3076 gp.0.n36 gp.0.t32 57.0825
R3077 gp.0.n35 gp.0.t31 57.0825
R3078 gp.0.n34 gp.0.t30 57.0825
R3079 gp.0.n33 gp.0.t29 57.0825
R3080 gp.0.n32 gp.0.t28 57.0825
R3081 gp.0.n31 gp.0.t27 57.0825
R3082 gp.0.n30 gp.0.t26 57.0825
R3083 gp.0.n29 gp.0.t25 57.0825
R3084 gp.0.n28 gp.0.t24 57.0825
R3085 gp.0.n27 gp.0.t23 57.0825
R3086 gp.0.n26 gp.0.t22 57.0825
R3087 gp.0.n25 gp.0.t21 57.0825
R3088 gp.0.n24 gp.0.t20 57.0825
R3089 gp.0.n23 gp.0.t19 57.0825
R3090 gp.0.n22 gp.0.t18 57.0825
R3091 gp.0.n21 gp.0.t17 57.0825
R3092 gp.0.n20 gp.0.t16 57.0825
R3093 gp.0.n19 gp.0.t15 57.0825
R3094 gp.0.n18 gp.0.t14 57.0825
R3095 gp.0.n17 gp.0.t13 57.0825
R3096 gp.0.n16 gp.0.t12 57.0825
R3097 gp.0.n16 gp.0.t11 57.4425
R3098 gp.0 gp.0.n6 4.59371
R3099 gp.0 gp.0.n15 14.8251
R3100 gp.0.n15 gp.0.n14 0.39963
R3101 gp.0.n14 gp.0 0.0474565
R3102 gp.0 gp.0.n13 1.15093
R3103 gp.0.n13 gp.0.n12 0.39963
R3104 gp.0.n12 gp.0.n11 1.19789
R3105 gp.0.n11 gp.0.n10 0.39963
R3106 gp.0.n10 gp.0.n9 1.19789
R3107 gp.0.n9 gp.0.n8 0.39963
R3108 gp.0.n8 gp.0.n7 1.19789
R3109 gp.0.n15 gp.0.t10 46.9298
R3110 gp.0.n14 gp.0.t9 46.9298
R3111 gp.0.n13 gp.0.t8 46.9298
R3112 gp.0.n12 gp.0.t7 46.9298
R3113 gp.0.n11 gp.0.t6 46.9298
R3114 gp.0.n10 gp.0.t5 46.9298
R3115 gp.0.n9 gp.0.t4 46.9298
R3116 gp.0.n8 gp.0.t3 46.9298
R3117 gp.0.n7 gp.0.t2 46.9298
R3118 gp.0.n7 gp.0.t1 47.329
R3119 gp.0.n5 gp.0.t33 2.12852
R3120 gp.0.n1 gp.0.t34 0.033
R3121 gp.0.n2 gp.0.n1 4.45525
R3122 gp.0.n1 gp.0.n3 0.0189805
R3123 gp.0.n3 gp.0.n4 9.03728
R3124 tp.0.n0 tp.0.t0 83.3193
C0 nd.0 d3.0 0.22426f
C1 rla_m1.0 d2a.0 0.00155f
C2 INN VDD 2.56298f
C3 EN i2.0 0.31483f
C4 VREF gn.0 2.33633f
C5 VDD nd.0 2.72518f
C6 ob.0 gn.0 1.03804f
C7 d2a.0 oa.0 0.23141f
C8 INP VDD 2.26778f
C9 VBN VB2 0.12676f
C10 VB2 fb.0 2.14447f
C11 VDD ts.0 0.55022f
C12 gp.0 VB2 0.05601f
C13 VDD oa.0 1.59618f
C14 OUT i2.0 0.50501f
C15 VBP INN 0.03712f
C16 sa.0 ob.0 0.01084f
C17 VREF ob.0 2.70252f
C18 rla_m1.0 rlb_m1.0 0.39394f
C19 tn.0 oa.0 9.87797f
C20 oa.0 fa.0 2.90441f
C21 VBP INP 0.03875f
C22 d2b.0 d2a.0 2.80463f
C23 EN d2a.0 0.18482f
C24 EN i1.0 0.26447f
C25 VB2 gn.0 0.05558f
C26 d3.0 d2b.0 0.35626f
C27 VBN VDD 0.13732f
C28 EN d3.0 0.54374f
C29 VDD d2b.0 12.259f
C30 gp.0 VDD 4.53691f
C31 VBN tn.0 0.82513f
C32 EN VDD 17.3635f
C33 VBN fa.0 2.39287f
C34 fa.0 fb.0 0.80129f
C35 gp.0 tn.0 1.20627f
C36 n3a.0 d2a.0 0.37969f
C37 OUT i1.0 0
C38 VB2 VREF 6.32706f
C39 gp.0 fa.0 2.44274f
C40 VB2 ob.0 0.57476f
C41 d3.0 n3a.0 0.59994f
C42 nm.0 d3.0 0.01765f
C43 VDD gn.0 4.52025f
C44 VDD n3a.0 5.30403f
C45 gp.0 VBP 0.26446f
C46 OUT VDD 3.99882f
C47 sa.0 d2a.0 1.70252f
C48 tn.0 gn.0 0.99696f
C49 fa.0 gn.0 0.67123f
C50 VDD sa.0 0.00564f
C51 VREF VDD 0.13393f
C52 VDD ob.0 1.9912f
C53 VBP gn.0 0.26446f
C54 i1.0 i2.0 0.28557f
C55 VREF tn.0 1.62411f
C56 tn.0 ob.0 9.55392f
C57 VREF fa.0 2.64932f
C58 rlb_m1.0 sa.0 0
C59 ob.0 fa.0 0
C60 VDD i2.0 4.2835f
C61 EN nd.0 0.90578f
C62 sb.0 d2b.0 0.85915f
C63 gp.0 INP 0.14621f
C64 VBN ts.0 0.52623f
C65 d2b.0 rla_m1.0 0.00475f
C66 VBN oa.0 0.33374f
C67 VB2 VDD 0.12285f
C68 INN gn.0 0.14621f
C69 gp.0 oa.0 1.25114f
C70 d3.0 d2a.0 2.65586f
C71 VB2 fa.0 1.75715f
C72 nm.0 nd.0 0.2193f
C73 VDD d2a.0 13.0234f
C74 VDD i1.0 2.62227f
C75 VBN fb.0 1.48704f
C76 VDD d3.0 4.25479f
C77 oa.0 gn.0 0.30476f
C78 gp.0 VBN 0.14191f
C79 gp.0 fb.0 0.86843f
C80 sb.0 sa.0 0.77697f
C81 EN d2b.0 0.43087f
C82 rla_m1.0 sa.0 0.30587f
C83 sb.0 ob.0 0.28465f
C84 VDD tn.0 0.19528f
C85 VREF ts.0 0.00271f
C86 sa.0 oa.0 0.20057f
C87 VREF oa.0 2.14744f
C88 VBN gn.0 0.11482f
C89 ob.0 oa.0 0.59251f
C90 fb.0 gn.0 2.59553f
C91 gp.0 gn.0 2.07546f
C92 n3a.0 d2b.0 0.50895f
C93 VBP VDD 28.4203f
C94 EN n3a.0 0.07539f
C95 EN OUT 0.00492f
C96 EN nm.0 0.02238f
C97 VBN VREF 0.90664f
C98 VREF fb.0 2.88984f
C99 VBN ob.0 0.19136f
C100 ob.0 fb.0 2.81909f
C101 d2b.0 sa.0 0.20733f
C102 gp.0 VREF 1.91483f
C103 d2b.0 ob.0 0.20289f
C104 gp.0 ob.0 0.3633f
C105 i1.0 nd.0 0.21598f
C106 VB2 oa.0 0.57905f
C107 OUT VSS 4.00479f
C108 EN VSS 4.30531f
C109 VBN VSS 40.2752f
C110 VB2 VSS 5.49286f
C111 VREF VSS 4.31402f
C112 INN VSS 1.5011f
C113 VBP VSS 0.726562f
C114 INP VSS 1.78005f
C115 VDD VSS 147.61f
C116 i2.0 VSS 3.15224f
C117 i1.0 VSS 3.20909f
C118 nm.0 VSS 0.189663f
C119 nd.0 VSS 2.84228f
C120 d3.0 VSS 4.59334f
C121 n3a.0 VSS 2.29019f
C122 sb.0 VSS 2.3039f
C123 d2b.0 VSS 2.43692f
C124 rlb_m1.0 VSS 0.983954f
C125 rla_m1.0 VSS 1.34562f
C126 sa.0 VSS 4.34081f
C127 d2a.0 VSS 1.45512f
C128 ts.0 VSS 5.11024f
C129 tn.0 VSS 0.18354f
C130 ob.0 VSS 3.72939f
C131 oa.0 VSS 3.82747f
C132 fa.0 VSS 3.252f
C133 fb.0 VSS 2.73074f
C134 gn.0 VSS 5.51271f
C135 gp.0 VSS 5.71127f
C136 tp.0.t0 VSS 47.5309f
C137 tp.0.n0 VSS 55.3691f
C138 gp.0.t0 VSS 0.0597418f
C139 gp.0.n0 VSS 0.0479263f
C140 gp.0.t34 VSS 1.25664f
C141 gp.0.n1 VSS 0.688495f
C142 gp.0.n2 VSS 0.209839f
C143 gp.0.n3 VSS 0.537763f
C144 gp.0.n4 VSS 0.0936965f
C145 gp.0.n5 VSS 0.163612f
C146 gp.0.t33 VSS 2.45802f
C147 gp.0.n6 VSS 0.0231037f
C148 gp.0.t1 VSS 0.055326f
C149 gp.0.t2 VSS 0.055069f
C150 gp.0.n7 VSS 0.0703725f
C151 gp.0.t3 VSS 0.055069f
C152 gp.0.n8 VSS 0.0404265f
C153 gp.0.t4 VSS 0.055069f
C154 gp.0.n9 VSS 0.0404265f
C155 gp.0.t5 VSS 0.055069f
C156 gp.0.n10 VSS 0.0404265f
C157 gp.0.t6 VSS 0.055069f
C158 gp.0.n11 VSS 0.0404265f
C159 gp.0.t7 VSS 0.055069f
C160 gp.0.n12 VSS 0.0404265f
C161 gp.0.t8 VSS 0.055069f
C162 gp.0.n13 VSS 0.0399926f
C163 gp.0.t9 VSS 0.055069f
C164 gp.0.n14 VSS 0.0298025f
C165 gp.0.t10 VSS 0.055069f
C166 gp.0.n15 VSS 0.119871f
C167 gp.0.t11 VSS 0.044128f
C168 gp.0.t12 VSS 0.0439644f
C169 gp.0.n16 VSS 0.0608366f
C170 gp.0.t13 VSS 0.0439644f
C171 gp.0.n17 VSS 0.0350694f
C172 gp.0.t14 VSS 0.0439644f
C173 gp.0.n18 VSS 0.0350694f
C174 gp.0.t15 VSS 0.0439644f
C175 gp.0.n19 VSS 0.0350694f
C176 gp.0.t16 VSS 0.0439644f
C177 gp.0.n20 VSS 0.0350694f
C178 gp.0.t17 VSS 0.0439644f
C179 gp.0.n21 VSS 0.0350694f
C180 gp.0.t18 VSS 0.0439644f
C181 gp.0.n22 VSS 0.0350694f
C182 gp.0.t19 VSS 0.0439644f
C183 gp.0.n23 VSS 0.0350694f
C184 gp.0.t20 VSS 0.0439644f
C185 gp.0.n24 VSS 0.0350694f
C186 gp.0.t21 VSS 0.0439644f
C187 gp.0.n25 VSS 0.0350694f
C188 gp.0.t22 VSS 0.0439644f
C189 gp.0.n26 VSS 0.0350694f
C190 gp.0.t23 VSS 0.0439644f
C191 gp.0.n27 VSS 0.0350694f
C192 gp.0.t24 VSS 0.0439644f
C193 gp.0.n28 VSS 0.0350694f
C194 gp.0.t25 VSS 0.0439644f
C195 gp.0.n29 VSS 0.0350694f
C196 gp.0.t26 VSS 0.0439644f
C197 gp.0.n30 VSS 0.0350694f
C198 gp.0.t27 VSS 0.0439644f
C199 gp.0.n31 VSS 0.0321256f
C200 gp.0.t28 VSS 0.0439644f
C201 gp.0.n32 VSS 0.0346889f
C202 gp.0.t29 VSS 0.0439644f
C203 gp.0.n33 VSS 0.0350694f
C204 gp.0.t30 VSS 0.0439644f
C205 gp.0.n34 VSS 0.0350694f
C206 gp.0.t31 VSS 0.0439644f
C207 gp.0.n35 VSS 0.0350694f
C208 gp.0.t32 VSS 0.0439644f
C209 gp.0.n36 VSS 0.145061f
C210 gn.0.t0 VSS 0.0598882f
C211 gn.0.n0 VSS 0.164011f
C212 gn.0.t34 VSS 2.46401f
C213 gn.0.n1 VSS 0.0939244f
C214 gn.0.n2 VSS 0.0480429f
C215 gn.0.n3 VSS 0.210351f
C216 gn.0.t33 VSS 1.25971f
C217 gn.0.n4 VSS 0.690174f
C218 gn.0.n5 VSS 0.539073f
C219 gn.0.t32 VSS 0.0446763f
C220 gn.0.t31 VSS 0.0440704f
C221 gn.0.n6 VSS 0.0672044f
C222 gn.0.t30 VSS 0.0440704f
C223 gn.0.n7 VSS 0.0351561f
C224 gn.0.t29 VSS 0.0440704f
C225 gn.0.n8 VSS 0.0351561f
C226 gn.0.t28 VSS 0.0440704f
C227 gn.0.n9 VSS 0.0351561f
C228 gn.0.t27 VSS 0.0440704f
C229 gn.0.n10 VSS 0.0351561f
C230 gn.0.t26 VSS 0.0440704f
C231 gn.0.n11 VSS 0.0351561f
C232 gn.0.t25 VSS 0.0440704f
C233 gn.0.n12 VSS 0.0351561f
C234 gn.0.t24 VSS 0.0440704f
C235 gn.0.n13 VSS 0.0351561f
C236 gn.0.t23 VSS 0.0440704f
C237 gn.0.n14 VSS 0.0351561f
C238 gn.0.t22 VSS 0.0440704f
C239 gn.0.n15 VSS 0.0351561f
C240 gn.0.t21 VSS 0.0440704f
C241 gn.0.n16 VSS 0.0351561f
C242 gn.0.t20 VSS 0.0440704f
C243 gn.0.n17 VSS 0.0351561f
C244 gn.0.t19 VSS 0.0440704f
C245 gn.0.n18 VSS 0.0351561f
C246 gn.0.t18 VSS 0.0440704f
C247 gn.0.n19 VSS 0.0351561f
C248 gn.0.t17 VSS 0.0440704f
C249 gn.0.n20 VSS 0.0351561f
C250 gn.0.t16 VSS 0.0440704f
C251 gn.0.n21 VSS 0.0338691f
C252 gn.0.t15 VSS 0.0440704f
C253 gn.0.n22 VSS 0.0264449f
C254 gn.0.t14 VSS 0.0440704f
C255 gn.0.n23 VSS 0.0351561f
C256 gn.0.t13 VSS 0.0440704f
C257 gn.0.n24 VSS 0.0351561f
C258 gn.0.t12 VSS 0.0440704f
C259 gn.0.n25 VSS 0.0351561f
C260 gn.0.t11 VSS 0.0440704f
C261 gn.0.n26 VSS 0.164417f
C262 gn.0.t10 VSS 0.0561417f
C263 gn.0.t9 VSS 0.0552051f
C264 gn.0.n27 VSS 0.0772485f
C265 gn.0.t8 VSS 0.0552051f
C266 gn.0.n28 VSS 0.0405237f
C267 gn.0.t7 VSS 0.0552051f
C268 gn.0.n29 VSS 0.0405237f
C269 gn.0.t6 VSS 0.0552051f
C270 gn.0.n30 VSS 0.0405237f
C271 gn.0.t5 VSS 0.0552051f
C272 gn.0.n31 VSS 0.0405237f
C273 gn.0.t4 VSS 0.0552051f
C274 gn.0.n32 VSS 0.0382411f
C275 gn.0.t3 VSS 0.0552051f
C276 gn.0.n33 VSS 0.031724f
C277 gn.0.t2 VSS 0.0552051f
C278 gn.0.n34 VSS 0.0405237f
C279 gn.0.t1 VSS 0.0552051f
C280 gn.0.n35 VSS 0.10185f
C281 gn.0.n36 VSS 0.0107875f
C282 fb.0.t51 VSS 0.014658f
C283 fb.0.n0 VSS 0.0316656f
C284 fb.0.t48 VSS 0.014658f
C285 fb.0.t49 VSS 0.014658f
C286 fb.0.n1 VSS 0.0316656f
C287 fb.0.n2 VSS 0.0825524f
C288 fb.0.t46 VSS 0.014658f
C289 fb.0.t47 VSS 0.014658f
C290 fb.0.n3 VSS 0.0316656f
C291 fb.0.n4 VSS 0.0636937f
C292 fb.0.t44 VSS 0.014658f
C293 fb.0.t45 VSS 0.014658f
C294 fb.0.n5 VSS 0.0316656f
C295 fb.0.n6 VSS 0.0636937f
C296 fb.0.t42 VSS 0.014658f
C297 fb.0.t43 VSS 0.014658f
C298 fb.0.n7 VSS 0.0316656f
C299 fb.0.n8 VSS 0.121047f
C300 fb.0.t40 VSS 0.014658f
C301 fb.0.t41 VSS 0.014658f
C302 fb.0.n9 VSS 0.0316656f
C303 fb.0.t33 VSS 0.0778902f
C304 fb.0.n10 VSS 0.0459426f
C305 fb.0.t31 VSS 0.0281429f
C306 fb.0.t32 VSS 0.0281429f
C307 fb.0.n11 VSS 0.064511f
C308 fb.0.n12 VSS 0.0522445f
C309 fb.0.t29 VSS 0.0281429f
C310 fb.0.t30 VSS 0.0281429f
C311 fb.0.n13 VSS 0.064511f
C312 fb.0.n14 VSS 0.0522445f
C313 fb.0.t27 VSS 0.0281429f
C314 fb.0.t28 VSS 0.0281429f
C315 fb.0.n15 VSS 0.064511f
C316 fb.0.n16 VSS 0.0522445f
C317 fb.0.t25 VSS 0.0281429f
C318 fb.0.t26 VSS 0.0281429f
C319 fb.0.n17 VSS 0.064511f
C320 fb.0.n18 VSS 0.0522445f
C321 fb.0.t23 VSS 0.0281429f
C322 fb.0.t24 VSS 0.0281429f
C323 fb.0.n19 VSS 0.064511f
C324 fb.0.n20 VSS 0.0522445f
C325 fb.0.t59 VSS 0.0281429f
C326 fb.0.t22 VSS 0.0281429f
C327 fb.0.n21 VSS 0.064511f
C328 fb.0.n22 VSS 0.0522445f
C329 fb.0.t39 VSS 0.0281429f
C330 fb.0.t4 VSS 0.0281429f
C331 fb.0.n23 VSS 0.064511f
C332 fb.0.n24 VSS 0.0522445f
C333 fb.0.t0 VSS 0.0281429f
C334 fb.0.t37 VSS 0.0281429f
C335 fb.0.n25 VSS 0.064511f
C336 fb.0.n26 VSS 0.0522445f
C337 fb.0.t2 VSS 0.0281429f
C338 fb.0.t1 VSS 0.0281429f
C339 fb.0.n27 VSS 0.064511f
C340 fb.0.n28 VSS 0.0522445f
C341 fb.0.t3 VSS 0.0281429f
C342 fb.0.t63 VSS 0.0281429f
C343 fb.0.n29 VSS 0.064511f
C344 fb.0.n30 VSS 0.0522445f
C345 fb.0.t57 VSS 0.0281429f
C346 fb.0.t56 VSS 0.0281429f
C347 fb.0.n31 VSS 0.064511f
C348 fb.0.t34 VSS 0.0281429f
C349 fb.0.t58 VSS 0.0281429f
C350 fb.0.n32 VSS 0.064511f
C351 fb.0.n33 VSS 0.0522445f
C352 fb.0.t36 VSS 0.0281429f
C353 fb.0.t35 VSS 0.0281429f
C354 fb.0.n34 VSS 0.064511f
C355 fb.0.n35 VSS 0.0522445f
C356 fb.0.t61 VSS 0.0281429f
C357 fb.0.t60 VSS 0.0281429f
C358 fb.0.n36 VSS 0.064511f
C359 fb.0.n37 VSS 0.0522445f
C360 fb.0.t52 VSS 0.0281429f
C361 fb.0.t62 VSS 0.0281429f
C362 fb.0.n38 VSS 0.064511f
C363 fb.0.n39 VSS 0.0522445f
C364 fb.0.t54 VSS 0.0281429f
C365 fb.0.t53 VSS 0.0281429f
C366 fb.0.n40 VSS 0.064511f
C367 fb.0.n41 VSS 0.0522445f
C368 fb.0.t21 VSS 0.0281429f
C369 fb.0.t55 VSS 0.0281429f
C370 fb.0.n42 VSS 0.064511f
C371 fb.0.n43 VSS 0.0522445f
C372 fb.0.t19 VSS 0.0281429f
C373 fb.0.t20 VSS 0.0281429f
C374 fb.0.n44 VSS 0.064511f
C375 fb.0.n45 VSS 0.0522445f
C376 fb.0.t17 VSS 0.0281429f
C377 fb.0.t18 VSS 0.0281429f
C378 fb.0.n46 VSS 0.064511f
C379 fb.0.n47 VSS 0.0522445f
C380 fb.0.t15 VSS 0.0281429f
C381 fb.0.t16 VSS 0.0281429f
C382 fb.0.n48 VSS 0.064511f
C383 fb.0.n49 VSS 0.0522445f
C384 fb.0.t13 VSS 0.0281429f
C385 fb.0.t14 VSS 0.0281429f
C386 fb.0.n50 VSS 0.064511f
C387 fb.0.n51 VSS 0.0802213f
C388 fb.0.t12 VSS 0.0778902f
C389 fb.0.t11 VSS 0.0265016f
C390 fb.0.t38 VSS 0.0265016f
C391 fb.0.n52 VSS 0.0559216f
C392 fb.0.n53 VSS 0.0419165f
C393 fb.0.t9 VSS 0.0265016f
C394 fb.0.t10 VSS 0.0265016f
C395 fb.0.n54 VSS 0.0559216f
C396 fb.0.n55 VSS 0.0253385f
C397 fb.0.t7 VSS 0.0265016f
C398 fb.0.t8 VSS 0.0265016f
C399 fb.0.n56 VSS 0.0559216f
C400 fb.0.n57 VSS 0.0451589f
C401 fb.0.t5 VSS 0.0265016f
C402 fb.0.t6 VSS 0.0265016f
C403 fb.0.n58 VSS 0.0559216f
C404 fb.0.n59 VSS 0.0696264f
C405 fb.0.n60 VSS 0.0790549f
C406 fb.0.t50 VSS 0.014658f
C407 fa.0.t59 VSS 0.016211f
C408 fa.0.n0 VSS 0.0350211f
C409 fa.0.t57 VSS 0.016211f
C410 fa.0.t58 VSS 0.016211f
C411 fa.0.n1 VSS 0.0350211f
C412 fa.0.n2 VSS 0.133869f
C413 fa.0.t55 VSS 0.016211f
C414 fa.0.t56 VSS 0.016211f
C415 fa.0.n3 VSS 0.0350211f
C416 fa.0.n4 VSS 0.091297f
C417 fa.0.t53 VSS 0.016211f
C418 fa.0.t54 VSS 0.016211f
C419 fa.0.n5 VSS 0.0350211f
C420 fa.0.t51 VSS 0.016211f
C421 fa.0.t52 VSS 0.016211f
C422 fa.0.n6 VSS 0.0350211f
C423 fa.0.n7 VSS 0.091297f
C424 fa.0.t49 VSS 0.016211f
C425 fa.0.t50 VSS 0.016211f
C426 fa.0.n8 VSS 0.0350211f
C427 fa.0.n9 VSS 0.091297f
C428 fa.0.t46 VSS 0.016211f
C429 fa.0.t48 VSS 0.016211f
C430 fa.0.n10 VSS 0.0350211f
C431 fa.0.n11 VSS 0.0768049f
C432 fa.0.t16 VSS 0.0311234f
C433 fa.0.t17 VSS 0.0311234f
C434 fa.0.n12 VSS 0.0713447f
C435 fa.0.n13 VSS 0.0572484f
C436 fa.0.t18 VSS 0.0311234f
C437 fa.0.t19 VSS 0.0311234f
C438 fa.0.n14 VSS 0.0713447f
C439 fa.0.n15 VSS 0.057778f
C440 fa.0.t20 VSS 0.0311234f
C441 fa.0.t21 VSS 0.0311234f
C442 fa.0.n16 VSS 0.0713447f
C443 fa.0.n17 VSS 0.057778f
C444 fa.0.t22 VSS 0.0311234f
C445 fa.0.t23 VSS 0.0311234f
C446 fa.0.n18 VSS 0.0713447f
C447 fa.0.n19 VSS 0.057778f
C448 fa.0.t24 VSS 0.0311234f
C449 fa.0.t25 VSS 0.0311234f
C450 fa.0.n20 VSS 0.0713447f
C451 fa.0.n21 VSS 0.057778f
C452 fa.0.t3 VSS 0.0311234f
C453 fa.0.t61 VSS 0.0311234f
C454 fa.0.n22 VSS 0.0713447f
C455 fa.0.n23 VSS 0.057778f
C456 fa.0.t1 VSS 0.0311234f
C457 fa.0.t6 VSS 0.0311234f
C458 fa.0.n24 VSS 0.0713447f
C459 fa.0.n25 VSS 0.057778f
C460 fa.0.t41 VSS 0.0311234f
C461 fa.0.t62 VSS 0.0311234f
C462 fa.0.n26 VSS 0.0713447f
C463 fa.0.n27 VSS 0.057778f
C464 fa.0.t42 VSS 0.0311234f
C465 fa.0.t5 VSS 0.0311234f
C466 fa.0.n28 VSS 0.0713447f
C467 fa.0.n29 VSS 0.057778f
C468 fa.0.t0 VSS 0.0311234f
C469 fa.0.t39 VSS 0.0311234f
C470 fa.0.n30 VSS 0.0713447f
C471 fa.0.n31 VSS 0.057778f
C472 fa.0.t63 VSS 0.0311234f
C473 fa.0.t44 VSS 0.0311234f
C474 fa.0.n32 VSS 0.0713447f
C475 fa.0.n33 VSS 0.0452687f
C476 fa.0.t4 VSS 0.0311234f
C477 fa.0.t40 VSS 0.0311234f
C478 fa.0.n34 VSS 0.0713447f
C479 fa.0.n35 VSS 0.0452687f
C480 fa.0.t64 VSS 0.0311234f
C481 fa.0.t7 VSS 0.0311234f
C482 fa.0.n36 VSS 0.0713447f
C483 fa.0.n37 VSS 0.057778f
C484 fa.0.t65 VSS 0.0311234f
C485 fa.0.t2 VSS 0.0311234f
C486 fa.0.n38 VSS 0.0713447f
C487 fa.0.n39 VSS 0.057778f
C488 fa.0.t38 VSS 0.0311234f
C489 fa.0.t43 VSS 0.0311234f
C490 fa.0.n40 VSS 0.0713447f
C491 fa.0.n41 VSS 0.057778f
C492 fa.0.t60 VSS 0.0311234f
C493 fa.0.t8 VSS 0.0311234f
C494 fa.0.n42 VSS 0.0713447f
C495 fa.0.n43 VSS 0.057778f
C496 fa.0.t26 VSS 0.0311234f
C497 fa.0.t27 VSS 0.0311234f
C498 fa.0.n44 VSS 0.0713447f
C499 fa.0.n45 VSS 0.057778f
C500 fa.0.t28 VSS 0.0311234f
C501 fa.0.t29 VSS 0.0311234f
C502 fa.0.n46 VSS 0.0713447f
C503 fa.0.n47 VSS 0.057778f
C504 fa.0.t30 VSS 0.0311234f
C505 fa.0.t31 VSS 0.0311234f
C506 fa.0.n48 VSS 0.0713447f
C507 fa.0.n49 VSS 0.057778f
C508 fa.0.t32 VSS 0.0311234f
C509 fa.0.t33 VSS 0.0311234f
C510 fa.0.n50 VSS 0.0713447f
C511 fa.0.n51 VSS 0.057778f
C512 fa.0.t34 VSS 0.0311234f
C513 fa.0.t35 VSS 0.0311234f
C514 fa.0.n52 VSS 0.0713447f
C515 fa.0.n53 VSS 0.0887186f
C516 fa.0.t36 VSS 0.0311234f
C517 fa.0.t37 VSS 0.0311234f
C518 fa.0.n54 VSS 0.0713447f
C519 fa.0.t9 VSS 0.0293084f
C520 fa.0.t10 VSS 0.0293084f
C521 fa.0.n55 VSS 0.0618454f
C522 fa.0.n56 VSS 0.0499222f
C523 fa.0.t11 VSS 0.0293084f
C524 fa.0.t12 VSS 0.0293084f
C525 fa.0.n57 VSS 0.0618454f
C526 fa.0.n58 VSS 0.0280229f
C527 fa.0.t13 VSS 0.0293084f
C528 fa.0.t14 VSS 0.0293084f
C529 fa.0.n59 VSS 0.0618454f
C530 fa.0.n60 VSS 0.049943f
C531 fa.0.t15 VSS 0.0293084f
C532 fa.0.t45 VSS 0.0293084f
C533 fa.0.n61 VSS 0.0618454f
C534 fa.0.n62 VSS 0.0794549f
C535 fa.0.t47 VSS 0.016211f
C536 oa.0.t23 VSS 0.0379419f
C537 oa.0.n0 VSS 0.0855457f
C538 oa.0.t20 VSS 0.0379419f
C539 oa.0.t21 VSS 0.0379419f
C540 oa.0.n1 VSS 0.0855457f
C541 oa.0.n2 VSS 0.118717f
C542 oa.0.t1 VSS 0.0379419f
C543 oa.0.t4 VSS 0.0379419f
C544 oa.0.n3 VSS 0.0855457f
C545 oa.0.n4 VSS 0.0780625f
C546 oa.0.t6 VSS 0.0379419f
C547 oa.0.t0 VSS 0.0379419f
C548 oa.0.n5 VSS 0.0855457f
C549 oa.0.n6 VSS 0.0780625f
C550 oa.0.t5 VSS 0.0379419f
C551 oa.0.t24 VSS 0.0379419f
C552 oa.0.n7 VSS 0.0855457f
C553 oa.0.n8 VSS 0.0609391f
C554 oa.0.t28 VSS 0.0379419f
C555 oa.0.t27 VSS 0.0379419f
C556 oa.0.n9 VSS 0.0855457f
C557 oa.0.n10 VSS 0.0609391f
C558 oa.0.t25 VSS 0.0379419f
C559 oa.0.t3 VSS 0.0379419f
C560 oa.0.n11 VSS 0.0855457f
C561 oa.0.n12 VSS 0.0780625f
C562 oa.0.t18 VSS 0.0379419f
C563 oa.0.t19 VSS 0.0379419f
C564 oa.0.n13 VSS 0.0855457f
C565 oa.0.n14 VSS 0.0780625f
C566 oa.0.t16 VSS 0.0379419f
C567 oa.0.t17 VSS 0.0379419f
C568 oa.0.n15 VSS 0.0855457f
C569 oa.0.n16 VSS 0.0780625f
C570 oa.0.t14 VSS 0.0379419f
C571 oa.0.t15 VSS 0.0379419f
C572 oa.0.n17 VSS 0.0855457f
C573 oa.0.n18 VSS 0.0678476f
C574 oa.0.n19 VSS 0.0704506f
C575 oa.0.t31 VSS 0.0871223f
C576 oa.0.n20 VSS 0.0534093f
C577 oa.0.t30 VSS 0.0871223f
C578 oa.0.n21 VSS 0.109701f
C579 oa.0.t29 VSS 0.0876342f
C580 oa.0.t2 VSS 0.05362f
C581 oa.0.n22 VSS 0.101476f
C582 oa.0.t10 VSS 0.0361053f
C583 oa.0.t7 VSS 0.0361053f
C584 oa.0.n23 VSS 0.0761903f
C585 oa.0.n24 VSS 0.0637419f
C586 oa.0.t8 VSS 0.0361053f
C587 oa.0.t9 VSS 0.0361053f
C588 oa.0.n25 VSS 0.0761903f
C589 oa.0.n26 VSS 0.0345232f
C590 oa.0.t12 VSS 0.0361053f
C591 oa.0.t13 VSS 0.0361053f
C592 oa.0.n27 VSS 0.0761903f
C593 oa.0.n28 VSS 0.0615248f
C594 oa.0.t26 VSS 0.0361053f
C595 oa.0.t11 VSS 0.0361053f
C596 oa.0.n29 VSS 0.0761903f
C597 oa.0.t22 VSS 0.0379419f
C598 ob.0.t22 VSS 0.103884f
C599 ob.0.t20 VSS 0.0361232f
C600 ob.0.t21 VSS 0.0361232f
C601 ob.0.n0 VSS 0.0814459f
C602 ob.0.n1 VSS 0.0743201f
C603 ob.0.t26 VSS 0.0361232f
C604 ob.0.t19 VSS 0.0361232f
C605 ob.0.n2 VSS 0.0814459f
C606 ob.0.n3 VSS 0.0743201f
C607 ob.0.t4 VSS 0.0361232f
C608 ob.0.t27 VSS 0.0361232f
C609 ob.0.n4 VSS 0.0814459f
C610 ob.0.n5 VSS 0.0743201f
C611 ob.0.t23 VSS 0.0361232f
C612 ob.0.t1 VSS 0.0361232f
C613 ob.0.n6 VSS 0.0814459f
C614 ob.0.n7 VSS 0.0743201f
C615 ob.0.t2 VSS 0.0361232f
C616 ob.0.t24 VSS 0.0361232f
C617 ob.0.n8 VSS 0.0814459f
C618 ob.0.t0 VSS 0.0361232f
C619 ob.0.t28 VSS 0.0361232f
C620 ob.0.n9 VSS 0.0814459f
C621 ob.0.n10 VSS 0.0743201f
C622 ob.0.t18 VSS 0.0361232f
C623 ob.0.t3 VSS 0.0361232f
C624 ob.0.n11 VSS 0.0814459f
C625 ob.0.n12 VSS 0.0743201f
C626 ob.0.t16 VSS 0.0361232f
C627 ob.0.t17 VSS 0.0361232f
C628 ob.0.n13 VSS 0.0814459f
C629 ob.0.n14 VSS 0.0743201f
C630 ob.0.t14 VSS 0.0361232f
C631 ob.0.t15 VSS 0.0361232f
C632 ob.0.n15 VSS 0.0814459f
C633 ob.0.n16 VSS 0.113025f
C634 ob.0.t13 VSS 0.103884f
C635 ob.0.t25 VSS 0.0343748f
C636 ob.0.t6 VSS 0.0343748f
C637 ob.0.n17 VSS 0.0725374f
C638 ob.0.n18 VSS 0.0565032f
C639 ob.0.t10 VSS 0.0343748f
C640 ob.0.t11 VSS 0.0343748f
C641 ob.0.n19 VSS 0.0725374f
C642 ob.0.n20 VSS 0.0328672f
C643 ob.0.t12 VSS 0.0343748f
C644 ob.0.t7 VSS 0.0343748f
C645 ob.0.n21 VSS 0.0725374f
C646 ob.0.n22 VSS 0.0585769f
C647 ob.0.t8 VSS 0.0343748f
C648 ob.0.t9 VSS 0.0343748f
C649 ob.0.n23 VSS 0.0725374f
C650 ob.0.t5 VSS 0.0510518f
C651 ob.0.t31 VSS 0.0834323f
C652 ob.0.t30 VSS 0.0829456f
C653 ob.0.n24 VSS 0.104442f
C654 ob.0.t29 VSS 0.0829456f
C655 ob.0.n25 VSS 0.0508508f
C656 ob.0.n26 VSS 0.105934f
C657 ob.0.n27 VSS 0.0251093f
C658 ob.0.n28 VSS 0.0562069f
C659 tn.0.t46 VSS 0.0179299f
C660 tn.0.n0 VSS 0.037081f
C661 tn.0.t44 VSS 0.0179299f
C662 tn.0.t45 VSS 0.0179299f
C663 tn.0.n1 VSS 0.037081f
C664 tn.0.n2 VSS 0.054022f
C665 tn.0.t42 VSS 0.0179299f
C666 tn.0.t43 VSS 0.0179299f
C667 tn.0.n3 VSS 0.037081f
C668 tn.0.n4 VSS 0.0426383f
C669 tn.0.t40 VSS 0.0179299f
C670 tn.0.t41 VSS 0.0179299f
C671 tn.0.n5 VSS 0.037081f
C672 tn.0.n6 VSS 0.0426383f
C673 tn.0.t38 VSS 0.0179299f
C674 tn.0.t39 VSS 0.0179299f
C675 tn.0.n7 VSS 0.037081f
C676 tn.0.n8 VSS 0.0844788f
C677 tn.0.t35 VSS 0.0179299f
C678 tn.0.t37 VSS 0.0179299f
C679 tn.0.n9 VSS 0.037081f
C680 tn.0.t19 VSS 0.0340669f
C681 tn.0.t27 VSS 0.0340669f
C682 tn.0.n10 VSS 0.0681354f
C683 tn.0.n11 VSS 0.0439222f
C684 tn.0.t28 VSS 0.0340669f
C685 tn.0.t15 VSS 0.0340669f
C686 tn.0.n12 VSS 0.0681354f
C687 tn.0.n13 VSS 0.0385758f
C688 tn.0.t16 VSS 0.0340669f
C689 tn.0.t29 VSS 0.0340669f
C690 tn.0.n14 VSS 0.0681354f
C691 tn.0.n15 VSS 0.0385758f
C692 tn.0.t30 VSS 0.0340669f
C693 tn.0.t17 VSS 0.0340669f
C694 tn.0.n16 VSS 0.0681354f
C695 tn.0.n17 VSS 0.0385758f
C696 tn.0.t18 VSS 0.0340669f
C697 tn.0.t23 VSS 0.0340669f
C698 tn.0.n18 VSS 0.0681354f
C699 tn.0.n19 VSS 0.0385758f
C700 tn.0.t24 VSS 0.0340669f
C701 tn.0.t11 VSS 0.0340669f
C702 tn.0.n20 VSS 0.0681354f
C703 tn.0.n21 VSS 0.0385758f
C704 tn.0.t8 VSS 0.0340669f
C705 tn.0.t34 VSS 0.0340669f
C706 tn.0.n22 VSS 0.0681354f
C707 tn.0.n23 VSS 0.0385758f
C708 tn.0.t3 VSS 0.0340669f
C709 tn.0.t2 VSS 0.0340669f
C710 tn.0.n24 VSS 0.0681354f
C711 tn.0.n25 VSS 0.0385758f
C712 tn.0.t51 VSS 0.0340669f
C713 tn.0.t50 VSS 0.0340669f
C714 tn.0.n26 VSS 0.0681354f
C715 tn.0.n27 VSS 0.0385758f
C716 tn.0.t48 VSS 0.0340669f
C717 tn.0.t7 VSS 0.0340669f
C718 tn.0.n28 VSS 0.0681354f
C719 tn.0.n29 VSS 0.0309963f
C720 tn.0.t33 VSS 0.0340669f
C721 tn.0.t6 VSS 0.0340669f
C722 tn.0.n30 VSS 0.0681354f
C723 tn.0.n31 VSS 0.0309963f
C724 tn.0.t31 VSS 0.0340669f
C725 tn.0.t32 VSS 0.0340669f
C726 tn.0.n32 VSS 0.0681354f
C727 tn.0.n33 VSS 0.0385758f
C728 tn.0.t5 VSS 0.0340669f
C729 tn.0.t10 VSS 0.0340669f
C730 tn.0.n34 VSS 0.0681354f
C731 tn.0.n35 VSS 0.0385758f
C732 tn.0.t0 VSS 0.0340669f
C733 tn.0.t9 VSS 0.0340669f
C734 tn.0.n36 VSS 0.0681354f
C735 tn.0.n37 VSS 0.0385758f
C736 tn.0.t49 VSS 0.0340669f
C737 tn.0.t1 VSS 0.0340669f
C738 tn.0.n38 VSS 0.0681354f
C739 tn.0.n39 VSS 0.0385758f
C740 tn.0.t4 VSS 0.0340669f
C741 tn.0.t47 VSS 0.0340669f
C742 tn.0.n40 VSS 0.0681354f
C743 tn.0.n41 VSS 0.0385758f
C744 tn.0.t12 VSS 0.0340669f
C745 tn.0.t25 VSS 0.0340669f
C746 tn.0.n42 VSS 0.0681354f
C747 tn.0.n43 VSS 0.0385758f
C748 tn.0.t26 VSS 0.0340669f
C749 tn.0.t13 VSS 0.0340669f
C750 tn.0.n44 VSS 0.0681354f
C751 tn.0.n45 VSS 0.0385758f
C752 tn.0.t14 VSS 0.0340669f
C753 tn.0.t21 VSS 0.0340669f
C754 tn.0.n46 VSS 0.0681354f
C755 tn.0.n47 VSS 0.0628211f
C756 tn.0.t22 VSS 0.0340669f
C757 tn.0.t20 VSS 0.0340669f
C758 tn.0.n48 VSS 0.0681354f
C759 tn.0.n49 VSS 0.062711f
C760 tn.0.t36 VSS 0.0179299f
C761 ts.0.t8 VSS 0.0129453f
C762 ts.0.n0 VSS 0.0267686f
C763 ts.0.t6 VSS 0.0129453f
C764 ts.0.t7 VSS 0.0129453f
C765 ts.0.n1 VSS 0.0267686f
C766 ts.0.n2 VSS 0.0307743f
C767 ts.0.t4 VSS 0.0129453f
C768 ts.0.t5 VSS 0.0129453f
C769 ts.0.n3 VSS 0.0267686f
C770 ts.0.n4 VSS 0.0527595f
C771 ts.0.t1 VSS 0.0129453f
C772 ts.0.t3 VSS 0.0129453f
C773 ts.0.n5 VSS 0.0267686f
C774 ts.0.t0 VSS 0.0347549f
C775 ts.0.t9 VSS 0.0347549f
C776 ts.0.n6 VSS 0.0377821f
C777 ts.0.t2 VSS 0.0129453f
C778 d2a.0.t5 VSS 0.00984475f
C779 d2a.0.n0 VSS 0.0212992f
C780 d2a.0.t2 VSS 0.00984475f
C781 d2a.0.t3 VSS 0.00984475f
C782 d2a.0.n1 VSS 0.0212992f
C783 d2a.0.n2 VSS 0.0343645f
C784 d2a.0.t12 VSS 0.00984475f
C785 d2a.0.t14 VSS 0.00984475f
C786 d2a.0.n3 VSS 0.0212992f
C787 d2a.0.n4 VSS 0.0341066f
C788 d2a.0.t7 VSS 0.00984475f
C789 d2a.0.t1 VSS 0.00984475f
C790 d2a.0.n5 VSS 0.0212992f
C791 d2a.0.n6 VSS 0.0269552f
C792 d2a.0.n7 VSS 0.0408273f
C793 d2a.0.t32 VSS 0.021115f
C794 d2a.0.n8 VSS 0.0580356f
C795 d2a.0.t31 VSS 0.021115f
C796 d2a.0.n9 VSS 0.0317309f
C797 d2a.0.t30 VSS 0.021115f
C798 d2a.0.n10 VSS 0.0272462f
C799 d2a.0.t29 VSS 0.021115f
C800 d2a.0.n11 VSS 0.0241971f
C801 d2a.0.t28 VSS 0.021115f
C802 d2a.0.n12 VSS 0.0317309f
C803 d2a.0.t27 VSS 0.021115f
C804 d2a.0.n13 VSS 0.0317309f
C805 d2a.0.t26 VSS 0.021115f
C806 d2a.0.n14 VSS 0.0595056f
C807 d2a.0.t25 VSS 0.0220653f
C808 d2a.0.t6 VSS 0.00984475f
C809 d2a.0.t19 VSS 0.00984475f
C810 d2a.0.n15 VSS 0.020359f
C811 d2a.0.n16 VSS 0.0138238f
C812 d2a.0.t8 VSS 0.0189996f
C813 d2a.0.t10 VSS 0.0189996f
C814 d2a.0.n17 VSS 0.0399063f
C815 d2a.0.n18 VSS 0.032934f
C816 d2a.0.t0 VSS 0.0189996f
C817 d2a.0.t9 VSS 0.0189996f
C818 d2a.0.n19 VSS 0.0399063f
C819 d2a.0.t11 VSS 0.021115f
C820 d2a.0.n20 VSS 0.0568541f
C821 d2a.0.t13 VSS 0.021115f
C822 d2a.0.n21 VSS 0.0392634f
C823 d2a.0.t24 VSS 0.021115f
C824 d2a.0.n22 VSS 0.0201913f
C825 d2a.0.t23 VSS 0.021115f
C826 d2a.0.n23 VSS 0.0237194f
C827 d2a.0.t22 VSS 0.021115f
C828 d2a.0.n24 VSS 0.0237194f
C829 d2a.0.t21 VSS 0.021115f
C830 d2a.0.n25 VSS 0.0397424f
C831 d2a.0.t15 VSS 0.021115f
C832 d2a.0.n26 VSS 0.0397424f
C833 d2a.0.t17 VSS 0.021115f
C834 d2a.0.n27 VSS 0.0441991f
C835 d2a.0.t20 VSS 0.0213487f
C836 d2a.0.n28 VSS 0.0355981f
C837 d2a.0.t16 VSS 0.00984475f
C838 d2a.0.t18 VSS 0.00984475f
C839 d2a.0.n29 VSS 0.0212992f
C840 d2a.0.n30 VSS 0.0676352f
C841 d2a.0.t4 VSS 0.00984475f
C842 sa.0.t0 VSS 0.0663438f
C843 sa.0.t4 VSS 0.0381494f
C844 sa.0.t1 VSS 0.0381494f
C845 sa.0.n0 VSS 0.0801298f
C846 sa.0.n1 VSS 0.0681516f
C847 sa.0.t3 VSS 0.0381494f
C848 sa.0.t2 VSS 0.0381494f
C849 sa.0.n2 VSS 0.0801298f
C850 rla_m1.0.t0 VSS 0.0675552f
C851 rla_m1.0.t1 VSS 0.0675552f
C852 rlb_m1.0.t0 VSS 0.064148f
C853 rlb_m1.0.t1 VSS 0.064148f
C854 d2b.0.t11 VSS 0.0137947f
C855 d2b.0.n0 VSS 0.0298448f
C856 d2b.0.t0 VSS 0.0137947f
C857 d2b.0.t15 VSS 0.0137947f
C858 d2b.0.n1 VSS 0.0298448f
C859 d2b.0.n2 VSS 0.0275598f
C860 d2b.0.t2 VSS 0.0137947f
C861 d2b.0.t1 VSS 0.0137947f
C862 d2b.0.n3 VSS 0.0298448f
C863 d2b.0.n4 VSS 0.0807009f
C864 d2b.0.t5 VSS 0.0137947f
C865 d2b.0.t7 VSS 0.0137947f
C866 d2b.0.n5 VSS 0.0298448f
C867 d2b.0.t14 VSS 0.0137947f
C868 d2b.0.t12 VSS 0.0137947f
C869 d2b.0.n6 VSS 0.0298448f
C870 d2b.0.n7 VSS 0.0514353f
C871 d2b.0.n8 VSS 0.138416f
C872 d2b.0.t25 VSS 0.0295848f
C873 d2b.0.n9 VSS 0.0796652f
C874 d2b.0.t26 VSS 0.0295848f
C875 d2b.0.n10 VSS 0.0444618f
C876 d2b.0.t27 VSS 0.0295848f
C877 d2b.0.n11 VSS 0.0409825f
C878 d2b.0.t28 VSS 0.0295848f
C879 d2b.0.n12 VSS 0.0423248f
C880 d2b.0.t29 VSS 0.0295848f
C881 d2b.0.n13 VSS 0.0444618f
C882 d2b.0.t30 VSS 0.0295848f
C883 d2b.0.n14 VSS 0.0444618f
C884 d2b.0.t31 VSS 0.0295848f
C885 d2b.0.n15 VSS 0.0731589f
C886 d2b.0.t32 VSS 0.0299146f
C887 d2b.0.t3 VSS 0.0266234f
C888 d2b.0.t18 VSS 0.0266234f
C889 d2b.0.n16 VSS 0.0559165f
C890 d2b.0.n17 VSS 0.0423544f
C891 d2b.0.t17 VSS 0.0266234f
C892 d2b.0.t16 VSS 0.0266234f
C893 d2b.0.n18 VSS 0.0559165f
C894 d2b.0.t13 VSS 0.0137947f
C895 d2b.0.t19 VSS 0.0137947f
C896 d2b.0.n19 VSS 0.0285258f
C897 d2b.0.n20 VSS 0.011051f
C898 d2b.0.t10 VSS 0.0295848f
C899 d2b.0.n21 VSS 0.0980405f
C900 d2b.0.t8 VSS 0.0295848f
C901 d2b.0.n22 VSS 0.0332354f
C902 d2b.0.t20 VSS 0.0295848f
C903 d2b.0.n23 VSS 0.0332354f
C904 d2b.0.t21 VSS 0.0295848f
C905 d2b.0.n24 VSS 0.0325632f
C906 d2b.0.t22 VSS 0.0295848f
C907 d2b.0.n25 VSS 0.0507462f
C908 d2b.0.t23 VSS 0.0295848f
C909 d2b.0.n26 VSS 0.0332354f
C910 d2b.0.t6 VSS 0.0295848f
C911 d2b.0.n27 VSS 0.0332354f
C912 d2b.0.t4 VSS 0.0295848f
C913 d2b.0.n28 VSS 0.0833791f
C914 d2b.0.t24 VSS 0.0309187f
C915 d2b.0.n29 VSS 0.049702f
C916 d2b.0.n30 VSS 0.055014f
C917 d2b.0.t9 VSS 0.0137947f
C918 sb.0.t1 VSS 0.0672651f
C919 sb.0.t2 VSS 0.0386789f
C920 sb.0.t0 VSS 0.0386789f
C921 sb.0.n0 VSS 0.0812369f
C922 sb.0.n1 VSS 0.0702893f
C923 sb.0.t4 VSS 0.0386789f
C924 sb.0.t3 VSS 0.0386789f
C925 sb.0.n2 VSS 0.0812369f
C926 n3a.0.t5 VSS 0.0175279f
C927 n3a.0.n0 VSS 0.037922f
C928 n3a.0.t7 VSS 0.0175279f
C929 n3a.0.t6 VSS 0.0175279f
C930 n3a.0.n1 VSS 0.037922f
C931 n3a.0.n2 VSS 0.0780921f
C932 n3a.0.t9 VSS 0.0175279f
C933 n3a.0.t8 VSS 0.0175279f
C934 n3a.0.n3 VSS 0.037922f
C935 n3a.0.t11 VSS 0.0175279f
C936 n3a.0.t10 VSS 0.0175279f
C937 n3a.0.n4 VSS 0.037922f
C938 n3a.0.n5 VSS 0.119908f
C939 n3a.0.t4 VSS 0.0175279f
C940 n3a.0.t12 VSS 0.0175279f
C941 n3a.0.n6 VSS 0.037922f
C942 n3a.0.t1 VSS 0.0226989f
C943 n3a.0.t3 VSS 0.0226989f
C944 n3a.0.n7 VSS 0.0489199f
C945 n3a.0.t2 VSS 0.0356644f
C946 n3a.0.n8 VSS 0.0764808f
C947 n3a.0.t13 VSS 0.0358977f
C948 n3a.0.n9 VSS 0.0673464f
C949 n3a.0.t0 VSS 0.0175279f
C950 d3.0.t1 VSS 0.0207494f
C951 d3.0.n0 VSS 0.0448905f
C952 d3.0.t5 VSS 0.0207494f
C953 d3.0.t4 VSS 0.0207494f
C954 d3.0.n1 VSS 0.0448905f
C955 d3.0.n2 VSS 0.121936f
C956 d3.0.t3 VSS 0.0207494f
C957 d3.0.t9 VSS 0.0207494f
C958 d3.0.n3 VSS 0.0448905f
C959 d3.0.n4 VSS 0.0724312f
C960 d3.0.t8 VSS 0.0207494f
C961 d3.0.t7 VSS 0.0207494f
C962 d3.0.n5 VSS 0.0448905f
C963 d3.0.n6 VSS 0.0900326f
C964 d3.0.n7 VSS 0.130521f
C965 d3.0.t10 VSS 0.0495285f
C966 d3.0.t11 VSS 0.0329857f
C967 d3.0.n8 VSS 0.208057f
C968 d3.0.t2 VSS 0.0268696f
C969 d3.0.t0 VSS 0.0268696f
C970 d3.0.n9 VSS 0.0579138f
C971 d3.0.t6 VSS 0.0207494f
C972 nd.0.t4 VSS 0.026667f
C973 nd.0.n0 VSS 0.0557853f
C974 nd.0.t3 VSS 0.026667f
C975 nd.0.t1 VSS 0.026667f
C976 nd.0.n1 VSS 0.0557853f
C977 nd.0.n2 VSS 0.0383143f
C978 nd.0.n3 VSS 0.0437433f
C979 nd.0.t0 VSS 0.017778f
C980 nd.0.t2 VSS 0.017778f
C981 nd.0.n4 VSS 0.0379415f
C982 nd.0.t7 VSS 0.0212774f
C983 nd.0.n5 VSS 0.0612976f
C984 nd.0.t6 VSS 0.0523735f
C985 nd.0.t5 VSS 0.026667f
C986 nm.0.t0 VSS 0.0315017f
C987 nm.0.n0 VSS 0.0630033f
C988 nm.0.t1 VSS 0.0315017f
C989 i1.0.t0 VSS 0.0124724f
C990 i1.0.n0 VSS 0.0254788f
C991 i1.0.n1 VSS 0.0144038f
C992 i1.0.n2 VSS 0.0257771f
C993 i1.0.n3 VSS 0.0727097f
C994 i1.0.t5 VSS 0.0492722f
C995 i1.0.n4 VSS 0.0844232f
C996 i1.0.t4 VSS 0.0494658f
C997 i1.0.t6 VSS 0.0396365f
C998 i1.0.t1 VSS 0.0307598f
C999 i1.0.t2 VSS 0.0307598f
C1000 i1.0.n5 VSS 0.064461f
C1001 i1.0.t3 VSS 0.0124724f
C1002 i2.0.t3 VSS 0.0311928f
C1003 i2.0.n0 VSS 0.066033f
C1004 i2.0.t2 VSS 0.0311928f
C1005 i2.0.t4 VSS 0.0311928f
C1006 i2.0.n1 VSS 0.066033f
C1007 i2.0.n2 VSS 0.0357609f
C1008 i2.0.n3 VSS 0.0219111f
C1009 i2.0.t0 VSS 0.0249551f
C1010 i2.0.t5 VSS 0.0249551f
C1011 i2.0.n4 VSS 0.0518352f
C1012 i2.0.n5 VSS 0.0304747f
C1013 i2.0.t9 VSS 0.0660021f
C1014 i2.0.n6 VSS 0.044972f
C1015 i2.0.t8 VSS 0.0660021f
C1016 i2.0.n7 VSS 0.049386f
C1017 i2.0.t7 VSS 0.0660021f
C1018 i2.0.n8 VSS 0.0943976f
C1019 i2.0.t6 VSS 0.0661783f
C1020 i2.0.t11 VSS 0.052637f
C1021 i2.0.n9 VSS 0.085583f
C1022 i2.0.t10 VSS 0.0528264f
C1023 i2.0.t1 VSS 0.0311928f
C1024 VDD.n0 VSS 0.691724f
C1025 VDD.n1 VSS 0.691724f
C1026 VDD.n2 VSS 0.113942f
C1027 VDD.n3 VSS 0.0926541f
C1028 VDD.n4 VSS 0.677211f
C1029 VDD.n5 VSS 0.677211f
C1030 VDD.t81 VSS 0.554811f
C1031 VDD.t42 VSS 0.353257f
C1032 VDD.t40 VSS 0.353257f
C1033 VDD.t38 VSS 0.353257f
C1034 VDD.t36 VSS 0.353257f
C1035 VDD.t34 VSS 0.353257f
C1036 VDD.t32 VSS 0.353257f
C1037 VDD.t30 VSS 0.353257f
C1038 VDD.t28 VSS 0.353257f
C1039 VDD.t26 VSS 0.353257f
C1040 VDD.t24 VSS 0.353257f
C1041 VDD.t22 VSS 0.264943f
C1042 VDD.t78 VSS 0.554811f
C1043 VDD.t0 VSS 0.353257f
C1044 VDD.t2 VSS 0.353257f
C1045 VDD.t4 VSS 0.353257f
C1046 VDD.t6 VSS 0.353257f
C1047 VDD.t8 VSS 0.353257f
C1048 VDD.t10 VSS 0.353257f
C1049 VDD.t12 VSS 0.353257f
C1050 VDD.t14 VSS 0.353257f
C1051 VDD.t16 VSS 0.353257f
C1052 VDD.t18 VSS 0.353257f
C1053 VDD.t20 VSS 0.264943f
C1054 VDD.t80 VSS 0.096627f
C1055 VDD.n6 VSS 0.17277f
C1056 VDD.t77 VSS 0.096627f
C1057 VDD.t79 VSS 0.0428033f
C1058 VDD.n7 VSS 0.233666f
C1059 VDD.n8 VSS 0.372679f
C1060 VDD.n9 VSS 0.372679f
C1061 VDD.n10 VSS 0.0571765f
C1062 VDD.t45 VSS 0.54281f
C1063 VDD.n13 VSS 0.0571765f
C1064 VDD.t155 VSS 0.0222367f
C1065 VDD.n14 VSS 0.0159674f
C1066 VDD.t133 VSS 0.0222367f
C1067 VDD.n15 VSS 0.0159674f
C1068 VDD.n16 VSS 2.22681f
C1069 VDD.n17 VSS 2.09199f
C1070 VDD.n18 VSS 0.010704f
C1071 VDD.n19 VSS 0.021408f
C1072 VDD.n20 VSS 0.286661f
C1073 VDD.n21 VSS 0.0336935f
C1074 VDD.n22 VSS 0.0200732f
C1075 VDD.n23 VSS 0.489101f
C1076 VDD.n24 VSS 0.489101f
C1077 VDD.t123 VSS 0.429324f
C1078 VDD.t64 VSS 0.185922f
C1079 VDD.t182 VSS 0.139443f
C1080 VDD.t122 VSS 0.0265955f
C1081 VDD.n25 VSS 0.0738146f
C1082 VDD.t119 VSS 0.0265955f
C1083 VDD.t124 VSS 0.042778f
C1084 VDD.t65 VSS 0.0165621f
C1085 VDD.t183 VSS 0.0165621f
C1086 VDD.n26 VSS 0.0354396f
C1087 VDD.n27 VSS 0.0218129f
C1088 VDD.t185 VSS 0.0165621f
C1089 VDD.t187 VSS 0.0165621f
C1090 VDD.n28 VSS 0.0354396f
C1091 VDD.n29 VSS 0.0119376f
C1092 VDD.n30 VSS 0.134464f
C1093 VDD.n31 VSS 0.00877449f
C1094 VDD.t98 VSS 0.0190673f
C1095 VDD.n32 VSS 0.0498887f
C1096 VDD.n33 VSS 0.061839f
C1097 VDD.n34 VSS 0.061839f
C1098 VDD.t97 VSS 0.0164545f
C1099 VDD.n35 VSS 0.0211296f
C1100 VDD.t95 VSS 0.0190673f
C1101 VDD.n36 VSS 0.0226732f
C1102 VDD.n37 VSS 0.0869415f
C1103 VDD.n38 VSS 0.203838f
C1104 VDD.t109 VSS 0.0313845f
C1105 VDD.n39 VSS 0.175193f
C1106 VDD.n40 VSS 0.0125829f
C1107 VDD.n41 VSS 0.0328015f
C1108 VDD.t110 VSS 0.0197189f
C1109 VDD.n42 VSS 0.0628702f
C1110 VDD.n43 VSS 0.0669063f
C1111 VDD.t107 VSS 0.0197189f
C1112 VDD.n44 VSS 0.0628069f
C1113 VDD.n45 VSS 0.0669063f
C1114 VDD.n46 VSS 0.414274f
C1115 VDD.t108 VSS 0.368155f
C1116 VDD.t127 VSS 0.159421f
C1117 VDD.t111 VSS 0.368155f
C1118 VDD.n47 VSS 0.414274f
C1119 VDD.n48 VSS 0.0307835f
C1120 VDD.t112 VSS 0.0436447f
C1121 VDD.t128 VSS 0.0122603f
C1122 VDD.n49 VSS 0.0256845f
C1123 VDD.n50 VSS 0.00754088f
C1124 VDD.n51 VSS 0.0249444f
C1125 VDD.n52 VSS 0.014563f
C1126 VDD.n53 VSS 0.142998f
C1127 VDD.n54 VSS 0.220153f
C1128 VDD.t74 VSS 0.0190673f
C1129 VDD.n55 VSS 0.0498887f
C1130 VDD.n56 VSS 0.0227934f
C1131 VDD.n57 VSS 0.342876f
C1132 VDD.n58 VSS 0.342876f
C1133 VDD.t75 VSS 0.31387f
C1134 VDD.n59 VSS 0.0375146f
C1135 VDD.t76 VSS 0.0230781f
C1136 VDD.t191 VSS 0.00662357f
C1137 VDD.n60 VSS 0.0137026f
C1138 VDD.n61 VSS 0.0168404f
C1139 VDD.n62 VSS 0.11274f
C1140 VDD.t193 VSS 0.00993852f
C1141 VDD.t67 VSS 0.00993852f
C1142 VDD.n63 VSS 0.020788f
C1143 VDD.t106 VSS 0.0250139f
C1144 VDD.t104 VSS 0.016037f
C1145 VDD.n64 VSS 0.0496293f
C1146 VDD.n65 VSS 0.0671973f
C1147 VDD.n66 VSS 0.0671973f
C1148 VDD.n67 VSS 0.0229959f
C1149 VDD.n68 VSS 0.115353f
C1150 VDD.t83 VSS 0.014854f
C1151 VDD.n69 VSS 0.401558f
C1152 VDD.t85 VSS 0.0159168f
C1153 VDD.n70 VSS 0.109298f
C1154 VDD.t88 VSS 0.0159168f
C1155 VDD.t86 VSS 0.014854f
C1156 VDD.n71 VSS 0.0896238f
C1157 VDD.n72 VSS 0.0627879f
C1158 VDD.n73 VSS 0.123109f
C1159 VDD.n74 VSS 0.123109f
C1160 VDD.t84 VSS 0.302173f
C1161 VDD.t176 VSS 0.143479f
C1162 VDD.t62 VSS 0.143479f
C1163 VDD.t148 VSS 0.143479f
C1164 VDD.t174 VSS 0.143479f
C1165 VDD.t172 VSS 0.143479f
C1166 VDD.t146 VSS 0.143479f
C1167 VDD.t144 VSS 0.143479f
C1168 VDD.t140 VSS 0.107609f
C1169 VDD.n75 VSS 0.0717396f
C1170 VDD.t138 VSS 0.107609f
C1171 VDD.t142 VSS 0.143479f
C1172 VDD.t170 VSS 0.143479f
C1173 VDD.t136 VSS 0.143479f
C1174 VDD.t134 VSS 0.143479f
C1175 VDD.t168 VSS 0.143479f
C1176 VDD.t166 VSS 0.143479f
C1177 VDD.t56 VSS 0.143479f
C1178 VDD.t87 VSS 0.302173f
C1179 VDD.n76 VSS 0.401558f
C1180 VDD.n77 VSS 0.0159864f
C1181 VDD.t57 VSS 0.00662357f
C1182 VDD.t167 VSS 0.00662357f
C1183 VDD.n78 VSS 0.0132535f
C1184 VDD.n79 VSS 0.0163913f
C1185 VDD.t169 VSS 0.00662357f
C1186 VDD.t135 VSS 0.00662357f
C1187 VDD.n80 VSS 0.0132535f
C1188 VDD.n81 VSS 0.0163913f
C1189 VDD.t137 VSS 0.00662357f
C1190 VDD.t171 VSS 0.00662357f
C1191 VDD.n82 VSS 0.0132535f
C1192 VDD.n83 VSS 0.0163913f
C1193 VDD.t143 VSS 0.00662357f
C1194 VDD.t139 VSS 0.00662357f
C1195 VDD.n84 VSS 0.0132535f
C1196 VDD.n85 VSS 0.0132408f
C1197 VDD.t141 VSS 0.00662357f
C1198 VDD.t145 VSS 0.00662357f
C1199 VDD.n86 VSS 0.0132535f
C1200 VDD.n87 VSS 0.0132408f
C1201 VDD.t147 VSS 0.00662357f
C1202 VDD.t173 VSS 0.00662357f
C1203 VDD.n88 VSS 0.0132535f
C1204 VDD.n89 VSS 0.0163913f
C1205 VDD.t175 VSS 0.00662357f
C1206 VDD.t149 VSS 0.00662357f
C1207 VDD.n90 VSS 0.0132535f
C1208 VDD.n91 VSS 0.0163913f
C1209 VDD.t63 VSS 0.00662357f
C1210 VDD.t177 VSS 0.00662357f
C1211 VDD.n92 VSS 0.0132535f
C1212 VDD.n93 VSS 0.0269941f
C1213 VDD.n94 VSS 0.0480098f
C1214 VDD.n95 VSS 0.0537667f
C1215 VDD.n96 VSS 2.23668f
C1216 VDD.n97 VSS 0.0163976f
C1217 VDD.t103 VSS 0.0250139f
C1218 VDD.n98 VSS 0.0233691f
C1219 VDD.t101 VSS 0.016037f
C1220 VDD.n99 VSS 0.0617504f
C1221 VDD.n100 VSS 0.383826f
C1222 VDD.t102 VSS 0.335202f
C1223 VDD.t66 VSS 0.108862f
C1224 VDD.n101 VSS 0.0725746f
C1225 VDD.t192 VSS 0.108862f
C1226 VDD.t105 VSS 0.335202f
C1227 VDD.n102 VSS 0.383826f
C1228 VDD.n103 VSS 0.0170998f
C1229 VDD.n104 VSS 0.0153285f
C1230 VDD.n105 VSS 0.106388f
C1231 VDD.n106 VSS 0.103301f
C1232 VDD.n107 VSS 0.0151197f
C1233 VDD.t91 VSS 0.0164545f
C1234 VDD.t89 VSS 0.0190673f
C1235 VDD.n108 VSS 0.0497685f
C1236 VDD.n109 VSS 0.0211296f
C1237 VDD.n110 VSS 0.061839f
C1238 VDD.t90 VSS 0.31387f
C1239 VDD.t190 VSS 0.159073f
C1240 VDD.n111 VSS 0.061839f
C1241 VDD.n112 VSS 0.0226732f
C1242 VDD.n113 VSS 0.431981f
C1243 VDD.n114 VSS 0.314439f
C1244 VDD.n115 VSS 0.0579863f
C1245 VDD.n116 VSS 0.410035f
C1246 VDD.n117 VSS 0.410035f
C1247 VDD.t72 VSS 0.302173f
C1248 VDD.t150 VSS 0.143479f
C1249 VDD.t48 VSS 0.143479f
C1250 VDD.t46 VSS 0.143479f
C1251 VDD.t180 VSS 0.143479f
C1252 VDD.t178 VSS 0.143479f
C1253 VDD.t156 VSS 0.143479f
C1254 VDD.t158 VSS 0.143479f
C1255 VDD.t152 VSS 0.143479f
C1256 VDD.t50 VSS 0.107609f
C1257 VDD.t71 VSS 0.014854f
C1258 VDD.n118 VSS 0.0938498f
C1259 VDD.t92 VSS 0.014854f
C1260 VDD.n119 VSS 0.0480098f
C1261 VDD.t94 VSS 0.0159168f
C1262 VDD.t73 VSS 0.0159168f
C1263 VDD.t151 VSS 0.00662357f
C1264 VDD.t49 VSS 0.00662357f
C1265 VDD.n120 VSS 0.0132535f
C1266 VDD.n121 VSS 0.0269941f
C1267 VDD.t47 VSS 0.00662357f
C1268 VDD.t181 VSS 0.00662357f
C1269 VDD.n122 VSS 0.0132535f
C1270 VDD.n123 VSS 0.0163913f
C1271 VDD.t179 VSS 0.00662357f
C1272 VDD.t157 VSS 0.00662357f
C1273 VDD.n124 VSS 0.0132535f
C1274 VDD.n125 VSS 0.0163913f
C1275 VDD.t159 VSS 0.00662357f
C1276 VDD.t153 VSS 0.00662357f
C1277 VDD.n126 VSS 0.0132535f
C1278 VDD.n127 VSS 0.0163913f
C1279 VDD.t51 VSS 0.00662357f
C1280 VDD.t53 VSS 0.00662357f
C1281 VDD.n128 VSS 0.0132535f
C1282 VDD.t55 VSS 0.00662357f
C1283 VDD.t161 VSS 0.00662357f
C1284 VDD.n129 VSS 0.0132535f
C1285 VDD.n130 VSS 0.0163913f
C1286 VDD.t163 VSS 0.00662357f
C1287 VDD.t132 VSS 0.00662357f
C1288 VDD.n131 VSS 0.0132535f
C1289 VDD.n132 VSS 0.0163913f
C1290 VDD.t130 VSS 0.00662357f
C1291 VDD.t61 VSS 0.00662357f
C1292 VDD.n133 VSS 0.0132535f
C1293 VDD.n134 VSS 0.0163913f
C1294 VDD.t59 VSS 0.00662357f
C1295 VDD.t165 VSS 0.00662357f
C1296 VDD.n135 VSS 0.0132535f
C1297 VDD.n136 VSS 0.0269941f
C1298 VDD.n137 VSS 0.13151f
C1299 VDD.t93 VSS 0.302173f
C1300 VDD.t164 VSS 0.143479f
C1301 VDD.t58 VSS 0.143479f
C1302 VDD.t60 VSS 0.143479f
C1303 VDD.t129 VSS 0.143479f
C1304 VDD.t131 VSS 0.143479f
C1305 VDD.t162 VSS 0.143479f
C1306 VDD.t160 VSS 0.143479f
C1307 VDD.t54 VSS 0.143479f
C1308 VDD.t52 VSS 0.107609f
C1309 VDD.n138 VSS 0.0717396f
C1310 VDD.n139 VSS 0.13151f
C1311 VDD.n140 VSS 0.0670075f
C1312 VDD.n141 VSS 0.465105f
C1313 VDD.t115 VSS 0.0312073f
C1314 VDD.n142 VSS 0.139196f
C1315 VDD.t118 VSS 0.0312073f
C1316 VDD.n143 VSS 0.0347564f
C1317 VDD.t116 VSS 0.0199846f
C1318 VDD.n144 VSS 0.0649388f
C1319 VDD.n145 VSS 0.0707274f
C1320 VDD.t113 VSS 0.0199846f
C1321 VDD.n146 VSS 0.0648756f
C1322 VDD.n147 VSS 0.0707274f
C1323 VDD.n148 VSS 0.420505f
C1324 VDD.t114 VSS 0.370477f
C1325 VDD.t125 VSS 0.120331f
C1326 VDD.n149 VSS 0.080223f
C1327 VDD.t68 VSS 0.120331f
C1328 VDD.t117 VSS 0.370477f
C1329 VDD.n150 VSS 0.420505f
C1330 VDD.n151 VSS 0.0308974f
C1331 VDD.n152 VSS 0.0153664f
C1332 VDD.t69 VSS 0.0124247f
C1333 VDD.t126 VSS 0.0124247f
C1334 VDD.n153 VSS 0.0262982f
C1335 VDD.n154 VSS 0.0250582f
C1336 VDD.n155 VSS 0.0163976f
C1337 VDD.n156 VSS 0.292392f
C1338 VDD.n157 VSS 0.145295f
C1339 VDD.n158 VSS 0.0227934f
C1340 VDD.n159 VSS 0.0497685f
C1341 VDD.n160 VSS 0.342876f
C1342 VDD.t96 VSS 0.31387f
C1343 VDD.t188 VSS 0.159073f
C1344 VDD.t99 VSS 0.31387f
C1345 VDD.n161 VSS 0.342876f
C1346 VDD.n162 VSS 0.0375146f
C1347 VDD.t189 VSS 0.00662357f
C1348 VDD.n163 VSS 0.0137026f
C1349 VDD.t100 VSS 0.0230781f
C1350 VDD.n164 VSS 0.0131333f
C1351 VDD.n165 VSS 0.437763f
C1352 VDD.n166 VSS 0.449612f
C1353 VDD.n167 VSS 0.0157966f
C1354 VDD.t121 VSS 0.042778f
C1355 VDD.n168 VSS 0.0278861f
C1356 VDD.n169 VSS 0.0737639f
C1357 VDD.n170 VSS 0.083791f
C1358 VDD.t120 VSS 0.429324f
C1359 VDD.t186 VSS 0.185922f
C1360 VDD.t184 VSS 0.139443f
C1361 VDD.n171 VSS 0.0929641f
C1362 VDD.n172 VSS 0.083791f
C1363 VDD.n173 VSS 0.0413673f
C1364 VDD.n174 VSS 2.02057f
C1365 VDD.n175 VSS 0.94192f
C1366 VDD.n177 VSS 0.0764463f
C1367 VDD.n178 VSS 0.010704f
C1368 VDD.n179 VSS 0.208703f
C1369 VDD.n180 VSS 1.32812f
C1370 VDD.n181 VSS 0.0623261f
C1371 VDD.n182 VSS 0.0460171f
C1372 VDD.n183 VSS 0.0478264f
C1373 VDD.n184 VSS 0.502215f
C1374 VDD.n185 VSS 0.502215f
C1375 VDD.n186 VSS 0.0474784f
C1376 VDD.n187 VSS 0.0720053f
C1377 VDD.t154 VSS 0.755884f
C1378 VDD.n190 VSS 0.0720053f
C1379 VDD.n191 VSS 0.025248f
C1380 VDD.n192 VSS 0.0526343f
C1381 VDD.n193 VSS 1.19183f
C1382 VDD.n194 VSS 1.1653f
C1383 VDD.t82 VSS 0.0428033f
C1384 VDD.n195 VSS 0.0336935f
C1385 VDD.n196 VSS 0.0208829f
C1386 VDD.t43 VSS 0.0165621f
C1387 VDD.t41 VSS 0.0165621f
C1388 VDD.n197 VSS 0.0354775f
C1389 VDD.n198 VSS 0.0249507f
C1390 VDD.t39 VSS 0.0165621f
C1391 VDD.t37 VSS 0.0165621f
C1392 VDD.n199 VSS 0.0354775f
C1393 VDD.n200 VSS 0.0249507f
C1394 VDD.t35 VSS 0.0165621f
C1395 VDD.t33 VSS 0.0165621f
C1396 VDD.n201 VSS 0.0354775f
C1397 VDD.n202 VSS 0.0249507f
C1398 VDD.t31 VSS 0.0165621f
C1399 VDD.t29 VSS 0.0165621f
C1400 VDD.n203 VSS 0.0354775f
C1401 VDD.n204 VSS 0.0249507f
C1402 VDD.t27 VSS 0.0165621f
C1403 VDD.t25 VSS 0.0165621f
C1404 VDD.n205 VSS 0.0354775f
C1405 VDD.n206 VSS 0.0249507f
C1406 VDD.t23 VSS 0.0165621f
C1407 VDD.t21 VSS 0.0165621f
C1408 VDD.n207 VSS 0.0354775f
C1409 VDD.t19 VSS 0.0165621f
C1410 VDD.t17 VSS 0.0165621f
C1411 VDD.n208 VSS 0.0354775f
C1412 VDD.n209 VSS 0.0249507f
C1413 VDD.t15 VSS 0.0165621f
C1414 VDD.t13 VSS 0.0165621f
C1415 VDD.n210 VSS 0.0354775f
C1416 VDD.n211 VSS 0.0249507f
C1417 VDD.t11 VSS 0.0165621f
C1418 VDD.t9 VSS 0.0165621f
C1419 VDD.n212 VSS 0.0354775f
C1420 VDD.n213 VSS 0.0249507f
C1421 VDD.t7 VSS 0.0165621f
C1422 VDD.t5 VSS 0.0165621f
C1423 VDD.n214 VSS 0.0354775f
C1424 VDD.n215 VSS 0.0249507f
C1425 VDD.t3 VSS 0.0165621f
C1426 VDD.t1 VSS 0.0165621f
C1427 VDD.n216 VSS 0.0354775f
C1428 VDD.n217 VSS 0.0249507f
C1429 VDD.n218 VSS 0.233666f
C1430 VDD.n219 VSS 0.025248f
C1431 VDD.n220 VSS 0.0474784f
C1432 VDD.n221 VSS 0.0720053f
C1433 VDD.t44 VSS 0.755884f
C1434 VDD.n222 VSS 0.0478264f
C1435 VDD.n224 VSS 0.502215f
C1436 VDD.n225 VSS 0.0720053f
C1437 VDD.n227 VSS 0.502215f
C1438 VDD.n228 VSS 0.0460171f
C1439 VDD.n229 VSS 0.0571765f
C1440 VDD.t70 VSS 0.54281f
C1441 VDD.n231 VSS 0.372679f
C1442 VDD.n232 VSS 0.0571765f
C1443 VDD.n234 VSS 0.372679f
C1444 VDD.n235 VSS 0.296739f
C1445 VDD.n236 VSS 0.0623261f
C1446 VDD.n237 VSS 0.0526343f
C1447 VDD.n238 VSS 1.19183f
C1448 VDD.n239 VSS 1.1653f
C1449 VDD.n240 VSS 0.0208829f
C1450 VDD.n241 VSS 0.0278861f
C1451 VDD.n242 VSS 0.172757f
C1452 VDD.n243 VSS 0.228149f
C1453 VDD.n244 VSS 0.176629f
C1454 VDD.n245 VSS 0.228149f
C1455 VDD.n246 VSS 0.173883f
C1456 INP.t0 VSS 0.165716f
C1457 VBP.t21 VSS 0.0574109f
C1458 VBP.t20 VSS 0.0574109f
C1459 VBP.t19 VSS 0.0574109f
C1460 VBP.t18 VSS 0.0574109f
C1461 VBP.t17 VSS 0.0574109f
C1462 VBP.t16 VSS 0.0574109f
C1463 VBP.t15 VSS 0.0574109f
C1464 VBP.t14 VSS 0.0574109f
C1465 VBP.t13 VSS 0.0574109f
C1466 VBP.t12 VSS 0.0574109f
C1467 VBP.t11 VSS 0.0574109f
C1468 VBP.t10 VSS 0.0574109f
C1469 VBP.t9 VSS 0.0574109f
C1470 VBP.t8 VSS 0.0574109f
C1471 VBP.t7 VSS 0.0574109f
C1472 VBP.t6 VSS 0.0574109f
C1473 VBP.t5 VSS 0.0574109f
C1474 VBP.t4 VSS 0.0574109f
C1475 VBP.t3 VSS 0.0574109f
C1476 VBP.t2 VSS 0.0574109f
C1477 VBP.t1 VSS 0.0574109f
C1478 VBP.t0 VSS 0.0580798f
C1479 VBP.n0 VSS 0.0579284f
C1480 VBP.n1 VSS 0.0304499f
C1481 VBP.n2 VSS 0.0304499f
C1482 VBP.n3 VSS 0.0304499f
C1483 VBP.n4 VSS 0.0304499f
C1484 VBP.n5 VSS 0.0304499f
C1485 VBP.n6 VSS 0.0304499f
C1486 VBP.n7 VSS 0.0304499f
C1487 VBP.n8 VSS 0.0304499f
C1488 VBP.n9 VSS 0.0304499f
C1489 VBP.n10 VSS 0.0298426f
C1490 VBP.n11 VSS 0.0283429f
C1491 VBP.n12 VSS 0.0304499f
C1492 VBP.n13 VSS 0.0304499f
C1493 VBP.n14 VSS 0.0304499f
C1494 VBP.n15 VSS 0.0304499f
C1495 VBP.n16 VSS 0.0304499f
C1496 VBP.n17 VSS 0.0304499f
C1497 VBP.n18 VSS 0.0304499f
C1498 VBP.n19 VSS 0.0304499f
C1499 VBP.n20 VSS 0.0429033f
C1500 VBP.n21 VSS 0.155005f
C1501 INN.t0 VSS 0.157965f
C1502 VREF.t20 VSS 0.0630636f
C1503 VREF.t21 VSS 0.0630636f
C1504 VREF.t22 VSS 0.0630636f
C1505 VREF.t23 VSS 0.0630636f
C1506 VREF.t24 VSS 0.0630636f
C1507 VREF.t25 VSS 0.0630636f
C1508 VREF.t26 VSS 0.0630636f
C1509 VREF.t27 VSS 0.0630636f
C1510 VREF.t28 VSS 0.0630636f
C1511 VREF.t29 VSS 0.0630636f
C1512 VREF.t30 VSS 0.0630636f
C1513 VREF.t31 VSS 0.0630636f
C1514 VREF.t32 VSS 0.0630636f
C1515 VREF.t33 VSS 0.0630636f
C1516 VREF.t34 VSS 0.0630636f
C1517 VREF.t35 VSS 0.0630636f
C1518 VREF.t36 VSS 0.0630636f
C1519 VREF.t37 VSS 0.0630636f
C1520 VREF.t38 VSS 0.0630636f
C1521 VREF.t39 VSS 0.0630636f
C1522 VREF.t40 VSS 0.0630636f
C1523 VREF.t41 VSS 0.0630636f
C1524 VREF.t42 VSS 0.0630636f
C1525 VREF.t43 VSS 0.0632961f
C1526 VREF.n0 VSS 0.0777308f
C1527 VREF.n1 VSS 0.0407711f
C1528 VREF.n2 VSS 0.0407711f
C1529 VREF.n3 VSS 0.0407711f
C1530 VREF.n4 VSS 0.0407711f
C1531 VREF.n5 VSS 0.0407711f
C1532 VREF.n6 VSS 0.0407711f
C1533 VREF.n7 VSS 0.0407711f
C1534 VREF.n8 VSS 0.0407711f
C1535 VREF.n9 VSS 0.0407711f
C1536 VREF.n10 VSS 0.0407711f
C1537 VREF.n11 VSS 0.0389574f
C1538 VREF.n12 VSS 0.0378169f
C1539 VREF.n13 VSS 0.0407711f
C1540 VREF.n14 VSS 0.0407711f
C1541 VREF.n15 VSS 0.0407711f
C1542 VREF.n16 VSS 0.0407711f
C1543 VREF.n17 VSS 0.0407711f
C1544 VREF.n18 VSS 0.0407711f
C1545 VREF.n19 VSS 0.0407711f
C1546 VREF.n20 VSS 0.0407711f
C1547 VREF.n21 VSS 0.0407711f
C1548 VREF.n22 VSS 0.0637005f
C1549 VREF.t0 VSS 0.0789948f
C1550 VREF.t1 VSS 0.0789948f
C1551 VREF.t2 VSS 0.0789948f
C1552 VREF.t3 VSS 0.0789948f
C1553 VREF.t4 VSS 0.0789948f
C1554 VREF.t5 VSS 0.0789948f
C1555 VREF.t6 VSS 0.0789948f
C1556 VREF.t7 VSS 0.0793604f
C1557 VREF.n23 VSS 0.0903735f
C1558 VREF.n24 VSS 0.0474158f
C1559 VREF.n25 VSS 0.0474158f
C1560 VREF.n26 VSS 0.0441516f
C1561 VREF.n27 VSS 0.0453962f
C1562 VREF.n28 VSS 0.0474158f
C1563 VREF.n29 VSS 0.0674127f
C1564 VREF.n30 VSS 0.233117f
C1565 VREF.t63 VSS 0.0630636f
C1566 VREF.t62 VSS 0.0630636f
C1567 VREF.t61 VSS 0.0630636f
C1568 VREF.t60 VSS 0.0630636f
C1569 VREF.t59 VSS 0.0630636f
C1570 VREF.t58 VSS 0.0630636f
C1571 VREF.t57 VSS 0.0630636f
C1572 VREF.t56 VSS 0.0630636f
C1573 VREF.t55 VSS 0.0630636f
C1574 VREF.t54 VSS 0.0630636f
C1575 VREF.t53 VSS 0.0630636f
C1576 VREF.t52 VSS 0.0630636f
C1577 VREF.t51 VSS 0.0630636f
C1578 VREF.t50 VSS 0.0630636f
C1579 VREF.t49 VSS 0.0630636f
C1580 VREF.t48 VSS 0.0630636f
C1581 VREF.t47 VSS 0.0630636f
C1582 VREF.t46 VSS 0.0630636f
C1583 VREF.t45 VSS 0.0630636f
C1584 VREF.t44 VSS 0.0632961f
C1585 VREF.n31 VSS 0.0777308f
C1586 VREF.n32 VSS 0.0407711f
C1587 VREF.n33 VSS 0.0407711f
C1588 VREF.n34 VSS 0.0407711f
C1589 VREF.n35 VSS 0.0407711f
C1590 VREF.n36 VSS 0.0407711f
C1591 VREF.n37 VSS 0.0407711f
C1592 VREF.n38 VSS 0.0407711f
C1593 VREF.n39 VSS 0.0407711f
C1594 VREF.n40 VSS 0.0389308f
C1595 VREF.n41 VSS 0.0378411f
C1596 VREF.n42 VSS 0.0407711f
C1597 VREF.n43 VSS 0.0407711f
C1598 VREF.n44 VSS 0.0407711f
C1599 VREF.n45 VSS 0.0407711f
C1600 VREF.n46 VSS 0.0407711f
C1601 VREF.n47 VSS 0.0407711f
C1602 VREF.n48 VSS 0.0407711f
C1603 VREF.n49 VSS 0.0637005f
C1604 VREF.n50 VSS 0.301845f
C1605 VREF.t19 VSS 0.0789948f
C1606 VREF.t18 VSS 0.0789948f
C1607 VREF.t17 VSS 0.0789948f
C1608 VREF.t16 VSS 0.0789948f
C1609 VREF.t15 VSS 0.0789948f
C1610 VREF.t14 VSS 0.0789948f
C1611 VREF.t13 VSS 0.0789948f
C1612 VREF.t12 VSS 0.0789948f
C1613 VREF.t11 VSS 0.0789948f
C1614 VREF.t10 VSS 0.0789948f
C1615 VREF.t9 VSS 0.0789948f
C1616 VREF.t8 VSS 0.0793604f
C1617 VREF.n51 VSS 0.0903735f
C1618 VREF.n52 VSS 0.0474158f
C1619 VREF.n53 VSS 0.0474158f
C1620 VREF.n54 VSS 0.0474158f
C1621 VREF.n55 VSS 0.0474158f
C1622 VREF.n56 VSS 0.0441516f
C1623 VREF.n57 VSS 0.0453962f
C1624 VREF.n58 VSS 0.0474158f
C1625 VREF.n59 VSS 0.0474158f
C1626 VREF.n60 VSS 0.0474158f
C1627 VREF.n61 VSS 0.0674127f
C1628 VREF.n62 VSS 0.324474f
C1629 VB2.t0 VSS 0.128962f
C1630 VB2.t1 VSS 0.128962f
C1631 VB2.t2 VSS 0.128962f
C1632 VB2.t3 VSS 0.128962f
C1633 VB2.t4 VSS 0.128962f
C1634 VB2.t5 VSS 0.128962f
C1635 VB2.t6 VSS 0.129591f
C1636 VB2.n0 VSS 0.150791f
C1637 VB2.n1 VSS 0.0792257f
C1638 VB2.n2 VSS 0.0792257f
C1639 VB2.n3 VSS 0.073574f
C1640 VB2.n4 VSS 0.0758021f
C1641 VB2.n5 VSS 0.129634f
C1642 VB2.t13 VSS 0.128962f
C1643 VB2.t12 VSS 0.128962f
C1644 VB2.t11 VSS 0.128962f
C1645 VB2.t10 VSS 0.128962f
C1646 VB2.t9 VSS 0.128962f
C1647 VB2.t8 VSS 0.128962f
C1648 VB2.t7 VSS 0.129591f
C1649 VB2.n6 VSS 0.150791f
C1650 VB2.n7 VSS 0.0792257f
C1651 VB2.n8 VSS 0.0792257f
C1652 VB2.n9 VSS 0.073574f
C1653 VB2.n10 VSS 0.0758021f
C1654 VB2.n11 VSS 0.129634f
C1655 VB2.n12 VSS 0.773408f
C1656 VBN.t0 VSS 0.0637969f
C1657 VBN.t1 VSS 0.0637969f
C1658 VBN.t2 VSS 0.0637969f
C1659 VBN.t3 VSS 0.0637969f
C1660 VBN.t4 VSS 0.0637969f
C1661 VBN.t5 VSS 0.0653697f
C1662 VBN.n0 VSS 0.0879f
C1663 VBN.n1 VSS 0.0473507f
C1664 VBN.n2 VSS 0.0453457f
C1665 VBN.n3 VSS 0.0432024f
C1666 VBN.n4 VSS 0.0734502f
C1667 VBN.t17 VSS 0.0637969f
C1668 VBN.t18 VSS 0.0637969f
C1669 VBN.t21 VSS 0.0637969f
C1670 VBN.t22 VSS 0.0637969f
C1671 VBN.t25 VSS 0.0637969f
C1672 VBN.t26 VSS 0.0637969f
C1673 VBN.t29 VSS 0.0637969f
C1674 VBN.t30 VSS 0.0637969f
C1675 VBN.t33 VSS 0.0637969f
C1676 VBN.t34 VSS 0.0637969f
C1677 VBN.t37 VSS 0.0637969f
C1678 VBN.t38 VSS 0.0653697f
C1679 VBN.n5 VSS 0.100198f
C1680 VBN.n6 VSS 0.0596399f
C1681 VBN.n7 VSS 0.0596399f
C1682 VBN.n8 VSS 0.0596399f
C1683 VBN.n9 VSS 0.0596399f
C1684 VBN.n10 VSS 0.054567f
C1685 VBN.n11 VSS 0.0585683f
C1686 VBN.n12 VSS 0.0596399f
C1687 VBN.n13 VSS 0.0596399f
C1688 VBN.n14 VSS 0.0596399f
C1689 VBN.n15 VSS 0.083648f
C1690 VBN.n16 VSS 0.178142f
C1691 VBN.t15 VSS 0.0637969f
C1692 VBN.t14 VSS 0.0637969f
C1693 VBN.t13 VSS 0.0637969f
C1694 VBN.t12 VSS 0.0637969f
C1695 VBN.t11 VSS 0.0637969f
C1696 VBN.t10 VSS 0.0637969f
C1697 VBN.t9 VSS 0.0637969f
C1698 VBN.t8 VSS 0.0637969f
C1699 VBN.t7 VSS 0.0637969f
C1700 VBN.t6 VSS 0.0653697f
C1701 VBN.n17 VSS 0.0879f
C1702 VBN.n18 VSS 0.0473507f
C1703 VBN.n19 VSS 0.0473507f
C1704 VBN.n20 VSS 0.0473507f
C1705 VBN.n21 VSS 0.0453284f
C1706 VBN.n22 VSS 0.0432197f
C1707 VBN.n23 VSS 0.0473507f
C1708 VBN.n24 VSS 0.0473507f
C1709 VBN.n25 VSS 0.0734502f
C1710 VBN.n26 VSS 0.23003f
C1711 VBN.t39 VSS 0.0637969f
C1712 VBN.t36 VSS 0.0637969f
C1713 VBN.t35 VSS 0.0637969f
C1714 VBN.t32 VSS 0.0637969f
C1715 VBN.t31 VSS 0.0637969f
C1716 VBN.t28 VSS 0.0637969f
C1717 VBN.t27 VSS 0.0637969f
C1718 VBN.t24 VSS 0.0637969f
C1719 VBN.t23 VSS 0.0637969f
C1720 VBN.t20 VSS 0.0637969f
C1721 VBN.t19 VSS 0.0637969f
C1722 VBN.t16 VSS 0.0694748f
C1723 VBN.n27 VSS 0.108391f
C1724 VBN.n28 VSS 0.0596399f
C1725 VBN.n29 VSS 0.0596399f
C1726 VBN.n30 VSS 0.0596399f
C1727 VBN.n31 VSS 0.0596399f
C1728 VBN.n32 VSS 0.0453457f
C1729 VBN.n33 VSS 0.0555003f
C1730 VBN.n34 VSS 0.0596399f
C1731 VBN.n35 VSS 0.0596399f
C1732 VBN.n36 VSS 0.0596399f
C1733 VBN.n37 VSS 0.0857394f
C1734 VBN.n38 VSS 0.267451f
C1735 EN.t2 VSS 0.0877272f
C1736 EN.t1 VSS 0.0496194f
C1737 EN.n0 VSS 0.762418f
C1738 EN.t3 VSS 0.0877272f
C1739 EN.n1 VSS 0.251107f
C1740 EN.t0 VSS 0.0745025f
C1741 EN.n2 VSS 0.482197f
C1742 OUT.t8 VSS 0.0409531f
C1743 OUT.t6 VSS 0.0409531f
C1744 OUT.n0 VSS 0.0859333f
C1745 OUT.t2 VSS 0.0409531f
C1746 OUT.t7 VSS 0.0409531f
C1747 OUT.n1 VSS 0.0859333f
C1748 OUT.n2 VSS 0.0444057f
C1749 OUT.t0 VSS 0.0511927f
C1750 OUT.t1 VSS 0.0511927f
C1751 OUT.n3 VSS 0.109527f
C1752 OUT.t3 VSS 0.0511927f
C1753 OUT.t4 VSS 0.0511927f
C1754 OUT.n4 VSS 0.109527f
C1755 OUT.t5 VSS 0.0511927f
C1756 OUT.t9 VSS 0.0511927f
C1757 OUT.n5 VSS 0.109527f
C1758 OUT.n6 VSS 0.0609974f
C1759 OUT.n7 VSS 0.146979f
Crep0 fb.0.n0 tp.0.n0 25.7437f
Crep1 VBP tp.0.n0 3.37779f
Crep2 gp.0.n0 tp.0.n0 12.8757f
Crep3 VDD tp.0.n0 11.3411f
Crep4 VREF tp.0.n0 14.925f
Crep5 gn.0.n0 tp.0.n0 13.4594f
Crep6 VB2 tp.0.n0 0.05309f
Crep7 fa.0.n0 tp.0.n0 25.3704f
.ends lvds_lane
