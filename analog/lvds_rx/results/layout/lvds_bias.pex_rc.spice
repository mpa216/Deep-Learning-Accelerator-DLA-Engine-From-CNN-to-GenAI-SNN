* lvds_bias: parasitic R (extresist, tolerance 10) on all nets; C from the C-coupled extraction (check.rc_repair, T11: Magic 8.3.636 extresist counts every coupling twice)
* GENERATED by layout/macro/run_macro.py (T10) from a GDS with sha256 f987143e7df435a94103da28642f30e302a3f65e7be0a58e1566a452c4ca446f -- do not edit by hand.
* Ports in the order of subckt lvds_bias of netlist/lvds_rx_lvs_ref.spice (Magic's own order was: EN VBN VB2 VREF VBP VDD VSS).
* NGSPICE file created from lvds_bias.ext - technology: gf180mcuD

.subckt lvds_bias VDD VSS EN VBN VBP VB2 VREF
X0 VBP.t5 VDD.t61 VDD.t63 VDD.t62 pfet_03v3 ad=0.52p pd=2.52u as=0.88p ps=4.88u w=2u l=0.5u
X1 nrb.0.t1 enb.0.t5 VDD.t3 VDD.t2 pfet_03v3 ad=1.3p pd=5.52u as=1.3p ps=5.52u w=5u l=0.5u
X2 VSS.t61 VSS.t59 VBP.t30 VSS.t60 nfet_03v3 ad=1.1p pd=5.88u as=0.65p ps=3.02u w=2.5u l=1u
X3 VBP.t15 VBP.t14 VDD.t15 VDD.t14 pfet_03v3 ad=1.3p pd=5.52u as=1.3p ps=5.52u w=5u l=1u
X4 VBP.t17 VBP.t16 VDD.t35 VDD.t34 pfet_03v3 ad=1.3p pd=5.52u as=1.3p ps=5.52u w=5u l=1u
X5 VREF.t0 rdb_m1.0.t1 VSS.t62 ppolyf_u_1k r_width=2u r_length=19.26u
X6 VB2.t3 VBP.t34 VDD.t21 VDD.t20 pfet_03v3 ad=1.3p pd=5.52u as=1.3p ps=5.52u w=5u l=1u
X7 VSS.t81 enb.0.t11 VB2.t7 VSS.t65 nfet_03v3 ad=0.52p pd=2.52u as=0.52p ps=2.52u w=2u l=0.5u
X8 nmid.0.t4 EN.t3 VSS.t67 VSS.t42 nfet_03v3 ad=1.3p pd=5.52u as=1.3p ps=5.52u w=5u l=0.5u
X9 VSS.t31 VSS.t32 VSS.t30 ppolyf_u_1k r_width=2u r_length=21.01u
X10 VBN.t3 VBN.t2 VSS.t12 VSS.t11 nfet_03v3 ad=0.65p pd=3.02u as=0.65p ps=3.02u w=2.5u l=1u
X11 VDD.t19 VBP.t22 VBP.t23 VDD.t18 pfet_03v3 ad=1.3p pd=5.52u as=1.3p ps=5.52u w=5u l=1u
X12 nrb.0.t3 enb.0.t9 VDD.t11 VDD.t10 pfet_03v3 ad=1.3p pd=5.52u as=1.3p ps=5.52u w=5u l=0.5u
X13 VSS.t24 VBN.t15 VBP.t3 VSS.t23 nfet_03v3 ad=0.65p pd=3.02u as=0.65p ps=3.02u w=2.5u l=1u
X14 VDD.t42 rdt_m1.0.t1 VSS.t75 ppolyf_u_1k r_width=2u r_length=21.01u
X15 VREF.t1 rdt_m3.0.t1 VSS.t80 ppolyf_u_1k r_width=2u r_length=21.01u
X16 nrb.0.t7 VDD.t67 VDD.t69 VDD.t68 pfet_03v3 ad=1.3p pd=5.52u as=2.2p ps=10.88u w=5u l=0.5u
X17 VSS.t69 EN.t0 enb.0.t0 VSS.t68 nfet_03v3 ad=0.44p pd=2.88u as=0.44p ps=2.88u w=1u l=0.28u
X18 VSS.t26 VBN.t8 VBN.t9 VSS.t25 nfet_03v3 ad=0.65p pd=3.02u as=0.65p ps=3.02u w=2.5u l=1u
X19 VDD.t66 VDD.t64 VDD.t66 VDD.t65 pfet_03v3 ad=0.52p pd=2.52u as=0 ps=0 w=2u l=0.5u
X20 nrb.0.t4 enb.0.t3 VDD.t44 VDD.t43 pfet_03v3 ad=1.3p pd=5.52u as=1.3p ps=5.52u w=5u l=0.5u
X21 VSS.t5 VSS.t6 VSS.t4 ppolyf_u_1k r_width=2u r_length=23.07u
X22 VSS.t77 VSS.t78 VSS.t76 ppolyf_u_1k r_width=2u r_length=21.01u
X23 vf.0.t2 VB2.t5 VB2.t6 VSS.t79 nfet_03v3 ad=2.0566p pd=8.43u as=2.0566p ps=8.43u w=7.91u l=0.5u
X24 VSS.t43 VSS.t41 VSS.t43 VSS.t42 nfet_03v3 ad=0.52p pd=2.52u as=0 ps=0 w=2u l=0.5u
X25 nmid.0.t0 rdb_m3.0.t0 VSS.t8 ppolyf_u_1k r_width=2u r_length=19.26u
X26 rf_m1.0.t1 VSS.t3 VSS.t2 ppolyf_u_1k r_width=2u r_length=23.07u
X27 VDD.t27 VBP.t10 VBP.t11 VDD.t26 pfet_03v3 ad=1.3p pd=5.52u as=1.3p ps=5.52u w=5u l=1u
X28 VBP.t6 VDD.t49 VDD.t51 VDD.t50 pfet_03v3 ad=1.3p pd=5.52u as=2.2p ps=10.88u w=5u l=1u
X29 VB2.t1 VBP.t32 VDD.t37 VDD.t36 pfet_03v3 ad=1.3p pd=5.52u as=1.3p ps=5.52u w=5u l=1u
X30 rdb_m2.0.t1 rdb_m3.0.t1 VSS.t83 ppolyf_u_1k r_width=2u r_length=19.26u
X31 rf_m1.0.t0 vf.0.t0 VSS.t1 ppolyf_u_1k r_width=2u r_length=23.07u
X32 VSS.t64 VREF.t2 VSS.t64 VSS.t63 nfet_03v3 ad=8.8p pd=40.88u as=0 ps=0 w=20u l=25.13u
X33 nrb.0.t5 enb.0.t7 VDD.t46 VDD.t45 pfet_03v3 ad=1.3p pd=5.52u as=1.3p ps=5.52u w=5u l=0.5u
X34 VSS.t14 VBN.t4 VBN.t5 VSS.t13 nfet_03v3 ad=0.65p pd=3.02u as=0.65p ps=3.02u w=2.5u l=1u
X35 VBN.t12 VSS.t56 VSS.t58 VSS.t57 nfet_03v3 ad=0.65p pd=3.02u as=1.1p ps=5.88u w=2.5u l=1u
X36 VDD.t74 enb.0.t4 nrb.0.t10 VDD.t73 pfet_03v3 ad=1.3p pd=5.52u as=1.3p ps=5.52u w=5u l=0.5u
X37 VSS.t18 VBN.t17 VBP.t0 VSS.t17 nfet_03v3 ad=0.65p pd=3.02u as=0.65p ps=3.02u w=2.5u l=1u
X38 VBN.t13 VSS.t38 VSS.t40 VSS.t39 nfet_03v3 ad=0.52p pd=2.52u as=0.88p ps=4.88u w=2u l=0.5u
X39 rdt_m2.0.t0 rdt_m1.0.t0 VSS.t29 ppolyf_u_1k r_width=2u r_length=21.01u
X40 VDD.t1 enb.0.t6 nrb.0.t0 VDD.t0 pfet_03v3 ad=1.3p pd=5.52u as=1.3p ps=5.52u w=5u l=0.5u
X41 rb_m3.0.t0 rb_m2.0.t0 VSS.t7 ppolyf_u_1k r_width=2u r_length=22.27u
X42 VDD.t13 VBP.t12 VBP.t13 VDD.t12 pfet_03v3 ad=1.3p pd=5.52u as=1.3p ps=5.52u w=5u l=1u
X43 VDD.t60 VDD.t58 VDD.t60 VDD.t59 pfet_03v3 ad=0.65p pd=3.02u as=0 ps=0 w=2.5u l=0.28u
X44 VDD.t17 VBP.t28 VBP.t29 VDD.t16 pfet_03v3 ad=1.3p pd=5.52u as=1.3p ps=5.52u w=5u l=1u
X45 VDD.t41 VBP.t18 VBP.t19 VDD.t40 pfet_03v3 ad=1.3p pd=5.52u as=1.3p ps=5.52u w=5u l=1u
X46 VDD.t23 VBP.t33 VB2.t2 VDD.t22 pfet_03v3 ad=1.3p pd=5.52u as=1.3p ps=5.52u w=5u l=1u
X47 VSS.t66 EN.t4 nmid.0.t3 VSS.t65 nfet_03v3 ad=1.3p pd=5.52u as=1.3p ps=5.52u w=5u l=0.5u
X48 VB2.t4 VSS.t53 VSS.t55 VSS.t54 nfet_03v3 ad=2.0566p pd=8.43u as=3.4804p ps=16.7u w=7.91u l=0.5u
X49 VBP.t1 VBN.t16 VSS.t20 VSS.t19 nfet_03v3 ad=0.65p pd=3.02u as=0.65p ps=3.02u w=2.5u l=1u
X50 VBP.t25 VBP.t24 VDD.t31 VDD.t30 pfet_03v3 ad=1.3p pd=5.52u as=1.3p ps=5.52u w=5u l=1u
X51 VSS.t73 enb.0.t12 VBN.t11 VSS.t65 nfet_03v3 ad=0.52p pd=2.52u as=0.52p ps=2.52u w=2u l=0.5u
X52 rdb_m2.0.t0 rdb_m1.0.t0 VSS.t0 ppolyf_u_1k r_width=2u r_length=19.26u
X53 VDD.t48 enb.0.t10 nrb.0.t6 VDD.t47 pfet_03v3 ad=1.3p pd=5.52u as=1.3p ps=5.52u w=5u l=0.5u
X54 rb_m3.0.t1 VBN.t10 VSS.t33 ppolyf_u_1k r_width=2u r_length=22.27u
X55 VDD.t72 VDD.t70 nrb.0.t8 VDD.t71 pfet_03v3 ad=2.2p pd=10.88u as=1.3p ps=5.52u w=5u l=0.5u
X56 VSS.t10 VBN.t0 VBN.t1 VSS.t9 nfet_03v3 ad=0.65p pd=3.02u as=0.65p ps=3.02u w=2.5u l=1u
X57 VBP.t4 VBN.t14 VSS.t28 VSS.t27 nfet_03v3 ad=0.65p pd=3.02u as=0.65p ps=3.02u w=2.5u l=1u
X58 VSS.t45 VSS.t44 VSS.t45 VSS.t42 nfet_03v3 ad=0.52p pd=2.52u as=0 ps=0 w=2u l=0.5u
X59 VDD.t9 EN.t1 VBP.t7 VDD.t8 pfet_03v3 ad=0.52p pd=2.52u as=0.52p ps=2.52u w=2u l=0.5u
X60 VSS.t37 VSS.t35 vf.0.t1 VSS.t36 nfet_03v3 ad=3.4804p pd=16.7u as=2.0566p ps=8.43u w=7.91u l=0.5u
X61 VBN.t7 VBN.t6 VSS.t22 VSS.t21 nfet_03v3 ad=0.65p pd=3.02u as=0.65p ps=3.02u w=2.5u l=1u
X62 VDD.t33 VBP.t26 VBP.t27 VDD.t32 pfet_03v3 ad=1.3p pd=5.52u as=1.3p ps=5.52u w=5u l=1u
X63 VDD.t7 EN.t2 enb.0.t1 VDD.t6 pfet_03v3 ad=0.65p pd=3.02u as=0.65p ps=3.02u w=2.5u l=0.28u
X64 rb_m1.0.t0 rb_m2.0.t1 VSS.t34 ppolyf_u_1k r_width=2u r_length=22.27u
X65 VBP.t21 VBP.t20 VDD.t29 VDD.t28 pfet_03v3 ad=1.3p pd=5.52u as=1.3p ps=5.52u w=5u l=1u
X66 VDD.t54 VDD.t52 VDD.t54 VDD.t53 pfet_03v3 ad=1.3p pd=5.52u as=0 ps=0 w=5u l=1u
X67 VSS.t52 VSS.t50 nmid.0.t2 VSS.t51 nfet_03v3 ad=2.2p pd=10.88u as=1.3p ps=5.52u w=5u l=0.5u
X68 rdt_m2.0.t1 rdt_m3.0.t0 VSS.t74 ppolyf_u_1k r_width=2u r_length=21.01u
X69 VBP.t9 VBP.t8 VDD.t25 VDD.t24 pfet_03v3 ad=1.3p pd=5.52u as=1.3p ps=5.52u w=5u l=1u
X70 VDD.t39 VBP.t31 VB2.t0 VDD.t38 pfet_03v3 ad=1.3p pd=5.52u as=1.3p ps=5.52u w=5u l=1u
X71 nmid.0.t1 VSS.t48 VSS.t49 VSS.t39 nfet_03v3 ad=1.3p pd=5.52u as=2.2p ps=10.88u w=5u l=0.5u
X72 enb.0.t2 VDD.t55 VDD.t57 VDD.t56 pfet_03v3 ad=0.65p pd=3.02u as=1.1p ps=5.88u w=2.5u l=0.28u
X73 VDD.t5 enb.0.t8 nrb.0.t2 VDD.t4 pfet_03v3 ad=1.3p pd=5.52u as=1.3p ps=5.52u w=5u l=0.5u
X74 rb_m1.0.t1 nrb.0.t9 VSS.t82 ppolyf_u_1k r_width=2u r_length=22.27u
X75 VB2.t8 VSS.t46 VSS.t47 VSS.t39 nfet_03v3 ad=0.52p pd=2.52u as=0.88p ps=4.88u w=2u l=0.5u
X76 VBP.t2 VBN.t18 VSS.t16 VSS.t15 nfet_03v3 ad=0.65p pd=3.02u as=0.65p ps=3.02u w=2.5u l=1u
X77 VSS.t71 VSS.t72 VSS.t70 ppolyf_u_1k r_width=2u r_length=22.27u
R0 EN.n0 EN.t4 49.154
R1 EN.n0 EN.t3 48.7548
R2 EN EN.t2 47.57
R3 EN EN.t0 27.7973
R4 EN EN.t1 27.4653
R5 EN.n1 EN 6.95621
R6 EN.n3 EN 6.16871
R7 EN.n1 EN 5.23014
R8 EN.n2 EN 5.09514
R9 EN EN.n3 2.90621
R10 EN EN.n2 1.36014
R11 EN EN.n1 1.21871
R12 EN.n3 EN 0.656214
R13 EN EN.n0 0.352674
R14 EN.n2 EN 0.1355
R15 VREF VREF.n0 6.05621
R16 VREF VREF.t2 6.04352
R17 VREF VREF.t0 3.57
R18 VREF VREF.t1 3.57
R19 VREF.n0 VREF 3.01871
R20 VREF.n0 VREF 1.33121
R21 VBN.n1 VBN.t0 15.9196
R22 VBN.n1 VBN.t2 15.3248
R23 VBN.n2 VBN.t4 15.3248
R24 VBN.n3 VBN.t18 15.3248
R25 VBN.n4 VBN.t17 15.3248
R26 VBN.n5 VBN.t16 15.3248
R27 VBN.n6 VBN.t15 15.3248
R28 VBN.n7 VBN.t6 15.3248
R29 VBN.n8 VBN.t8 15.3248
R30 VBN.n9 VBN.t14 15.3248
R31 VBN VBN.n16 13.1051
R32 VBN VBN.n9 10.329
R33 VBN.n15 VBN 9.0005
R34 VBN.n13 VBN 9.0005
R35 VBN.n11 VBN 9.0005
R36 VBN VBN.n17 6.28121
R37 VBN.n17 VBN 5.83121
R38 VBN.n16 VBN 5.60621
R39 VBN VBN.t10 3.57
R40 VBN.n11 VBN 2.65871
R41 VBN VBN.n11 1.9355
R42 VBN VBN.n0 1.66746
R43 VBN VBN.n14 1.47767
R44 VBN VBN.n12 1.47767
R45 VBN VBN.n10 1.47767
R46 VBN.n13 VBN 0.958357
R47 VBN.n15 VBN.n13 0.939071
R48 VBN.n0 VBN.t11 0.8195
R49 VBN.n0 VBN.t13 0.8195
R50 VBN VBN.n15 0.807286
R51 VBN.n16 VBN 0.656214
R52 VBN.n14 VBN.t1 0.6557
R53 VBN.n14 VBN.t12 0.6557
R54 VBN.n12 VBN.t5 0.6557
R55 VBN.n12 VBN.t3 0.6557
R56 VBN.n10 VBN.t9 0.6557
R57 VBN.n10 VBN.t7 0.6557
R58 VBN.n9 VBN.n8 0.595283
R59 VBN.n8 VBN.n7 0.595283
R60 VBN.n7 VBN.n6 0.595283
R61 VBN.n5 VBN.n4 0.595283
R62 VBN.n4 VBN.n3 0.595283
R63 VBN.n3 VBN.n2 0.595283
R64 VBN.n2 VBN.n1 0.595283
R65 VBN.n17 VBN 0.543714
R66 VBN VBN.n5 0.39963
R67 VBN.n6 VBN 0.196152
R68 VB2 VB2.t5 70.5496
R69 VB2.n7 VB2 11.3887
R70 VB2.n2 VB2 9.0005
R71 VB2.n7 VB2 8.83014
R72 VB2.n6 VB2 5.79264
R73 VB2 VB2.n4 5.25104
R74 VB2 VB2.n2 2.65068
R75 VB2.n2 VB2 1.9355
R76 VB2 VB2.n7 1.78121
R77 VB2 VB2.n5 1.66746
R78 VB2.n4 VB2 1.59318
R79 VB2.n6 VB2 1.24121
R80 VB2.n5 VB2.t7 0.8195
R81 VB2.n5 VB2.t8 0.8195
R82 VB2 VB2.n1 0.737674
R83 VB2 VB2.n0 0.737674
R84 VB2 VB2.n3 0.463045
R85 VB2.n1 VB2.t2 0.3645
R86 VB2.n1 VB2.t3 0.3645
R87 VB2.n0 VB2.t0 0.3645
R88 VB2.n0 VB2.t1 0.3645
R89 VB2.n3 VB2.t6 0.20758
R90 VB2.n3 VB2.t4 0.20758
R91 VB2.n4 VB2 0.161214
R92 VB2 VB2.n6 0.138714
R93 VBP.n7 VBP.t12 25.0446
R94 VBP.n7 VBP.t14 24.4498
R95 VBP.n8 VBP.t28 24.4498
R96 VBP.n9 VBP.t34 24.4498
R97 VBP.n10 VBP.t33 24.4498
R98 VBP.n11 VBP.t8 24.4498
R99 VBP.n12 VBP.t10 24.4498
R100 VBP.n13 VBP.t20 24.4498
R101 VBP.n14 VBP.t22 24.4498
R102 VBP.n15 VBP.t24 24.4498
R103 VBP.n16 VBP.t26 24.4498
R104 VBP.n17 VBP.t32 24.4498
R105 VBP.n18 VBP.t31 24.4498
R106 VBP.n19 VBP.t16 24.4498
R107 VBP.n20 VBP.t18 24.4498
R108 VBP.n33 VBP 10.8937
R109 VBP VBP.n6 10.6334
R110 VBP VBP.n20 10.4503
R111 VBP.n32 VBP 9.0005
R112 VBP.n30 VBP 9.0005
R113 VBP.n28 VBP 9.0005
R114 VBP.n26 VBP 9.0005
R115 VBP.n24 VBP 9.0005
R116 VBP.n22 VBP 9.0005
R117 VBP.n4 VBP 9.0005
R118 VBP.n2 VBP 9.0005
R119 VBP.n33 VBP 6.43389
R120 VBP.n6 VBP 5.44068
R121 VBP VBP.n4 2.68443
R122 VBP.n22 VBP 2.67157
R123 VBP VBP.n32 2.01104
R124 VBP.n24 VBP.n22 1.91621
R125 VBP.n30 VBP.n28 1.91621
R126 VBP VBP.n3 1.47767
R127 VBP VBP.n1 1.47767
R128 VBP VBP.n0 1.47767
R129 VBP VBP.n5 1.39246
R130 VBP.n26 VBP.n24 0.939071
R131 VBP.n32 VBP.n30 0.939071
R132 VBP.n4 VBP.n2 0.939071
R133 VBP.n5 VBP.t7 0.9105
R134 VBP.n5 VBP.t5 0.9105
R135 VBP VBP.n31 0.737674
R136 VBP VBP.n29 0.737674
R137 VBP VBP.n27 0.737674
R138 VBP VBP.n25 0.737674
R139 VBP VBP.n23 0.737674
R140 VBP VBP.n21 0.737674
R141 VBP.n3 VBP.t0 0.6557
R142 VBP.n3 VBP.t2 0.6557
R143 VBP.n1 VBP.t3 0.6557
R144 VBP.n1 VBP.t1 0.6557
R145 VBP.n0 VBP.t30 0.6557
R146 VBP.n0 VBP.t4 0.6557
R147 VBP.n20 VBP.n19 0.595283
R148 VBP.n19 VBP.n18 0.595283
R149 VBP.n18 VBP.n17 0.595283
R150 VBP.n17 VBP.n16 0.595283
R151 VBP.n16 VBP.n15 0.595283
R152 VBP.n14 VBP.n13 0.595283
R153 VBP.n13 VBP.n12 0.595283
R154 VBP.n12 VBP.n11 0.595283
R155 VBP.n11 VBP.n10 0.595283
R156 VBP.n10 VBP.n9 0.595283
R157 VBP.n9 VBP.n8 0.595283
R158 VBP.n8 VBP.n7 0.595283
R159 VBP VBP.n26 0.469786
R160 VBP.n28 VBP 0.469786
R161 VBP.n2 VBP 0.469786
R162 VBP.n15 VBP 0.430935
R163 VBP.n31 VBP.t13 0.3645
R164 VBP.n31 VBP.t6 0.3645
R165 VBP.n29 VBP.t29 0.3645
R166 VBP.n29 VBP.t15 0.3645
R167 VBP.n27 VBP.t11 0.3645
R168 VBP.n27 VBP.t9 0.3645
R169 VBP.n25 VBP.t23 0.3645
R170 VBP.n25 VBP.t21 0.3645
R171 VBP.n23 VBP.t27 0.3645
R172 VBP.n23 VBP.t25 0.3645
R173 VBP.n21 VBP.t19 0.3645
R174 VBP.n21 VBP.t17 0.3645
R175 VBP VBP.n14 0.164848
R176 VBP.n6 VBP 0.148357
R177 VBP VBP.n33 0.0937143
R178 VDD.t65 VDD.n41 490.897
R179 VDD.n42 VDD.t62 490.897
R180 VDD.n71 VDD.t59 437.187
R181 VDD.t56 VDD.n70 437.187
R182 VDD.t53 VDD.n2 356.781
R183 VDD.t50 VDD.n3 356.781
R184 VDD.n81 VDD.n3 341.075
R185 VDD.n80 VDD.n3 341.075
R186 VDD.n80 VDD.n2 341.075
R187 VDD.n81 VDD.n2 341.075
R188 VDD.n54 VDD.t71 329.368
R189 VDD.t68 VDD.n52 329.368
R190 VDD.n54 VDD.n49 204.226
R191 VDD.n54 VDD.n51 204.226
R192 VDD.n52 VDD.n49 204.226
R193 VDD.n52 VDD.n51 204.226
R194 VDD.t8 VDD.t65 166.667
R195 VDD.t62 VDD.t8 166.667
R196 VDD.t40 VDD.t53 166.667
R197 VDD.t34 VDD.t40 166.667
R198 VDD.t38 VDD.t34 166.667
R199 VDD.t36 VDD.t38 166.667
R200 VDD.t32 VDD.t36 166.667
R201 VDD.t30 VDD.t32 166.667
R202 VDD.t18 VDD.t30 166.667
R203 VDD.t28 VDD.t18 166.667
R204 VDD.t28 VDD.t26 166.667
R205 VDD.t26 VDD.t24 166.667
R206 VDD.t24 VDD.t22 166.667
R207 VDD.t22 VDD.t20 166.667
R208 VDD.t20 VDD.t16 166.667
R209 VDD.t16 VDD.t14 166.667
R210 VDD.t14 VDD.t12 166.667
R211 VDD.t12 VDD.t50 166.667
R212 VDD.t59 VDD.t6 120.847
R213 VDD.t6 VDD.t56 120.847
R214 VDD.n41 VDD.n33 115.501
R215 VDD.n41 VDD.n34 115.501
R216 VDD.n42 VDD.n33 115.501
R217 VDD.n42 VDD.n34 115.501
R218 VDD.n71 VDD.n25 114.1
R219 VDD.n71 VDD.n26 114.1
R220 VDD.n70 VDD.n25 114.1
R221 VDD.n70 VDD.n26 114.1
R222 VDD.t71 VDD.t43 111.843
R223 VDD.t43 VDD.t73 111.843
R224 VDD.t73 VDD.t2 111.843
R225 VDD.t2 VDD.t0 111.843
R226 VDD.t45 VDD.t4 111.843
R227 VDD.t4 VDD.t10 111.843
R228 VDD.t10 VDD.t47 111.843
R229 VDD.t47 VDD.t68 111.843
R230 VDD.t0 VDD.n53 55.9216
R231 VDD.n53 VDD.t45 55.9216
R232 VDD.n50 VDD.t67 49.8583
R233 VDD.n48 VDD.t70 49.8583
R234 VDD.n24 VDD.t58 48.0826
R235 VDD.n69 VDD.t55 48.0826
R236 VDD.n40 VDD.t64 27.9583
R237 VDD.n43 VDD.t61 27.9583
R238 VDD.n4 VDD.t52 25.6511
R239 VDD.n79 VDD.t49 25.6511
R240 VDD.n77 VDD.n76 20.5395
R241 VDD VDD.n64 9.61764
R242 VDD.n6 VDD 9.4505
R243 VDD VDD.n37 9.28978
R244 VDD VDD.n23 9.0005
R245 VDD.n74 VDD 9.0005
R246 VDD.n37 VDD 9.0005
R247 VDD.n35 VDD 9.0005
R248 VDD.n58 VDD 9.0005
R249 VDD.n60 VDD 9.0005
R250 VDD.n62 VDD 9.0005
R251 VDD.n64 VDD 9.0005
R252 VDD.n56 VDD 9.0005
R253 VDD.n6 VDD 9.0005
R254 VDD.n8 VDD 9.0005
R255 VDD.n10 VDD 9.0005
R256 VDD.n12 VDD 9.0005
R257 VDD.n14 VDD 9.0005
R258 VDD.n16 VDD 9.0005
R259 VDD.n18 VDD 9.0005
R260 VDD.n20 VDD 9.0005
R261 VDD VDD.n78 9.0005
R262 VDD.n76 VDD 6.28121
R263 VDD.n31 VDD.n22 6.26193
R264 VDD VDD.n77 5.49371
R265 VDD VDD.n0 5.42045
R266 VDD.n28 VDD 5.38121
R267 VDD.n75 VDD 5.18354
R268 VDD VDD.n28 4.98161
R269 VDD VDD.n67 4.93121
R270 VDD.n30 VDD 4.93121
R271 VDD.n45 VDD 4.93121
R272 VDD.n67 VDD 4.93121
R273 VDD VDD.n46 4.93121
R274 VDD.n21 VDD 4.93121
R275 VDD VDD.n0 4.93121
R276 VDD VDD.n22 4.59371
R277 VDD.n68 VDD 4.5005
R278 VDD VDD.n29 4.5005
R279 VDD VDD.n44 4.5005
R280 VDD.n39 VDD 4.5005
R281 VDD.n47 VDD 4.5005
R282 VDD VDD.n66 4.5005
R283 VDD.n82 VDD 4.5005
R284 VDD VDD.n1 4.5005
R285 VDD VDD.n83 4.5005
R286 VDD VDD.n4 4.028
R287 VDD VDD.n79 4.028
R288 VDD VDD.t42 3.57
R289 VDD.n83 VDD.n82 3.388
R290 VDD.n82 VDD.n1 3.388
R291 VDD VDD.t66 2.30246
R292 VDD VDD.t63 2.30246
R293 VDD VDD.n48 2.073
R294 VDD VDD.n50 2.073
R295 VDD VDD.t60 1.86046
R296 VDD VDD.t57 1.86046
R297 VDD.n38 VDD 1.5705
R298 VDD.n72 VDD 1.5505
R299 VDD.n83 VDD 1.4705
R300 VDD.n47 VDD 1.438
R301 VDD.n66 VDD 1.438
R302 VDD VDD.n36 1.39246
R303 VDD.n55 VDD.n47 1.3905
R304 VDD.n73 VDD 1.13246
R305 VDD VDD.n65 1.0905
R306 VDD VDD.t69 0.976457
R307 VDD VDD.t72 0.976457
R308 VDD.n78 VDD.n20 0.939071
R309 VDD.n20 VDD.n18 0.939071
R310 VDD.n18 VDD.n16 0.939071
R311 VDD.n16 VDD.n14 0.939071
R312 VDD.n12 VDD.n10 0.939071
R313 VDD.n10 VDD.n8 0.939071
R314 VDD.n8 VDD.n6 0.939071
R315 VDD.n36 VDD.t66 0.9105
R316 VDD.n36 VDD.t9 0.9105
R317 VDD.t54 VDD 0.8845
R318 VDD VDD.t51 0.8845
R319 VDD VDD.n48 0.8455
R320 VDD.n50 VDD 0.8455
R321 VDD.n79 VDD 0.8455
R322 VDD.n4 VDD 0.8455
R323 VDD VDD.n72 0.826152
R324 VDD.n27 VDD 0.826152
R325 VDD.n38 VDD 0.826152
R326 VDD VDD.n32 0.826152
R327 VDD VDD.n55 0.826152
R328 VDD.n65 VDD 0.826152
R329 VDD.n27 VDD 0.778
R330 VDD.n76 VDD 0.768714
R331 VDD VDD.n74 0.760679
R332 VDD.t60 VDD.n73 0.7285
R333 VDD.n73 VDD.t7 0.7285
R334 VDD VDD.n32 0.7155
R335 VDD VDD.n12 0.714071
R336 VDD VDD.n42 0.7005
R337 VDD.n41 VDD 0.7005
R338 VDD.n70 VDD 0.6305
R339 VDD VDD.n71 0.6305
R340 VDD.n69 VDD.n68 0.6255
R341 VDD.n29 VDD.n24 0.6255
R342 VDD.n44 VDD.n43 0.6255
R343 VDD.n40 VDD.n39 0.6255
R344 VDD.n64 VDD.n62 0.617643
R345 VDD.n60 VDD.n58 0.617643
R346 VDD.n58 VDD.n56 0.617643
R347 VDD VDD.n57 0.612457
R348 VDD VDD.n59 0.612457
R349 VDD VDD.n61 0.612457
R350 VDD VDD.n63 0.612457
R351 VDD.n39 VDD 0.5455
R352 VDD.n44 VDD 0.5455
R353 VDD.n35 VDD 0.545321
R354 VDD VDD.n69 0.533
R355 VDD VDD.n24 0.533
R356 VDD.n78 VDD 0.52925
R357 VDD VDD.n5 0.5205
R358 VDD VDD.n7 0.5205
R359 VDD VDD.n9 0.5205
R360 VDD VDD.n11 0.5205
R361 VDD VDD.n13 0.5205
R362 VDD VDD.n15 0.5205
R363 VDD VDD.n17 0.5205
R364 VDD VDD.n19 0.5205
R365 VDD.n56 VDD 0.519607
R366 VDD VDD.n35 0.473
R367 VDD.n43 VDD 0.4705
R368 VDD VDD.n40 0.4705
R369 VDD.n29 VDD 0.463
R370 VDD.n68 VDD 0.463
R371 VDD VDD.n54 0.4205
R372 VDD.n52 VDD 0.4205
R373 VDD VDD.n3 0.4205
R374 VDD.n2 VDD 0.4205
R375 VDD VDD.n26 0.39425
R376 VDD.t6 VDD.n26 0.39425
R377 VDD.n25 VDD 0.39425
R378 VDD.t6 VDD.n25 0.39425
R379 VDD VDD.n0 0.37814
R380 VDD.n57 VDD.t44 0.3645
R381 VDD.n57 VDD.t74 0.3645
R382 VDD.n59 VDD.t3 0.3645
R383 VDD.n59 VDD.t1 0.3645
R384 VDD.n61 VDD.t46 0.3645
R385 VDD.n61 VDD.t5 0.3645
R386 VDD.n63 VDD.t11 0.3645
R387 VDD.n63 VDD.t48 0.3645
R388 VDD.n5 VDD.t54 0.3645
R389 VDD.n5 VDD.t41 0.3645
R390 VDD.n7 VDD.t35 0.3645
R391 VDD.n7 VDD.t39 0.3645
R392 VDD.n9 VDD.t37 0.3645
R393 VDD.n9 VDD.t33 0.3645
R394 VDD.n11 VDD.t31 0.3645
R395 VDD.n11 VDD.t19 0.3645
R396 VDD.n13 VDD.t29 0.3645
R397 VDD.n13 VDD.t27 0.3645
R398 VDD.n15 VDD.t25 0.3645
R399 VDD.n15 VDD.t23 0.3645
R400 VDD.n17 VDD.t21 0.3645
R401 VDD.n17 VDD.t17 0.3645
R402 VDD.n19 VDD.t15 0.3645
R403 VDD.n19 VDD.t13 0.3645
R404 VDD.n75 VDD.n22 0.357286
R405 VDD.n34 VDD 0.3505
R406 VDD.t8 VDD.n34 0.3505
R407 VDD VDD.n33 0.3505
R408 VDD.t8 VDD.n33 0.3505
R409 VDD.n62 VDD 0.309071
R410 VDD VDD.n60 0.309071
R411 VDD.n66 VDD 0.2905
R412 VDD VDD.n1 0.2905
R413 VDD.n14 VDD 0.2255
R414 VDD.n74 VDD.n23 0.219071
R415 VDD.n51 VDD 0.191409
R416 VDD.n53 VDD.n51 0.191409
R417 VDD.n49 VDD 0.191409
R418 VDD.n53 VDD.n49 0.191409
R419 VDD.n37 VDD 0.145143
R420 VDD VDD.n75 0.121036
R421 VDD.n45 VDD.n31 0.1193
R422 VDD VDD.n30 0.11714
R423 VDD.n67 VDD 0.11318
R424 VDD.n21 VDD 0.1121
R425 VDD VDD.n23 0.109786
R426 VDD.n80 VDD 0.0959545
R427 VDD.t28 VDD.n80 0.0959545
R428 VDD.n82 VDD.n81 0.0959545
R429 VDD.n81 VDD.t28 0.0959545
R430 VDD.n77 VDD.n21 0.0905
R431 VDD.n46 VDD.n28 0.08834
R432 VDD VDD.n27 0.0805
R433 VDD.n72 VDD 0.0805
R434 VDD VDD.n32 0.0805
R435 VDD VDD.n38 0.0805
R436 VDD.n55 VDD 0.0805
R437 VDD.n65 VDD 0.0805
R438 VDD.n31 VDD 0.0257
R439 VDD.n30 VDD 0.02246
R440 VDD.n46 VDD.n45 0.02066
R441 VSS.n130 VSS.n59 137020
R442 VSS.n84 VSS.n15 97280.5
R443 VSS.n108 VSS.n59 37830
R444 VSS.n132 VSS.n131 14306
R445 VSS.n131 VSS.n58 10299.1
R446 VSS.n131 VSS.n130 4820.07
R447 VSS.n130 VSS.n129 2883.8
R448 VSS.t2 VSS.t4 1725.9
R449 VSS.t1 VSS.t2 1725.9
R450 VSS.t33 VSS.t1 1725.9
R451 VSS.t7 VSS.t34 1725.9
R452 VSS.t33 VSS.n108 1651.55
R453 VSS.n96 VSS.n83 615.806
R454 VSS.n96 VSS.n92 615.806
R455 VSS.n92 VSS.n85 615.806
R456 VSS.n85 VSS.n83 615.806
R457 VSS.n128 VSS.n60 566.049
R458 VSS.n160 VSS.n3 552.319
R459 VSS.n160 VSS.n2 552.319
R460 VSS.n103 VSS.n3 552.222
R461 VSS.n103 VSS.n2 552.222
R462 VSS.n158 VSS.n5 516.932
R463 VSS.n158 VSS.n6 516.932
R464 VSS.n6 VSS.n4 516.932
R465 VSS.n5 VSS.n4 516.932
R466 VSS.n66 VSS.n65 511.365
R467 VSS.n66 VSS.t54 382.103
R468 VSS.n65 VSS.t68 366.478
R469 VSS.n132 VSS.t68 366.478
R470 VSS.n95 VSS.n94 321.171
R471 VSS.n129 VSS.t36 282.671
R472 VSS.n117 VSS.n73 274.75
R473 VSS.n119 VSS.n73 274.75
R474 VSS.n119 VSS.n75 274.75
R475 VSS.n117 VSS.n75 274.75
R476 VSS.t4 VSS.n76 181.202
R477 VSS.t70 VSS.n60 181.202
R478 VSS.n67 VSS.n61 179.764
R479 VSS.n67 VSS.n62 179.764
R480 VSS.n127 VSS.n62 179.764
R481 VSS.n127 VSS.n61 179.764
R482 VSS.n105 VSS.t70 167.46
R483 VSS.n146 VSS.n19 161.389
R484 VSS.n19 VSS.n17 161.389
R485 VSS.n18 VSS.n17 161.389
R486 VSS.n146 VSS.n18 161.389
R487 VSS.n106 VSS.t82 145.18
R488 VSS.t79 VSS.t36 144.887
R489 VSS.t54 VSS.t79 144.887
R490 VSS.t76 VSS.t80 129.666
R491 VSS.t80 VSS.t62 129.666
R492 VSS.t62 VSS.t0 129.666
R493 VSS.t8 VSS.t83 129.666
R494 VSS.t75 VSS.t8 129.666
R495 VSS.t60 VSS.t27 126.344
R496 VSS.t25 VSS.t21 126.344
R497 VSS.t23 VSS.t19 126.344
R498 VSS.t9 VSS.t11 126.344
R499 VSS.n104 VSS.t17 124.266
R500 VSS.n57 VSS.n13 122.306
R501 VSS.n57 VSS.n14 122.306
R502 VSS.n149 VSS.n14 122.306
R503 VSS.n149 VSS.n13 122.306
R504 VSS.n32 VSS.n29 122.306
R505 VSS.n36 VSS.n29 122.306
R506 VSS.n36 VSS.n16 122.306
R507 VSS.n32 VSS.n16 122.306
R508 VSS.n108 VSS.t15 121.356
R509 VSS.t7 VSS.t11 119.694
R510 VSS.n58 VSS.t39 107.323
R511 VSS.t1 VSS.t21 98.0823
R512 VSS.t29 VSS.n59 96.9499
R513 VSS.n133 VSS.n27 90.6116
R514 VSS.n133 VSS.n28 90.6116
R515 VSS.n64 VSS.n28 90.6116
R516 VSS.n64 VSS.n27 90.6116
R517 VSS.t34 VSS.n106 88.4022
R518 VSS.n84 VSS.t76 86.9757
R519 VSS.n95 VSS.t30 86.9757
R520 VSS.t2 VSS.t27 80.6271
R521 VSS.n93 VSS.t75 73.0118
R522 VSS.n126 VSS.t35 70.98
R523 VSS.n68 VSS.t53 70.98
R524 VSS.n148 VSS.t51 66.6283
R525 VSS.t82 VSS.n105 66.1222
R526 VSS.n159 VSS.t0 64.8329
R527 VSS.n91 VSS.t74 64.8329
R528 VSS.n91 VSS.t29 64.8329
R529 VSS.t4 VSS.t60 63.1719
R530 VSS.n118 VSS.t19 63.1719
R531 VSS.n129 VSS.n128 58.1846
R532 VSS.n159 VSS.t63 57.851
R533 VSS.t30 VSS.n93 56.6541
R534 VSS.n118 VSS.t33 52.3662
R535 VSS.n21 VSS.t50 49.737
R536 VSS.n144 VSS.t48 49.737
R537 VSS.t2 VSS.t25 45.7166
R538 VSS.t51 VSS.t42 40.6953
R539 VSS.t39 VSS.t65 40.6953
R540 VSS.n148 VSS.n15 34.7108
R541 VSS.t83 VSS.n59 32.7159
R542 VSS.t1 VSS.t23 28.2614
R543 VSS.n12 VSS.t41 27.837
R544 VSS.n56 VSS.t38 27.837
R545 VSS.n35 VSS.t46 27.837
R546 VSS.n37 VSS.t44 27.837
R547 VSS.t34 VSS.t9 24.1054
R548 VSS.t42 VSS.n147 20.3479
R549 VSS.n147 VSS.t65 20.3479
R550 VSS.n116 VSS.t59 16.4048
R551 VSS.n121 VSS.t56 16.4048
R552 VSS.t33 VSS.t17 10.8061
R553 VSS VSS.n115 9.93907
R554 VSS.n46 VSS 9.0005
R555 VSS.n154 VSS 9.0005
R556 VSS VSS.n11 9.0005
R557 VSS.n152 VSS 9.0005
R558 VSS.n40 VSS 9.0005
R559 VSS VSS.n33 9.0005
R560 VSS.n115 VSS 9.0005
R561 VSS.n113 VSS 9.0005
R562 VSS.n110 VSS 9.0005
R563 VSS.n72 VSS 9.0005
R564 VSS.n122 VSS 9.0005
R565 VSS.n106 VSS.t57 8.60104
R566 VSS.n105 VSS.n73 7.94073
R567 VSS.t63 VSS.t74 6.98245
R568 VSS.n155 VSS 6.50621
R569 VSS.n94 VSS.n15 5.98503
R570 VSS.n107 VSS.t7 5.75067
R571 VSS VSS.n70 5.61377
R572 VSS.n63 VSS.t69 5.60241
R573 VSS VSS.n0 5.27032
R574 VSS VSS.n81 5.27032
R575 VSS.n98 VSS 5.27032
R576 VSS.n153 VSS 5.26871
R577 VSS.n123 VSS 5.26871
R578 VSS.n9 VSS 5.26123
R579 VSS.n153 VSS 5.15621
R580 VSS.n47 VSS 4.95371
R581 VSS VSS.n99 4.93121
R582 VSS.n23 VSS 4.93121
R583 VSS VSS.n142 4.93121
R584 VSS VSS.n54 4.93121
R585 VSS VSS.n10 4.93121
R586 VSS.n54 VSS 4.93121
R587 VSS VSS.n10 4.93121
R588 VSS VSS.n26 4.93121
R589 VSS VSS.n124 4.93121
R590 VSS VSS.n70 4.93121
R591 VSS.n135 VSS 4.93121
R592 VSS.n80 VSS 4.93121
R593 VSS VSS.n0 4.93121
R594 VSS VSS.n156 4.78657
R595 VSS.n9 VSS 4.78657
R596 VSS.n1 VSS.t71 4.55212
R597 VSS.n82 VSS.t32 4.5285
R598 VSS.n89 VSS.t78 4.5285
R599 VSS VSS.n97 4.5005
R600 VSS.n90 VSS 4.5005
R601 VSS.n88 VSS 4.5005
R602 VSS.n143 VSS 4.5005
R603 VSS VSS.n22 4.5005
R604 VSS.n55 VSS 4.5005
R605 VSS.n31 VSS 4.5005
R606 VSS VSS.n7 4.5005
R607 VSS.n157 VSS 4.5005
R608 VSS VSS.n8 4.5005
R609 VSS.n34 VSS 4.5005
R610 VSS VSS.n42 4.5005
R611 VSS.n51 VSS.n50 4.5005
R612 VSS.n53 VSS.n43 4.5005
R613 VSS.n69 VSS 4.5005
R614 VSS.n125 VSS 4.5005
R615 VSS.n120 VSS 4.5005
R616 VSS.n74 VSS 4.5005
R617 VSS VSS.n134 4.5005
R618 VSS.n161 VSS 4.5005
R619 VSS.n100 VSS 4.5005
R620 VSS VSS.n163 4.5005
R621 VSS.n141 VSS.n140 4.5005
R622 VSS.n136 VSS.n24 4.5005
R623 VSS.n86 VSS.t31 4.416
R624 VSS.n87 VSS.t77 4.416
R625 VSS.n162 VSS.t5 4.37212
R626 VSS.n136 VSS.n135 4.34316
R627 VSS.n108 VSS.n107 4.31325
R628 VSS VSS.n87 4.21175
R629 VSS.n102 VSS.n101 4.20675
R630 VSS.n78 VSS.n77 4.20675
R631 VSS.n88 VSS 4.16912
R632 VSS.n97 VSS 4.16912
R633 VSS.n163 VSS 4.16412
R634 VSS.n154 VSS 4.10354
R635 VSS.n102 VSS.t72 4.101
R636 VSS.n79 VSS.t3 4.101
R637 VSS.n78 VSS.t6 4.101
R638 VSS.n50 VSS 3.67847
R639 VSS.n90 VSS.n82 3.64912
R640 VSS.n90 VSS.n89 3.64912
R641 VSS.n87 VSS 3.60675
R642 VSS VSS.n86 3.60675
R643 VSS VSS.n157 3.3455
R644 VSS.n8 VSS 3.3455
R645 VSS.n8 VSS.n7 3.28675
R646 VSS.n157 VSS.n7 3.28675
R647 VSS.n162 VSS.n161 2.83662
R648 VSS.n161 VSS.n1 2.83662
R649 VSS VSS.n102 2.79425
R650 VSS VSS.t43 2.48646
R651 VSS VSS.t40 2.48646
R652 VSS VSS.t47 2.48646
R653 VSS.t45 VSS 2.48646
R654 VSS VSS.n74 2.3655
R655 VSS.n120 VSS 2.3655
R656 VSS.n52 VSS.n48 2.24472
R657 VSS.n53 VSS.n44 2.23795
R658 VSS.n51 VSS.n49 2.23795
R659 VSS.n139 VSS.n25 2.23795
R660 VSS.n138 VSS.n24 2.23795
R661 VSS.n137 VSS.n25 2.23795
R662 VSS.n48 VSS 2.153
R663 VSS.t15 VSS.n104 2.07851
R664 VSS VSS.n20 1.9955
R665 VSS VSS.n79 1.98175
R666 VSS VSS.t61 1.9157
R667 VSS VSS.t58 1.9157
R668 VSS.n151 VSS 1.66746
R669 VSS VSS.n39 1.66746
R670 VSS.n150 VSS 1.493
R671 VSS VSS.t55 1.36078
R672 VSS VSS.t37 1.36078
R673 VSS VSS.n114 1.2605
R674 VSS VSS.n112 1.2605
R675 VSS VSS.n111 1.2605
R676 VSS VSS.n109 1.2605
R677 VSS VSS.n71 1.2605
R678 VSS.n68 VSS 1.20925
R679 VSS VSS.n126 1.20925
R680 VSS.n37 VSS 1.103
R681 VSS VSS.n35 1.103
R682 VSS VSS.n145 1.0905
R683 VSS VSS.n63 1.0655
R684 VSS VSS.t52 1.05006
R685 VSS VSS.t49 1.05006
R686 VSS.n38 VSS.n34 1.0155
R687 VSS.n134 VSS 0.9705
R688 VSS.n122 VSS.n72 0.939071
R689 VSS.n110 VSS.n72 0.939071
R690 VSS VSS.n110 0.939071
R691 VSS.n113 VSS 0.939071
R692 VSS.n115 VSS.n113 0.939071
R693 VSS VSS.n144 0.8455
R694 VSS.n21 VSS 0.8455
R695 VSS.t43 VSS.n151 0.8195
R696 VSS.n151 VSS.t73 0.8195
R697 VSS.n39 VSS.t45 0.8195
R698 VSS.n39 VSS.t81 0.8195
R699 VSS.n64 VSS 0.743357
R700 VSS.n65 VSS.n64 0.743357
R701 VSS VSS.n133 0.743357
R702 VSS.n133 VSS.n132 0.743357
R703 VSS VSS.n45 0.722457
R704 VSS.n30 VSS 0.7155
R705 VSS VSS.n41 0.7155
R706 VSS.n79 VSS.n78 0.713
R707 VSS.n145 VSS 0.704848
R708 VSS VSS.n20 0.704848
R709 VSS VSS.n150 0.704848
R710 VSS.n30 VSS 0.704848
R711 VSS VSS.n38 0.704848
R712 VSS.n41 VSS 0.704848
R713 VSS.n114 VSS.t28 0.6557
R714 VSS.n114 VSS.t26 0.6557
R715 VSS.n112 VSS.t22 0.6557
R716 VSS.n112 VSS.t24 0.6557
R717 VSS.n111 VSS.t20 0.6557
R718 VSS.n111 VSS.t18 0.6557
R719 VSS.n109 VSS.t16 0.6557
R720 VSS.n109 VSS.t14 0.6557
R721 VSS.n71 VSS.t12 0.6557
R722 VSS.n71 VSS.t10 0.6557
R723 VSS.n144 VSS.n143 0.6255
R724 VSS.n22 VSS.n21 0.6255
R725 VSS.n56 VSS.n55 0.6255
R726 VSS.n31 VSS.n12 0.6255
R727 VSS.n69 VSS.n68 0.6255
R728 VSS.n126 VSS.n125 0.6255
R729 VSS.n121 VSS.n120 0.6255
R730 VSS.n116 VSS.n74 0.6255
R731 VSS.n46 VSS 0.617643
R732 VSS.n143 VSS 0.5955
R733 VSS.n22 VSS 0.5955
R734 VSS VSS.n16 0.578278
R735 VSS.n148 VSS.n16 0.578278
R736 VSS VSS.n29 0.578278
R737 VSS.n58 VSS.n29 0.578278
R738 VSS VSS.n149 0.578278
R739 VSS.n149 VSS.n148 0.578278
R740 VSS.n57 VSS 0.578278
R741 VSS.n58 VSS.n57 0.578278
R742 VSS VSS.n121 0.533
R743 VSS VSS.n116 0.533
R744 VSS VSS.n46 0.530857
R745 VSS VSS.n75 0.5205
R746 VSS.n76 VSS.n75 0.5205
R747 VSS VSS.n73 0.5205
R748 VSS VSS.n154 0.497107
R749 VSS VSS.n152 0.479429
R750 VSS.n33 VSS 0.479429
R751 VSS VSS.n27 0.473227
R752 VSS.t68 VSS.n27 0.473227
R753 VSS.n28 VSS 0.473227
R754 VSS.t68 VSS.n28 0.473227
R755 VSS VSS.n56 0.4705
R756 VSS VSS.n12 0.4705
R757 VSS VSS.n37 0.4705
R758 VSS.n35 VSS 0.4705
R759 VSS VSS.n31 0.468
R760 VSS.n55 VSS 0.468
R761 VSS.n34 VSS 0.468
R762 VSS.n42 VSS 0.468
R763 VSS.n125 VSS 0.468
R764 VSS VSS.n69 0.468
R765 VSS VSS.n122 0.4505
R766 VSS.n80 VSS.n0 0.42296
R767 VSS.n98 VSS.n23 0.42134
R768 VSS.n155 VSS.n153 0.4037
R769 VSS VSS.n9 0.39272
R770 VSS.n107 VSS.t13 0.386692
R771 VSS.n124 VSS 0.35474
R772 VSS VSS.n18 0.347167
R773 VSS.n94 VSS.n18 0.347167
R774 VSS VSS.n19 0.347167
R775 VSS.n58 VSS.n19 0.347167
R776 VSS.n86 VSS 0.3355
R777 VSS.n45 VSS.t67 0.3281
R778 VSS.n45 VSS.t66 0.3281
R779 VSS VSS.n61 0.3255
R780 VSS.t79 VSS.n61 0.3255
R781 VSS VSS.n62 0.3255
R782 VSS.t79 VSS.n62 0.3255
R783 VSS VSS.n32 0.3255
R784 VSS.n32 VSS.t65 0.3255
R785 VSS VSS.n36 0.3255
R786 VSS.n36 VSS.t65 0.3255
R787 VSS.n13 VSS 0.3255
R788 VSS.t65 VSS.n13 0.3255
R789 VSS VSS.n14 0.3255
R790 VSS.t65 VSS.n14 0.3255
R791 VSS.n135 VSS.n26 0.31586
R792 VSS.n99 VSS.n81 0.30596
R793 VSS VSS.n100 0.292868
R794 VSS.n42 VSS 0.2905
R795 VSS.n152 VSS.n11 0.289786
R796 VSS.n40 VSS.n33 0.289786
R797 VSS.n146 VSS 0.289389
R798 VSS.n147 VSS.n146 0.289389
R799 VSS VSS.n17 0.289389
R800 VSS.n147 VSS.n17 0.289389
R801 VSS VSS.n67 0.248119
R802 VSS.n67 VSS.n66 0.248119
R803 VSS.n127 VSS 0.248119
R804 VSS.n128 VSS.n127 0.248119
R805 VSS.n140 VSS 0.23675
R806 VSS VSS.t64 0.2324
R807 VSS.t64 VSS 0.2324
R808 VSS VSS.n98 0.21254
R809 VSS.n134 VSS 0.1855
R810 VSS.n142 VSS.n23 0.1733
R811 VSS VSS.n11 0.145143
R812 VSS VSS.n40 0.145143
R813 VSS.n54 VSS.n10 0.13658
R814 VSS.n124 VSS.n26 0.13658
R815 VSS VSS.n47 0.1295
R816 VSS.n81 VSS.n80 0.1175
R817 VSS VSS.n5 0.111138
R818 VSS.n84 VSS.n5 0.111138
R819 VSS VSS.n6 0.111138
R820 VSS.n93 VSS.n6 0.111138
R821 VSS.n117 VSS 0.106622
R822 VSS.n118 VSS.n117 0.106622
R823 VSS VSS.n119 0.106622
R824 VSS.n119 VSS.n118 0.106622
R825 VSS.n54 VSS.n53 0.10382
R826 VSS.n142 VSS.n141 0.10292
R827 VSS VSS.n123 0.1013
R828 VSS.n63 VSS 0.1005
R829 VSS.n156 VSS.n155 0.09446
R830 VSS.n153 VSS.n10 0.0905
R831 VSS.n161 VSS.n160 0.0901552
R832 VSS.n160 VSS.n159 0.0901552
R833 VSS.n103 VSS 0.0901552
R834 VSS.n104 VSS.n103 0.0901552
R835 VSS.n97 VSS.n82 0.0857632
R836 VSS.n89 VSS.n88 0.0857632
R837 VSS.n100 VSS.n1 0.0857632
R838 VSS.n163 VSS.n162 0.0857632
R839 VSS VSS.n85 0.0857459
R840 VSS.n85 VSS.n84 0.0857459
R841 VSS VSS.n96 0.0857459
R842 VSS.n96 VSS.n95 0.0857459
R843 VSS.n101 VSS.n3 0.0857459
R844 VSS.n60 VSS.n3 0.0857459
R845 VSS.n77 VSS.n2 0.0857459
R846 VSS.n76 VSS.n2 0.0857459
R847 VSS.n123 VSS.n70 0.08402
R848 VSS.n156 VSS 0.08294
R849 VSS.n7 VSS.n4 0.08175
R850 VSS.t63 VSS.n4 0.08175
R851 VSS.n158 VSS 0.08175
R852 VSS.t63 VSS.n158 0.08175
R853 VSS.n145 VSS 0.0805
R854 VSS VSS.n20 0.0805
R855 VSS VSS.n30 0.0805
R856 VSS.n150 VSS 0.0805
R857 VSS.n38 VSS 0.0805
R858 VSS.n41 VSS 0.0805
R859 VSS VSS.n83 0.0727222
R860 VSS.n91 VSS.n83 0.0727222
R861 VSS.n92 VSS.n90 0.0727222
R862 VSS.n92 VSS.n91 0.0727222
R863 VSS.n139 VSS.n138 0.0536955
R864 VSS.n49 VSS.n44 0.0536955
R865 VSS.n138 VSS.n137 0.0536955
R866 VSS.n48 VSS.n43 0.053
R867 VSS.n47 VSS 0.041
R868 VSS.n50 VSS.n44 0.0270978
R869 VSS.n49 VSS.n43 0.0270978
R870 VSS.n137 VSS.n136 0.0270978
R871 VSS.n140 VSS.n139 0.0270978
R872 VSS.n25 VSS.n24 0.0257
R873 VSS.n99 VSS 0.02246
R874 VSS.n52 VSS.n51 0.0135648
R875 VSS.n53 VSS.n52 0.0135648
R876 VSS.n101 VSS 0.00175
R877 VSS.n77 VSS 0.00175
R878 VSS.n141 VSS.n24 0.0014
R879 vf.0 vf.0.t0 3.57
R880 vf.0.n0 vf.0 0.463045
R881 vf.0.t2 vf.0.n0 0.20758
R882 vf.0.n0 vf.0.t1 0.20758
R883 rb_m3.0.t0 rb_m3.0 3.57
R884 rb_m3.0.t1 rb_m3.0 3.57
R885 rb_m2.0 rb_m2.0.t0 3.57
R886 rb_m2.0 rb_m2.0.t1 3.57
R887 rb_m1.0.t0 rb_m1.0 3.57
R888 rb_m1.0.t1 rb_m1.0 3.57
R889 rf_m1.0.t0 rf_m1.0 3.57
R890 rf_m1.0.t1 rf_m1.0 3.57
R891 nrb.0 nrb.0.t9 3.57
R892 nrb.0.n1 nrb.0 1.69604
R893 nrb.0.n3 nrb.0.n1 0.617643
R894 nrb.0 nrb.0.n3 0.617643
R895 nrb.0.n6 nrb.0 0.617643
R896 nrb.0 nrb.0.n6 9.61764
R897 nrb.0 nrb.0.n7 0.612457
R898 nrb.0.t7 nrb.0.n7 0.3645
R899 nrb.0.n7 nrb.0.t6 0.3645
R900 nrb.0 nrb.0.n6 9.0005
R901 nrb.0 nrb.0.n5 0.612457
R902 nrb.0.t3 nrb.0.n5 0.3645
R903 nrb.0.n5 nrb.0.t2 0.3645
R904 nrb.0 nrb.0.n4 0.612457
R905 nrb.0.t5 nrb.0.n4 0.3645
R906 nrb.0.n4 nrb.0.t0 0.3645
R907 nrb.0 nrb.0.n3 9.0005
R908 nrb.0 nrb.0.n2 0.612457
R909 nrb.0.t1 nrb.0.n2 0.3645
R910 nrb.0.n2 nrb.0.t10 0.3645
R911 nrb.0 nrb.0.n1 9.0005
R912 nrb.0 nrb.0.n0 0.612457
R913 nrb.0.t4 nrb.0.n0 0.3645
R914 nrb.0.n0 nrb.0.t8 0.3645
R915 rdb_m1.0 rdb_m1.0.t0 3.57
R916 rdb_m1.0 rdb_m1.0.t1 3.57
R917 rdt_m3.0 rdt_m3.0.t0 3.57
R918 rdt_m3.0 rdt_m3.0.t1 3.57
R919 rdb_m2.0.t0 rdb_m2.0 3.57
R920 rdb_m2.0.t1 rdb_m2.0 3.57
R921 rdb_m3.0 rdb_m3.0.t0 3.57
R922 rdb_m3.0 rdb_m3.0.t1 3.57
R923 rdt_m1.0 rdt_m1.0.t0 3.57
R924 rdt_m1.0 rdt_m1.0.t1 3.57
R925 rdt_m2.0.t0 rdt_m2.0 3.57
R926 rdt_m2.0.t1 rdt_m2.0 3.57
R927 nmid.0.t0 nmid.0 3.57
R928 nmid.0.n1 nmid.0 1.26693
R929 nmid.0 nmid.0.n1 0.309071
R930 nmid.0 nmid.0.n2 0.722457
R931 nmid.0.t1 nmid.0.n2 0.3281
R932 nmid.0.n2 nmid.0.t3 0.3281
R933 nmid.0 nmid.0.n1 9.0005
R934 nmid.0 nmid.0.n0 0.722457
R935 nmid.0.t4 nmid.0.n0 0.3281
R936 nmid.0.n0 nmid.0.t2 0.3281
R937 enb.0 enb.0.t0 4.7885
R938 enb.0 enb.0.n0 1.72336
R939 enb.0.n0 enb.0 0.122643
R940 enb.0 enb.0.n10 4.84764
R941 enb.0.n10 enb.0 0.768714
R942 enb.0 enb.0.n9 6.39371
R943 enb.0.n9 enb.0 0.177286
R944 enb.0.t11 enb.0 27.4066
R945 enb.0 enb.0.n9 4.59371
R946 enb.0.t12 enb.0 27.4066
R947 enb.0 enb.0.n10 1.33121
R948 enb.0 enb.0.n8 1.13246
R949 enb.0.t2 enb.0.n8 0.7285
R950 enb.0.n8 enb.0.t1 0.7285
R951 enb.0 enb.0.n0 4.81229
R952 enb.0.n1 enb.0.n2 0.39963
R953 enb.0.n2 enb.0.n3 0.39963
R954 enb.0.n3 enb.0.n4 0.39963
R955 enb.0.n4 enb.0.n5 0.39963
R956 enb.0.n5 enb.0 0.0122391
R957 enb.0 enb.0.n6 0.387891
R958 enb.0.n6 enb.0.n7 0.39963
R959 enb.0.n7 enb.0 10.1568
R960 enb.0.t3 enb.0.n7 48.7548
R961 enb.0.t4 enb.0.n6 48.7548
R962 enb.0.t5 enb.0.n5 48.7548
R963 enb.0.t6 enb.0.n4 48.7548
R964 enb.0.t7 enb.0.n3 48.7548
R965 enb.0.t8 enb.0.n2 48.7548
R966 enb.0.t9 enb.0.n1 48.7548
R967 enb.0.t10 enb.0.n1 49.154
C0 nmid.0 rdb_m2.0 0.04228f
C1 vf.0 rb_m2.0 0.08519f
C2 VBN vf.0 1.55879f
C3 VDD vf.0 0.00294f
C4 vf.0 EN 0.02265f
C5 VB2 VBN 0.22178f
C6 VBP VBN 7.55653f
C7 rdt_m3.0 rdt_m1.0 0.08167f
C8 VB2 VREF 0.61553f
C9 nrb.0 vf.0 0.61512f
C10 VBN nmid.0 0.11617f
C11 VB2 VDD 6.36236f
C12 VBP VREF 0.06866f
C13 VBP VDD 19.3494f
C14 VB2 EN 2.209f
C15 VBP EN 0.30881f
C16 VREF nmid.0 0.97574f
C17 VDD nmid.0 0.17489f
C18 nmid.0 EN 0.59891f
C19 rb_m1.0 EN 0.00905f
C20 rdb_m1.0 rdt_m3.0 0.22342f
C21 VB2 nrb.0 0.03524f
C22 VBP nrb.0 0.36239f
C23 VBN enb.0 0.30834f
C24 rdb_m3.0 rdt_m1.0 0.41833f
C25 VREF enb.0 0.19826f
C26 VDD enb.0 6.07954f
C27 enb.0 EN 4.07467f
C28 nmid.0 rdt_m2.0 0.00432f
C29 enb.0 nrb.0 0.83214f
C30 VREF rdb_m2.0 0.32236f
C31 VDD rdb_m2.0 0.00594f
C32 VB2 vf.0 0.92426f
C33 VBP vf.0 0.19894f
C34 VB2 VBP 5.49406f
C35 VB2 nmid.0 0.91956f
C36 VBP nmid.0 0.03404f
C37 VBP rb_m1.0 0
C38 VBN rb_m2.0 0.03909f
C39 VREF VBN 0.08546f
C40 VDD VBN 3.33118f
C41 rdb_m2.0 rdt_m2.0 0.37f
C42 VBN EN 0.42317f
C43 enb.0 vf.0 1.18587f
C44 VDD VREF 3.0865f
C45 VDD EN 3.65306f
C46 rb_m3.0 rf_m1.0 0.04347f
C47 nrb.0 rb_m2.0 0.03837f
C48 VBN nrb.0 0.04433f
C49 rb_m3.0 rb_m1.0 0.06955f
C50 VB2 enb.0 2.1266f
C51 VBP enb.0 1.14704f
C52 VDD nrb.0 5.10108f
C53 nrb.0 EN 0.24322f
C54 nmid.0 enb.0 0.71708f
C55 enb.0 rb_m1.0 0
C56 enb.0 rdt_m1.0 0.0052f
C57 VREF rdt_m2.0 0.00293f
C58 VDD rdt_m2.0 0.00209f
C59 EN VSS 5.13004f
C60 VREF VSS 14.4293f
C61 VBN VSS 12.0301f
C62 VB2 VSS 6.64428f
C63 VBP VSS 3.67313f
C64 VDD VSS 53.4198f
C65 vf.0 VSS 2.5547f
C66 rb_m3.0 VSS 1.29214f
C67 rb_m2.0 VSS 1.11908f
C68 rb_m1.0 VSS 1.26876f
C69 rf_m1.0 VSS 1.38676f
C70 nrb.0 VSS 0.954117f
C71 rdb_m1.0 VSS 1.03822f
C72 rdt_m3.0 VSS 1.74717f
C73 rdb_m2.0 VSS 1.57521f
C74 rdb_m3.0 VSS 1.01451f
C75 rdt_m1.0 VSS 1.55946f
C76 rdt_m2.0 VSS 1.0669f
C77 nmid.0 VSS 3.60437f
C78 enb.0 VSS 6.20877f
C79 enb.0.t0 VSS 0.02352f
C80 enb.0.n0 VSS 0.0629321f
C81 enb.0.t10 VSS 0.130646f
C82 enb.0.t9 VSS 0.130077f
C83 enb.0.n1 VSS 0.145595f
C84 enb.0.t8 VSS 0.130077f
C85 enb.0.n2 VSS 0.0762803f
C86 enb.0.t7 VSS 0.130077f
C87 enb.0.n3 VSS 0.0762803f
C88 enb.0.t6 VSS 0.130077f
C89 enb.0.n4 VSS 0.0762803f
C90 enb.0.t5 VSS 0.130077f
C91 enb.0.n5 VSS 0.0682619f
C92 enb.0.t4 VSS 0.130077f
C93 enb.0.n6 VSS 0.076038f
C94 enb.0.t3 VSS 0.130077f
C95 enb.0.n7 VSS 0.126497f
C96 enb.0.t2 VSS 0.0228875f
C97 enb.0.t1 VSS 0.0228875f
C98 enb.0.n8 VSS 0.0475852f
C99 enb.0.n9 VSS 0.207121f
C100 enb.0.t12 VSS 0.0513437f
C101 enb.0.t11 VSS 0.0513437f
C102 enb.0.n10 VSS 0.0713576f
C103 nmid.0.t0 VSS 0.0704991f
C104 nmid.0.t4 VSS 0.0525124f
C105 nmid.0.t2 VSS 0.0525124f
C106 nmid.0.n0 VSS 0.111333f
C107 nmid.0.n1 VSS 0.0681795f
C108 nmid.0.t1 VSS 0.0525124f
C109 nmid.0.t3 VSS 0.0525124f
C110 nmid.0.n2 VSS 0.111333f
C111 rdt_m2.0.t0 VSS 0.0575275f
C112 rdt_m2.0.t1 VSS 0.0575275f
C113 rdt_m1.0.t0 VSS 0.0514765f
C114 rdt_m1.0.t1 VSS 0.0514765f
C115 rdb_m3.0.t0 VSS 0.0612615f
C116 rdb_m3.0.t1 VSS 0.0612615f
C117 rdb_m2.0.t0 VSS 0.0596008f
C118 rdb_m2.0.t1 VSS 0.0596008f
C119 rdt_m3.0.t0 VSS 0.0327396f
C120 rdt_m3.0.t1 VSS 0.0327396f
C121 rdb_m1.0.t0 VSS 0.0410027f
C122 rdb_m1.0.t1 VSS 0.0410027f
C123 nrb.0.t9 VSS 0.0468183f
C124 nrb.0.t4 VSS 0.0348735f
C125 nrb.0.t8 VSS 0.0348735f
C126 nrb.0.n0 VSS 0.0746883f
C127 nrb.0.n1 VSS 0.0626837f
C128 nrb.0.t1 VSS 0.0348735f
C129 nrb.0.t10 VSS 0.0348735f
C130 nrb.0.n2 VSS 0.0746883f
C131 nrb.0.n3 VSS 0.0375139f
C132 nrb.0.t5 VSS 0.0348735f
C133 nrb.0.t0 VSS 0.0348735f
C134 nrb.0.n4 VSS 0.0746883f
C135 nrb.0.t3 VSS 0.0348735f
C136 nrb.0.t2 VSS 0.0348735f
C137 nrb.0.n5 VSS 0.0746883f
C138 nrb.0.n6 VSS 0.0610908f
C139 nrb.0.t7 VSS 0.0348735f
C140 nrb.0.t6 VSS 0.0348735f
C141 nrb.0.n7 VSS 0.0746883f
C142 rf_m1.0.t0 VSS 0.00774976f
C143 rf_m1.0.t1 VSS 0.00774976f
C144 rb_m1.0.t0 VSS 0.0147327f
C145 rb_m1.0.t1 VSS 0.0147327f
C146 rb_m2.0.t0 VSS 0.0314701f
C147 rb_m2.0.t1 VSS 0.0314701f
C148 rb_m3.0.t0 VSS 0.0189127f
C149 rb_m3.0.t1 VSS 0.0189127f
C150 vf.0.t0 VSS 0.0767446f
C151 vf.0.t2 VSS 0.0904326f
C152 vf.0.t1 VSS 0.0904326f
C153 vf.0.n0 VSS 0.197431f
C154 VDD.n0 VSS 1.53129f
C155 VDD.n1 VSS 0.0798848f
C156 VDD.n2 VSS 0.735397f
C157 VDD.n3 VSS 0.735397f
C158 VDD.t53 VSS 0.649419f
C159 VDD.t40 VSS 0.413495f
C160 VDD.t34 VSS 0.413495f
C161 VDD.t38 VSS 0.413495f
C162 VDD.t36 VSS 0.413495f
C163 VDD.t32 VSS 0.413495f
C164 VDD.t30 VSS 0.413495f
C165 VDD.t18 VSS 0.413495f
C166 VDD.t50 VSS 0.649419f
C167 VDD.t12 VSS 0.413495f
C168 VDD.t14 VSS 0.413495f
C169 VDD.t16 VSS 0.413495f
C170 VDD.t20 VSS 0.413495f
C171 VDD.t22 VSS 0.413495f
C172 VDD.t24 VSS 0.413495f
C173 VDD.t26 VSS 0.413495f
C174 VDD.t52 VSS 0.1131f
C175 VDD.n4 VSS 0.173646f
C176 VDD.t49 VSS 0.1131f
C177 VDD.t51 VSS 0.0465874f
C178 VDD.t54 VSS 0.0659709f
C179 VDD.t41 VSS 0.0193899f
C180 VDD.n5 VSS 0.0387797f
C181 VDD.n6 VSS 0.0341355f
C182 VDD.t35 VSS 0.0193899f
C183 VDD.t39 VSS 0.0193899f
C184 VDD.n7 VSS 0.0387797f
C185 VDD.n8 VSS 0.0292077f
C186 VDD.t37 VSS 0.0193899f
C187 VDD.t33 VSS 0.0193899f
C188 VDD.n9 VSS 0.0387797f
C189 VDD.n10 VSS 0.0292077f
C190 VDD.t31 VSS 0.0193899f
C191 VDD.t19 VSS 0.0193899f
C192 VDD.n11 VSS 0.0387797f
C193 VDD.n12 VSS 0.026246f
C194 VDD.t29 VSS 0.0193899f
C195 VDD.t27 VSS 0.0193899f
C196 VDD.n13 VSS 0.0387797f
C197 VDD.n14 VSS 0.0198184f
C198 VDD.t25 VSS 0.0193899f
C199 VDD.t23 VSS 0.0193899f
C200 VDD.n15 VSS 0.0387797f
C201 VDD.n16 VSS 0.0292077f
C202 VDD.t21 VSS 0.0193899f
C203 VDD.t17 VSS 0.0193899f
C204 VDD.n17 VSS 0.0387797f
C205 VDD.n18 VSS 0.0292077f
C206 VDD.t15 VSS 0.0193899f
C207 VDD.t13 VSS 0.0193899f
C208 VDD.n19 VSS 0.0387797f
C209 VDD.n20 VSS 0.0292077f
C210 VDD.n21 VSS 0.209596f
C211 VDD.n22 VSS 0.0490828f
C212 VDD.n23 VSS 0.00882847f
C213 VDD.t58 VSS 0.0157161f
C214 VDD.n24 VSS 0.0573567f
C215 VDD.n25 VSS 0.0716927f
C216 VDD.n26 VSS 0.0716927f
C217 VDD.t57 VSS 0.0242295f
C218 VDD.n27 VSS 0.026038f
C219 VDD.t55 VSS 0.0157161f
C220 VDD.t69 VSS 0.0501036f
C221 VDD.t72 VSS 0.0501036f
C222 VDD.n28 VSS 0.40478f
C223 VDD.n29 VSS 0.0247651f
C224 VDD.n30 VSS 0.14435f
C225 VDD.n31 VSS 0.156594f
C226 VDD.t61 VSS 0.0223201f
C227 VDD.n32 VSS 0.0247336f
C228 VDD.n33 VSS 0.0723859f
C229 VDD.n34 VSS 0.0723859f
C230 VDD.t66 VSS 0.0270147f
C231 VDD.t63 VSS 0.0192575f
C232 VDD.n35 VSS 0.0179279f
C233 VDD.t9 VSS 0.00775721f
C234 VDD.n36 VSS 0.0160374f
C235 VDD.n37 VSS 0.0197112f
C236 VDD.n38 VSS 0.0439092f
C237 VDD.t64 VSS 0.0223201f
C238 VDD.n39 VSS 0.0265421f
C239 VDD.n40 VSS 0.0583965f
C240 VDD.n41 VSS 0.401352f
C241 VDD.t65 VSS 0.367393f
C242 VDD.t8 VSS 0.186198f
C243 VDD.t62 VSS 0.367393f
C244 VDD.n42 VSS 0.401352f
C245 VDD.n43 VSS 0.0582578f
C246 VDD.n44 VSS 0.0266808f
C247 VDD.n45 VSS 0.144721f
C248 VDD.n46 VSS 0.112653f
C249 VDD.n47 VSS 0.0629273f
C250 VDD.t70 VSS 0.0558821f
C251 VDD.n48 VSS 0.10908f
C252 VDD.n49 VSS 0.126667f
C253 VDD.t67 VSS 0.0558821f
C254 VDD.n50 VSS 0.109042f
C255 VDD.n51 VSS 0.126667f
C256 VDD.n52 VSS 0.616871f
C257 VDD.t68 VSS 0.547416f
C258 VDD.t47 VSS 0.277476f
C259 VDD.t10 VSS 0.277476f
C260 VDD.t4 VSS 0.277476f
C261 VDD.t45 VSS 0.208109f
C262 VDD.n53 VSS 0.138735f
C263 VDD.t0 VSS 0.208109f
C264 VDD.t2 VSS 0.277476f
C265 VDD.t73 VSS 0.277476f
C266 VDD.t43 VSS 0.277476f
C267 VDD.t71 VSS 0.547416f
C268 VDD.n54 VSS 0.616871f
C269 VDD.n55 VSS 0.0394414f
C270 VDD.n56 VSS 0.0195285f
C271 VDD.t44 VSS 0.0193899f
C272 VDD.t74 VSS 0.0193899f
C273 VDD.n57 VSS 0.0415209f
C274 VDD.n58 VSS 0.0208581f
C275 VDD.t3 VSS 0.0193899f
C276 VDD.t1 VSS 0.0193899f
C277 VDD.n59 VSS 0.0415209f
C278 VDD.n60 VSS 0.0167558f
C279 VDD.t46 VSS 0.0193899f
C280 VDD.t5 VSS 0.0193899f
C281 VDD.n61 VSS 0.0415209f
C282 VDD.n62 VSS 0.0167558f
C283 VDD.t11 VSS 0.0193899f
C284 VDD.t48 VSS 0.0193899f
C285 VDD.n63 VSS 0.0415209f
C286 VDD.n64 VSS 0.0339654f
C287 VDD.n65 VSS 0.032642f
C288 VDD.n66 VSS 0.0379983f
C289 VDD.n67 VSS 0.432992f
C290 VDD.n68 VSS 0.0249037f
C291 VDD.n69 VSS 0.0572118f
C292 VDD.n70 VSS 0.41628f
C293 VDD.t56 VSS 0.364822f
C294 VDD.t6 VSS 0.157974f
C295 VDD.t59 VSS 0.364822f
C296 VDD.n71 VSS 0.41628f
C297 VDD.n72 VSS 0.0433925f
C298 VDD.t7 VSS 0.00969178f
C299 VDD.n73 VSS 0.0201524f
C300 VDD.t60 VSS 0.0339212f
C301 VDD.n74 VSS 0.0174994f
C302 VDD.n75 VSS 0.0100447f
C303 VDD.t42 VSS 0.0260317f
C304 VDD.n76 VSS 0.292468f
C305 VDD.n77 VSS 1.80153f
C306 VDD.n78 VSS 0.0238325f
C307 VDD.n79 VSS 0.173627f
C308 VDD.n80 VSS 0.2101f
C309 VDD.t28 VSS 0.413495f
C310 VDD.n81 VSS 0.2101f
C311 VDD.n82 VSS 0.14641f
C312 VDD.n83 VSS 0.106566f
C313 VBP.t30 VSS 0.0125849f
C314 VBP.t4 VSS 0.0125849f
C315 VBP.n0 VSS 0.0271892f
C316 VBP.t3 VSS 0.0125849f
C317 VBP.t1 VSS 0.0125849f
C318 VBP.n1 VSS 0.0271892f
C319 VBP.n2 VSS 0.0299276f
C320 VBP.t0 VSS 0.0125849f
C321 VBP.t2 VSS 0.0125849f
C322 VBP.n3 VSS 0.0271892f
C323 VBP.n4 VSS 0.0673417f
C324 VBP.t7 VSS 0.0100675f
C325 VBP.t5 VSS 0.0100675f
C326 VBP.n5 VSS 0.0208221f
C327 VBP.n6 VSS 0.137306f
C328 VBP.t18 VSS 0.143217f
C329 VBP.t16 VSS 0.143217f
C330 VBP.t31 VSS 0.143217f
C331 VBP.t32 VSS 0.143217f
C332 VBP.t26 VSS 0.143217f
C333 VBP.t24 VSS 0.143217f
C334 VBP.t22 VSS 0.143217f
C335 VBP.t20 VSS 0.143217f
C336 VBP.t10 VSS 0.143217f
C337 VBP.t8 VSS 0.143217f
C338 VBP.t33 VSS 0.143217f
C339 VBP.t34 VSS 0.143217f
C340 VBP.t28 VSS 0.143217f
C341 VBP.t14 VSS 0.143217f
C342 VBP.t12 VSS 0.144886f
C343 VBP.n7 VSS 0.144508f
C344 VBP.n8 VSS 0.0759593f
C345 VBP.n9 VSS 0.0759593f
C346 VBP.n10 VSS 0.0759593f
C347 VBP.n11 VSS 0.0759593f
C348 VBP.n12 VSS 0.0759593f
C349 VBP.n13 VSS 0.0759593f
C350 VBP.n14 VSS 0.0710619f
C351 VBP.n15 VSS 0.0740892f
C352 VBP.n16 VSS 0.0759593f
C353 VBP.n17 VSS 0.0759593f
C354 VBP.n18 VSS 0.0759593f
C355 VBP.n19 VSS 0.0759593f
C356 VBP.n20 VSS 0.107026f
C357 VBP.t19 VSS 0.0251697f
C358 VBP.t17 VSS 0.0251697f
C359 VBP.n21 VSS 0.0576645f
C360 VBP.n22 VSS 0.084318f
C361 VBP.t27 VSS 0.0251697f
C362 VBP.t25 VSS 0.0251697f
C363 VBP.n23 VSS 0.0576645f
C364 VBP.n24 VSS 0.0543983f
C365 VBP.t23 VSS 0.0251697f
C366 VBP.t21 VSS 0.0251697f
C367 VBP.n25 VSS 0.0576645f
C368 VBP.n26 VSS 0.0299276f
C369 VBP.t11 VSS 0.0251697f
C370 VBP.t9 VSS 0.0251697f
C371 VBP.n27 VSS 0.0576645f
C372 VBP.n28 VSS 0.046408f
C373 VBP.t29 VSS 0.0251697f
C374 VBP.t15 VSS 0.0251697f
C375 VBP.n29 VSS 0.0576645f
C376 VBP.n30 VSS 0.0543983f
C377 VBP.t13 VSS 0.0251697f
C378 VBP.t6 VSS 0.0251697f
C379 VBP.n31 VSS 0.0576645f
C380 VBP.n32 VSS 0.0559796f
C381 VBP.n33 VSS 0.199275f
C382 VB2.t0 VSS 0.0505809f
C383 VB2.t1 VSS 0.0505809f
C384 VB2.n0 VSS 0.115878f
C385 VB2.t2 VSS 0.0505809f
C386 VB2.t3 VSS 0.0505809f
C387 VB2.n1 VSS 0.115878f
C388 VB2.n2 VSS 0.167914f
C389 VB2.t5 VSS 0.229674f
C390 VB2.t6 VSS 0.0800163f
C391 VB2.t4 VSS 0.0800163f
C392 VB2.n3 VSS 0.174694f
C393 VB2.n4 VSS 0.107846f
C394 VB2.t7 VSS 0.0202305f
C395 VB2.t8 VSS 0.0202305f
C396 VB2.n5 VSS 0.0416124f
C397 VB2.n6 VSS 0.0643668f
C398 VB2.n7 VSS 0.312847f
C399 VBN.t11 VSS 0.0214663f
C400 VBN.t13 VSS 0.0214663f
C401 VBN.n0 VSS 0.0441476f
C402 VBN.t10 VSS 0.0720403f
C403 VBN.t14 VSS 0.149751f
C404 VBN.t8 VSS 0.149751f
C405 VBN.t6 VSS 0.149751f
C406 VBN.t15 VSS 0.149751f
C407 VBN.t16 VSS 0.149751f
C408 VBN.t17 VSS 0.149751f
C409 VBN.t18 VSS 0.149751f
C410 VBN.t4 VSS 0.149751f
C411 VBN.t2 VSS 0.149751f
C412 VBN.t0 VSS 0.153445f
C413 VBN.n1 VSS 0.206336f
C414 VBN.n2 VSS 0.111139f
C415 VBN.n3 VSS 0.111139f
C416 VBN.n4 VSS 0.111139f
C417 VBN.n5 VSS 0.106392f
C418 VBN.n6 VSS 0.101456f
C419 VBN.n7 VSS 0.111139f
C420 VBN.n8 VSS 0.111139f
C421 VBN.n9 VSS 0.1724f
C422 VBN.t9 VSS 0.0268288f
C423 VBN.t7 VSS 0.0268288f
C424 VBN.n10 VSS 0.0579671f
C425 VBN.n11 VSS 0.179469f
C426 VBN.t5 VSS 0.0268288f
C427 VBN.t3 VSS 0.0268288f
C428 VBN.n12 VSS 0.0579671f
C429 VBN.n13 VSS 0.0814531f
C430 VBN.t1 VSS 0.0268288f
C431 VBN.t12 VSS 0.0268288f
C432 VBN.n14 VSS 0.0579671f
C433 VBN.n15 VSS 0.0760041f
C434 VBN.n16 VSS 0.305701f
C435 VBN.n17 VSS 0.256748f
C436 VREF.t2 VSS 3.33563f
C437 VREF.t1 VSS 0.00661821f
C438 VREF.t0 VSS 0.00661821f
C439 VREF.n0 VSS 0.016534f
C440 EN.t2 VSS 0.0426882f
C441 EN.t3 VSS 0.152427f
C442 EN.t4 VSS 0.153093f
C443 EN.n0 VSS 0.169473f
C444 EN.n1 VSS 0.137082f
C445 EN.t1 VSS 0.0603134f
C446 EN.n2 VSS 0.0634872f
C447 EN.t0 VSS 0.0170939f
C448 EN.n3 VSS 0.153511f
.ends lvds_bias
