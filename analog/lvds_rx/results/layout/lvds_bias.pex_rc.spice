* lvds_bias: parasitic R (extresist, tolerance 10) on all nets; C from the C-coupled extraction (check.rc_repair, T11: Magic 8.3.636 extresist counts every coupling twice)
* GENERATED by layout/macro/run_macro.py (T10) from a GDS with sha256 138fad3bdf40bf766c92c38d885d53887c33eccab2c2a2e6204d930bb80b0d21 -- do not edit by hand.
* Ports in the order of subckt lvds_bias of netlist/lvds_rx_lvs_ref.spice (Magic's own order was: EN VBN VB2 VREF VBP VDD VSS).
* NGSPICE file created from lvds_bias.ext - technology: gf180mcuD

.subckt lvds_bias VDD VSS EN VBN VBP VB2 VREF
X0 VDD.t31 VBP.t14 VBP.t15 VDD.t30 pfet_03v3 ad=1.3p pd=5.52u as=1.3p ps=5.52u w=5u l=1u
X1 VREF.t1 rdt_m3.0.t1 VSS.t81 ppolyf_u_1k r_width=2u r_length=21.01u
X2 VBP.t22 VDD.t12 VDD.t14 VDD.t13 pfet_03v3 ad=0.52p pd=2.52u as=0.88p ps=4.88u w=2u l=0.5u
X3 nrb.0.t6 enb.0.t5 VDD.t63 VDD.t62 pfet_03v3 ad=1.3p pd=5.52u as=1.3p ps=5.52u w=5u l=0.5u
X4 VSS.t31 VSS.t29 VBP.t29 VSS.t30 nfet_03v3 ad=1.1p pd=5.88u as=0.65p ps=3.02u w=2.5u l=1u
X5 VSS.t60 VSS.t61 VSS.t59 ppolyf_u_1k r_width=2u r_length=21.01u
X6 VSS.t75 VSS.t76 VSS.t74 ppolyf_u_1k r_width=2u r_length=23.07u
X7 VSS.t7 VSS.t5 VSS.t7 VSS.t6 nfet_03v3 ad=0.52p pd=2.52u as=0 ps=0 w=2u l=0.5u
X8 nmid.0.t0 rdb_m3.0.t0 VSS.t2 ppolyf_u_1k r_width=2u r_length=19.26u
X9 VBN.t2 VBN.t1 VSS.t40 VSS.t39 nfet_03v3 ad=0.65p pd=3.02u as=0.65p ps=3.02u w=2.5u l=1u
X10 rdb_m2.0.t0 rdb_m3.0.t1 VSS.t67 ppolyf_u_1k r_width=2u r_length=19.26u
X11 nrb.0.t4 enb.0.t9 VDD.t59 VDD.t58 pfet_03v3 ad=1.3p pd=5.52u as=1.3p ps=5.52u w=5u l=0.5u
X12 rf_m1.0.t1 VSS.t63 VSS.t62 ppolyf_u_1k r_width=2u r_length=23.07u
X13 VSS.t50 VBN.t15 VBP.t26 VSS.t49 nfet_03v3 ad=0.65p pd=3.02u as=0.65p ps=3.02u w=2.5u l=1u
X14 VDD.t39 VBP.t2 VBP.t3 VDD.t38 pfet_03v3 ad=1.3p pd=5.52u as=1.3p ps=5.52u w=5u l=1u
X15 nrb.0.t0 VDD.t18 VDD.t20 VDD.t19 pfet_03v3 ad=1.3p pd=5.52u as=2.2p ps=10.88u w=5u l=0.5u
X16 VSS.t78 EN.t0 enb.0.t2 VSS.t77 nfet_03v3 ad=0.44p pd=2.88u as=0.44p ps=2.88u w=1u l=0.28u
X17 VSS.t54 VBN.t5 VBN.t6 VSS.t53 nfet_03v3 ad=0.65p pd=3.02u as=0.65p ps=3.02u w=2.5u l=1u
X18 VBP.t28 VDD.t3 VDD.t5 VDD.t4 pfet_03v3 ad=1.3p pd=5.52u as=2.2p ps=10.88u w=5u l=1u
X19 VB2.t6 VBP.t32 VDD.t49 VDD.t48 pfet_03v3 ad=1.3p pd=5.52u as=1.3p ps=5.52u w=5u l=1u
X20 VDD.t17 VDD.t15 VDD.t17 VDD.t16 pfet_03v3 ad=0.52p pd=2.52u as=0 ps=0 w=2u l=0.5u
X21 nrb.0.t2 enb.0.t3 VDD.t55 VDD.t54 pfet_03v3 ad=1.3p pd=5.52u as=1.3p ps=5.52u w=5u l=0.5u
X22 rf_m1.0.t0 vf.0.t2 VSS.t58 ppolyf_u_1k r_width=2u r_length=23.07u
X23 VSS.t4 VREF.t2 VSS.t4 VSS.t3 nfet_03v3 ad=8.8p pd=40.88u as=0 ps=0 w=20u l=25.13u
X24 vf.0.t1 VB2.t0 VB2.t1 VSS.t32 nfet_03v3 ad=2.0566p pd=8.43u as=2.0566p ps=8.43u w=7.91u l=0.5u
X25 VBN.t12 VSS.t16 VSS.t17 VSS.t11 nfet_03v3 ad=0.52p pd=2.52u as=0.88p ps=4.88u w=2u l=0.5u
X26 rdt_m2.0.t1 rdt_m1.0.t1 VSS.t70 ppolyf_u_1k r_width=2u r_length=21.01u
X27 rb_m3.0.t0 rb_m2.0.t0 VSS.t0 ppolyf_u_1k r_width=2u r_length=22.27u
X28 VDD.t25 VBP.t4 VBP.t5 VDD.t24 pfet_03v3 ad=1.3p pd=5.52u as=1.3p ps=5.52u w=5u l=1u
X29 nrb.0.t7 enb.0.t7 VDD.t66 VDD.t65 pfet_03v3 ad=1.3p pd=5.52u as=1.3p ps=5.52u w=5u l=0.5u
X30 VSS.t42 VBN.t3 VBN.t4 VSS.t41 nfet_03v3 ad=0.65p pd=3.02u as=0.65p ps=3.02u w=2.5u l=1u
X31 VDD.t29 VBP.t20 VBP.t21 VDD.t28 pfet_03v3 ad=1.3p pd=5.52u as=1.3p ps=5.52u w=5u l=1u
X32 VDD.t53 VBP.t8 VBP.t9 VDD.t52 pfet_03v3 ad=1.3p pd=5.52u as=1.3p ps=5.52u w=5u l=1u
X33 VSS.t79 EN.t4 nmid.0.t3 VSS.t33 nfet_03v3 ad=1.3p pd=5.52u as=1.3p ps=5.52u w=5u l=0.5u
X34 VBN.t13 VSS.t23 VSS.t25 VSS.t24 nfet_03v3 ad=0.65p pd=3.02u as=1.1p ps=5.88u w=2.5u l=1u
X35 VSS.t34 enb.0.t12 VBN.t0 VSS.t33 nfet_03v3 ad=0.52p pd=2.52u as=0.52p ps=2.52u w=2u l=0.5u
X36 rdb_m2.0.t1 rdb_m1.0.t1 VSS.t68 ppolyf_u_1k r_width=2u r_length=19.26u
X37 VDD.t74 enb.0.t4 nrb.0.t10 VDD.t73 pfet_03v3 ad=1.3p pd=5.52u as=1.3p ps=5.52u w=5u l=0.5u
X38 VSS.t46 VBN.t17 VBP.t27 VSS.t45 nfet_03v3 ad=0.65p pd=3.02u as=0.65p ps=3.02u w=2.5u l=1u
X39 VDD.t35 VBP.t33 VB2.t7 VDD.t34 pfet_03v3 ad=1.3p pd=5.52u as=1.3p ps=5.52u w=5u l=1u
X40 VDD.t61 enb.0.t6 nrb.0.t5 VDD.t60 pfet_03v3 ad=1.3p pd=5.52u as=1.3p ps=5.52u w=5u l=0.5u
X41 VBP.t11 VBP.t10 VDD.t43 VDD.t42 pfet_03v3 ad=1.3p pd=5.52u as=1.3p ps=5.52u w=5u l=1u
X42 rb_m3.0.t1 VBN.t11 VSS.t57 ppolyf_u_1k r_width=2u r_length=22.27u
X43 VDD.t11 VDD.t9 VDD.t11 VDD.t10 pfet_03v3 ad=0.65p pd=3.02u as=0 ps=0 w=2.5u l=0.28u
X44 VSS.t9 VSS.t8 VSS.t9 VSS.t6 nfet_03v3 ad=0.52p pd=2.52u as=0 ps=0 w=2u l=0.5u
X45 VB2.t3 VSS.t13 VSS.t15 VSS.t14 nfet_03v3 ad=2.0566p pd=8.43u as=3.4804p ps=16.7u w=7.91u l=0.5u
X46 VBP.t25 VBN.t16 VSS.t48 VSS.t47 nfet_03v3 ad=0.65p pd=3.02u as=0.65p ps=3.02u w=2.5u l=1u
X47 VSS.t22 VSS.t20 nmid.0.t2 VSS.t21 nfet_03v3 ad=2.2p pd=10.88u as=1.3p ps=5.52u w=5u l=0.5u
X48 VDD.t45 VBP.t12 VBP.t13 VDD.t44 pfet_03v3 ad=1.3p pd=5.52u as=1.3p ps=5.52u w=5u l=1u
X49 nmid.0.t1 VSS.t18 VSS.t19 VSS.t11 nfet_03v3 ad=1.3p pd=5.52u as=2.2p ps=10.88u w=5u l=0.5u
X50 rdt_m2.0.t0 rdt_m3.0.t0 VSS.t35 ppolyf_u_1k r_width=2u r_length=21.01u
X51 VDD.t57 enb.0.t10 nrb.0.t3 VDD.t56 pfet_03v3 ad=1.3p pd=5.52u as=1.3p ps=5.52u w=5u l=0.5u
X52 rb_m1.0.t0 rb_m2.0.t1 VSS.t69 ppolyf_u_1k r_width=2u r_length=22.27u
X53 VBP.t19 VBP.t18 VDD.t41 VDD.t40 pfet_03v3 ad=1.3p pd=5.52u as=1.3p ps=5.52u w=5u l=1u
X54 VDD.t2 VDD.t0 VDD.t2 VDD.t1 pfet_03v3 ad=1.3p pd=5.52u as=0 ps=0 w=5u l=1u
X55 VDD.t23 VDD.t21 nrb.0.t1 VDD.t22 pfet_03v3 ad=2.2p pd=10.88u as=1.3p ps=5.52u w=5u l=0.5u
X56 VSS.t38 VBN.t9 VBN.t10 VSS.t37 nfet_03v3 ad=0.65p pd=3.02u as=0.65p ps=3.02u w=2.5u l=1u
X57 VBP.t24 VBN.t14 VSS.t56 VSS.t55 nfet_03v3 ad=0.65p pd=3.02u as=0.65p ps=3.02u w=2.5u l=1u
X58 VBP.t1 VBP.t0 VDD.t37 VDD.t36 pfet_03v3 ad=1.3p pd=5.52u as=1.3p ps=5.52u w=5u l=1u
X59 VDD.t51 VBP.t31 VB2.t5 VDD.t50 pfet_03v3 ad=1.3p pd=5.52u as=1.3p ps=5.52u w=5u l=1u
X60 VDD.t70 EN.t1 VBP.t30 VDD.t69 pfet_03v3 ad=0.52p pd=2.52u as=0.52p ps=2.52u w=2u l=0.5u
X61 VSS.t28 VSS.t26 vf.0.t0 VSS.t27 nfet_03v3 ad=3.4804p pd=16.7u as=2.0566p ps=8.43u w=7.91u l=0.5u
X62 rb_m1.0.t1 nrb.0.t9 VSS.t82 ppolyf_u_1k r_width=2u r_length=22.27u
X63 VB2.t2 VSS.t10 VSS.t12 VSS.t11 nfet_03v3 ad=0.52p pd=2.52u as=0.88p ps=4.88u w=2u l=0.5u
X64 VBN.t8 VBN.t7 VSS.t52 VSS.t51 nfet_03v3 ad=0.65p pd=3.02u as=0.65p ps=3.02u w=2.5u l=1u
X65 VSS.t65 VSS.t66 VSS.t64 ppolyf_u_1k r_width=2u r_length=22.27u
X66 VDD.t72 EN.t2 enb.0.t1 VDD.t71 pfet_03v3 ad=0.65p pd=3.02u as=0.65p ps=3.02u w=2.5u l=0.28u
X67 VREF.t0 rdb_m1.0.t0 VSS.t1 ppolyf_u_1k r_width=2u r_length=19.26u
X68 VBP.t7 VBP.t6 VDD.t27 VDD.t26 pfet_03v3 ad=1.3p pd=5.52u as=1.3p ps=5.52u w=5u l=1u
X69 VBP.t17 VBP.t16 VDD.t47 VDD.t46 pfet_03v3 ad=1.3p pd=5.52u as=1.3p ps=5.52u w=5u l=1u
X70 nmid.0.t4 EN.t3 VSS.t80 VSS.t6 nfet_03v3 ad=1.3p pd=5.52u as=1.3p ps=5.52u w=5u l=0.5u
X71 enb.0.t0 VDD.t6 VDD.t8 VDD.t7 pfet_03v3 ad=0.65p pd=3.02u as=1.1p ps=5.88u w=2.5u l=0.28u
X72 VDD.t68 enb.0.t8 nrb.0.t8 VDD.t67 pfet_03v3 ad=1.3p pd=5.52u as=1.3p ps=5.52u w=5u l=0.5u
X73 VSS.t72 VSS.t73 VSS.t71 ppolyf_u_1k r_width=2u r_length=21.01u
X74 VBP.t23 VBN.t18 VSS.t44 VSS.t43 nfet_03v3 ad=0.65p pd=3.02u as=0.65p ps=3.02u w=2.5u l=1u
X75 VB2.t4 VBP.t34 VDD.t33 VDD.t32 pfet_03v3 ad=1.3p pd=5.52u as=1.3p ps=5.52u w=5u l=1u
X76 VSS.t83 enb.0.t11 VB2.t8 VSS.t33 nfet_03v3 ad=0.52p pd=2.52u as=0.52p ps=2.52u w=2u l=0.5u
X77 VDD.t64 rdt_m1.0.t0 VSS.t36 ppolyf_u_1k r_width=2u r_length=21.01u
R0 EN.n0 EN.t4 49.154
R1 EN.n0 EN.t3 48.7548
R2 EN EN.t2 47.57
R3 EN EN.t0 27.7973
R4 EN EN.t1 27.4653
R5 EN.n1 EN 6.61871
R6 EN.n3 EN 6.16871
R7 EN.n1 EN 5.23014
R8 EN.n2 EN 5.09514
R9 EN EN.n3 2.90621
R10 EN EN.n2 1.36014
R11 EN EN.n1 1.21871
R12 EN.n3 EN 0.656214
R13 EN EN.n0 0.352674
R14 EN.n2 EN 0.1355
R15 VREF VREF.n0 6.05621
R16 VREF VREF.t2 6.04352
R17 VREF VREF.t0 3.57
R18 VREF VREF.t1 3.57
R19 VREF.n0 VREF 2.23121
R20 VREF.n0 VREF 1.33121
R21 VBN.n1 VBN.t9 15.9196
R22 VBN.n1 VBN.t1 15.3248
R23 VBN.n2 VBN.t3 15.3248
R24 VBN.n3 VBN.t18 15.3248
R25 VBN.n4 VBN.t17 15.3248
R26 VBN.n5 VBN.t16 15.3248
R27 VBN.n6 VBN.t15 15.3248
R28 VBN.n7 VBN.t7 15.3248
R29 VBN.n8 VBN.t5 15.3248
R30 VBN.n9 VBN.t14 15.3248
R31 VBN VBN.n16 13.1051
R32 VBN VBN.n9 10.329
R33 VBN.n15 VBN 9.0005
R34 VBN.n13 VBN 9.0005
R35 VBN.n11 VBN 9.0005
R36 VBN VBN.n17 6.28121
R37 VBN.n17 VBN 5.83121
R38 VBN.n16 VBN 5.26871
R39 VBN VBN.t11 3.57
R40 VBN.n11 VBN 2.65871
R41 VBN VBN.n11 1.9355
R42 VBN VBN.n0 1.66746
R43 VBN VBN.n14 1.47767
R44 VBN VBN.n12 1.47767
R45 VBN VBN.n10 1.47767
R46 VBN.n13 VBN 0.958357
R47 VBN.n15 VBN.n13 0.939071
R48 VBN.n0 VBN.t0 0.8195
R49 VBN.n0 VBN.t12 0.8195
R50 VBN VBN.n15 0.807286
R51 VBN.n16 VBN 0.656214
R52 VBN.n14 VBN.t10 0.6557
R53 VBN.n14 VBN.t13 0.6557
R54 VBN.n12 VBN.t4 0.6557
R55 VBN.n12 VBN.t2 0.6557
R56 VBN.n10 VBN.t6 0.6557
R57 VBN.n10 VBN.t8 0.6557
R58 VBN.n9 VBN.n8 0.595283
R59 VBN.n8 VBN.n7 0.595283
R60 VBN.n7 VBN.n6 0.595283
R61 VBN.n5 VBN.n4 0.595283
R62 VBN.n4 VBN.n3 0.595283
R63 VBN.n3 VBN.n2 0.595283
R64 VBN.n2 VBN.n1 0.595283
R65 VBN.n17 VBN 0.543714
R66 VBN VBN.n5 0.39963
R67 VBN.n6 VBN 0.196152
R68 VB2 VB2.t0 70.5496
R69 VB2.n7 VB2 11.3887
R70 VB2.n2 VB2 9.0005
R71 VB2.n7 VB2 8.83014
R72 VB2.n6 VB2 5.79264
R73 VB2 VB2.n4 5.25104
R74 VB2 VB2.n2 2.65068
R75 VB2.n2 VB2 1.9355
R76 VB2 VB2.n7 1.78121
R77 VB2 VB2.n5 1.66746
R78 VB2.n4 VB2 1.59318
R79 VB2.n6 VB2 1.24121
R80 VB2.n5 VB2.t8 0.8195
R81 VB2.n5 VB2.t2 0.8195
R82 VB2 VB2.n1 0.737674
R83 VB2 VB2.n0 0.737674
R84 VB2 VB2.n3 0.463045
R85 VB2.n1 VB2.t7 0.3645
R86 VB2.n1 VB2.t4 0.3645
R87 VB2.n0 VB2.t5 0.3645
R88 VB2.n0 VB2.t6 0.3645
R89 VB2.n3 VB2.t1 0.20758
R90 VB2.n3 VB2.t3 0.20758
R91 VB2.n4 VB2 0.161214
R92 VB2 VB2.n6 0.138714
R93 VBP.n7 VBP.t4 25.0446
R94 VBP.n7 VBP.t6 24.4498
R95 VBP.n8 VBP.t20 24.4498
R96 VBP.n9 VBP.t34 24.4498
R97 VBP.n10 VBP.t33 24.4498
R98 VBP.n11 VBP.t0 24.4498
R99 VBP.n12 VBP.t2 24.4498
R100 VBP.n13 VBP.t18 24.4498
R101 VBP.n14 VBP.t14 24.4498
R102 VBP.n15 VBP.t10 24.4498
R103 VBP.n16 VBP.t12 24.4498
R104 VBP.n17 VBP.t32 24.4498
R105 VBP.n18 VBP.t31 24.4498
R106 VBP.n19 VBP.t16 24.4498
R107 VBP.n20 VBP.t8 24.4498
R108 VBP.n33 VBP 10.8937
R109 VBP VBP.n20 10.4503
R110 VBP VBP.n6 9.95836
R111 VBP.n32 VBP 9.0005
R112 VBP.n30 VBP 9.0005
R113 VBP.n28 VBP 9.0005
R114 VBP.n26 VBP 9.0005
R115 VBP.n24 VBP 9.0005
R116 VBP.n22 VBP 9.0005
R117 VBP.n4 VBP 9.0005
R118 VBP.n2 VBP 9.0005
R119 VBP.n33 VBP 6.43389
R120 VBP.n6 VBP 5.44068
R121 VBP VBP.n4 2.68443
R122 VBP.n22 VBP 2.67157
R123 VBP VBP.n32 2.01104
R124 VBP.n24 VBP.n22 1.91621
R125 VBP.n30 VBP.n28 1.91621
R126 VBP VBP.n3 1.47767
R127 VBP VBP.n1 1.47767
R128 VBP VBP.n0 1.47767
R129 VBP VBP.n5 1.39246
R130 VBP.n26 VBP.n24 0.939071
R131 VBP.n32 VBP.n30 0.939071
R132 VBP.n4 VBP.n2 0.939071
R133 VBP.n5 VBP.t30 0.9105
R134 VBP.n5 VBP.t22 0.9105
R135 VBP VBP.n31 0.737674
R136 VBP VBP.n29 0.737674
R137 VBP VBP.n27 0.737674
R138 VBP VBP.n25 0.737674
R139 VBP VBP.n23 0.737674
R140 VBP VBP.n21 0.737674
R141 VBP.n3 VBP.t27 0.6557
R142 VBP.n3 VBP.t23 0.6557
R143 VBP.n1 VBP.t26 0.6557
R144 VBP.n1 VBP.t25 0.6557
R145 VBP.n0 VBP.t29 0.6557
R146 VBP.n0 VBP.t24 0.6557
R147 VBP.n20 VBP.n19 0.595283
R148 VBP.n19 VBP.n18 0.595283
R149 VBP.n18 VBP.n17 0.595283
R150 VBP.n17 VBP.n16 0.595283
R151 VBP.n16 VBP.n15 0.595283
R152 VBP.n14 VBP.n13 0.595283
R153 VBP.n13 VBP.n12 0.595283
R154 VBP.n12 VBP.n11 0.595283
R155 VBP.n11 VBP.n10 0.595283
R156 VBP.n10 VBP.n9 0.595283
R157 VBP.n9 VBP.n8 0.595283
R158 VBP.n8 VBP.n7 0.595283
R159 VBP VBP.n26 0.469786
R160 VBP.n28 VBP 0.469786
R161 VBP.n2 VBP 0.469786
R162 VBP.n15 VBP 0.430935
R163 VBP.n31 VBP.t5 0.3645
R164 VBP.n31 VBP.t28 0.3645
R165 VBP.n29 VBP.t21 0.3645
R166 VBP.n29 VBP.t7 0.3645
R167 VBP.n27 VBP.t3 0.3645
R168 VBP.n27 VBP.t1 0.3645
R169 VBP.n25 VBP.t15 0.3645
R170 VBP.n25 VBP.t19 0.3645
R171 VBP.n23 VBP.t13 0.3645
R172 VBP.n23 VBP.t11 0.3645
R173 VBP.n21 VBP.t9 0.3645
R174 VBP.n21 VBP.t17 0.3645
R175 VBP VBP.n14 0.164848
R176 VBP.n6 VBP 0.148357
R177 VBP VBP.n33 0.0937143
R178 VDD.t16 VDD.n41 490.897
R179 VDD.n42 VDD.t13 490.897
R180 VDD.n71 VDD.t10 437.187
R181 VDD.t7 VDD.n70 437.187
R182 VDD.t1 VDD.n2 356.781
R183 VDD.t4 VDD.n3 356.781
R184 VDD.n81 VDD.n3 341.075
R185 VDD.n80 VDD.n3 341.075
R186 VDD.n80 VDD.n2 341.075
R187 VDD.n81 VDD.n2 341.075
R188 VDD.n54 VDD.t22 329.368
R189 VDD.t19 VDD.n52 329.368
R190 VDD.n54 VDD.n49 204.226
R191 VDD.n54 VDD.n51 204.226
R192 VDD.n52 VDD.n49 204.226
R193 VDD.n52 VDD.n51 204.226
R194 VDD.t69 VDD.t16 166.667
R195 VDD.t13 VDD.t69 166.667
R196 VDD.t52 VDD.t1 166.667
R197 VDD.t46 VDD.t52 166.667
R198 VDD.t50 VDD.t46 166.667
R199 VDD.t48 VDD.t50 166.667
R200 VDD.t44 VDD.t48 166.667
R201 VDD.t42 VDD.t44 166.667
R202 VDD.t30 VDD.t42 166.667
R203 VDD.t40 VDD.t30 166.667
R204 VDD.t40 VDD.t38 166.667
R205 VDD.t38 VDD.t36 166.667
R206 VDD.t36 VDD.t34 166.667
R207 VDD.t34 VDD.t32 166.667
R208 VDD.t32 VDD.t28 166.667
R209 VDD.t28 VDD.t26 166.667
R210 VDD.t26 VDD.t24 166.667
R211 VDD.t24 VDD.t4 166.667
R212 VDD.t10 VDD.t71 120.847
R213 VDD.t71 VDD.t7 120.847
R214 VDD.n41 VDD.n33 115.501
R215 VDD.n41 VDD.n34 115.501
R216 VDD.n42 VDD.n33 115.501
R217 VDD.n42 VDD.n34 115.501
R218 VDD.n71 VDD.n25 114.1
R219 VDD.n71 VDD.n26 114.1
R220 VDD.n70 VDD.n25 114.1
R221 VDD.n70 VDD.n26 114.1
R222 VDD.t22 VDD.t54 111.843
R223 VDD.t54 VDD.t73 111.843
R224 VDD.t73 VDD.t62 111.843
R225 VDD.t62 VDD.t60 111.843
R226 VDD.t65 VDD.t67 111.843
R227 VDD.t67 VDD.t58 111.843
R228 VDD.t58 VDD.t56 111.843
R229 VDD.t56 VDD.t19 111.843
R230 VDD.t60 VDD.n53 55.9216
R231 VDD.n53 VDD.t65 55.9216
R232 VDD.n50 VDD.t18 49.8583
R233 VDD.n48 VDD.t21 49.8583
R234 VDD.n24 VDD.t9 48.0826
R235 VDD.n69 VDD.t6 48.0826
R236 VDD.n40 VDD.t15 27.9583
R237 VDD.n43 VDD.t12 27.9583
R238 VDD.n4 VDD.t0 25.6511
R239 VDD.n79 VDD.t3 25.6511
R240 VDD.n77 VDD.n76 20.7645
R241 VDD VDD.n64 9.61764
R242 VDD.n6 VDD 9.4505
R243 VDD VDD.n37 9.28978
R244 VDD VDD.n23 9.0005
R245 VDD.n74 VDD 9.0005
R246 VDD.n37 VDD 9.0005
R247 VDD.n35 VDD 9.0005
R248 VDD.n58 VDD 9.0005
R249 VDD.n60 VDD 9.0005
R250 VDD.n62 VDD 9.0005
R251 VDD.n64 VDD 9.0005
R252 VDD.n56 VDD 9.0005
R253 VDD.n6 VDD 9.0005
R254 VDD.n8 VDD 9.0005
R255 VDD.n10 VDD 9.0005
R256 VDD.n12 VDD 9.0005
R257 VDD.n14 VDD 9.0005
R258 VDD.n16 VDD 9.0005
R259 VDD.n18 VDD 9.0005
R260 VDD.n20 VDD 9.0005
R261 VDD VDD.n78 9.0005
R262 VDD.n76 VDD 6.28121
R263 VDD.n31 VDD.n22 6.26193
R264 VDD VDD.n77 5.49371
R265 VDD VDD.n0 5.42045
R266 VDD.n28 VDD 5.38121
R267 VDD.n75 VDD 5.18354
R268 VDD VDD.n28 4.98161
R269 VDD VDD.n67 4.93121
R270 VDD.n30 VDD 4.93121
R271 VDD.n45 VDD 4.93121
R272 VDD.n67 VDD 4.93121
R273 VDD VDD.n46 4.93121
R274 VDD.n21 VDD 4.93121
R275 VDD VDD.n0 4.93121
R276 VDD VDD.n22 4.59371
R277 VDD.n68 VDD 4.5005
R278 VDD VDD.n29 4.5005
R279 VDD VDD.n44 4.5005
R280 VDD.n39 VDD 4.5005
R281 VDD.n47 VDD 4.5005
R282 VDD VDD.n66 4.5005
R283 VDD.n82 VDD 4.5005
R284 VDD VDD.n1 4.5005
R285 VDD VDD.n83 4.5005
R286 VDD VDD.n4 4.028
R287 VDD VDD.n79 4.028
R288 VDD VDD.t64 3.57
R289 VDD.n83 VDD.n82 3.388
R290 VDD.n82 VDD.n1 3.388
R291 VDD VDD.t17 2.30246
R292 VDD VDD.t14 2.30246
R293 VDD VDD.n48 2.073
R294 VDD VDD.n50 2.073
R295 VDD VDD.t11 1.86046
R296 VDD VDD.t8 1.86046
R297 VDD.n38 VDD 1.5705
R298 VDD.n72 VDD 1.5505
R299 VDD.n83 VDD 1.4705
R300 VDD.n47 VDD 1.438
R301 VDD.n66 VDD 1.438
R302 VDD VDD.n36 1.39246
R303 VDD.n55 VDD.n47 1.3905
R304 VDD.n73 VDD 1.13246
R305 VDD VDD.n65 1.0905
R306 VDD VDD.t20 0.976457
R307 VDD VDD.t23 0.976457
R308 VDD.n78 VDD.n20 0.939071
R309 VDD.n20 VDD.n18 0.939071
R310 VDD.n18 VDD.n16 0.939071
R311 VDD.n16 VDD.n14 0.939071
R312 VDD.n12 VDD.n10 0.939071
R313 VDD.n10 VDD.n8 0.939071
R314 VDD.n8 VDD.n6 0.939071
R315 VDD.n36 VDD.t17 0.9105
R316 VDD.n36 VDD.t70 0.9105
R317 VDD.t2 VDD 0.8845
R318 VDD VDD.t5 0.8845
R319 VDD VDD.n48 0.8455
R320 VDD.n50 VDD 0.8455
R321 VDD.n79 VDD 0.8455
R322 VDD.n4 VDD 0.8455
R323 VDD VDD.n72 0.826152
R324 VDD.n27 VDD 0.826152
R325 VDD.n38 VDD 0.826152
R326 VDD VDD.n32 0.826152
R327 VDD VDD.n55 0.826152
R328 VDD.n65 VDD 0.826152
R329 VDD.n27 VDD 0.778
R330 VDD VDD.n74 0.760679
R331 VDD.t11 VDD.n73 0.7285
R332 VDD.n73 VDD.t72 0.7285
R333 VDD VDD.n32 0.7155
R334 VDD VDD.n12 0.714071
R335 VDD VDD.n42 0.7005
R336 VDD.n41 VDD 0.7005
R337 VDD.n70 VDD 0.6305
R338 VDD VDD.n71 0.6305
R339 VDD.n69 VDD.n68 0.6255
R340 VDD.n29 VDD.n24 0.6255
R341 VDD.n44 VDD.n43 0.6255
R342 VDD.n40 VDD.n39 0.6255
R343 VDD.n64 VDD.n62 0.617643
R344 VDD.n60 VDD.n58 0.617643
R345 VDD.n58 VDD.n56 0.617643
R346 VDD VDD.n57 0.612457
R347 VDD VDD.n59 0.612457
R348 VDD VDD.n61 0.612457
R349 VDD VDD.n63 0.612457
R350 VDD.n39 VDD 0.5455
R351 VDD.n44 VDD 0.5455
R352 VDD.n35 VDD 0.545321
R353 VDD VDD.n69 0.533
R354 VDD VDD.n24 0.533
R355 VDD.n78 VDD 0.52925
R356 VDD VDD.n5 0.5205
R357 VDD VDD.n7 0.5205
R358 VDD VDD.n9 0.5205
R359 VDD VDD.n11 0.5205
R360 VDD VDD.n13 0.5205
R361 VDD VDD.n15 0.5205
R362 VDD VDD.n17 0.5205
R363 VDD VDD.n19 0.5205
R364 VDD.n56 VDD 0.519607
R365 VDD VDD.n35 0.473
R366 VDD.n43 VDD 0.4705
R367 VDD VDD.n40 0.4705
R368 VDD.n29 VDD 0.463
R369 VDD.n68 VDD 0.463
R370 VDD VDD.n54 0.4205
R371 VDD.n52 VDD 0.4205
R372 VDD VDD.n3 0.4205
R373 VDD.n2 VDD 0.4205
R374 VDD VDD.n26 0.39425
R375 VDD.t71 VDD.n26 0.39425
R376 VDD.n25 VDD 0.39425
R377 VDD.t71 VDD.n25 0.39425
R378 VDD VDD.n0 0.37814
R379 VDD.n57 VDD.t55 0.3645
R380 VDD.n57 VDD.t74 0.3645
R381 VDD.n59 VDD.t63 0.3645
R382 VDD.n59 VDD.t61 0.3645
R383 VDD.n61 VDD.t66 0.3645
R384 VDD.n61 VDD.t68 0.3645
R385 VDD.n63 VDD.t59 0.3645
R386 VDD.n63 VDD.t57 0.3645
R387 VDD.n5 VDD.t2 0.3645
R388 VDD.n5 VDD.t53 0.3645
R389 VDD.n7 VDD.t47 0.3645
R390 VDD.n7 VDD.t51 0.3645
R391 VDD.n9 VDD.t49 0.3645
R392 VDD.n9 VDD.t45 0.3645
R393 VDD.n11 VDD.t43 0.3645
R394 VDD.n11 VDD.t31 0.3645
R395 VDD.n13 VDD.t41 0.3645
R396 VDD.n13 VDD.t39 0.3645
R397 VDD.n15 VDD.t37 0.3645
R398 VDD.n15 VDD.t35 0.3645
R399 VDD.n17 VDD.t33 0.3645
R400 VDD.n17 VDD.t29 0.3645
R401 VDD.n19 VDD.t27 0.3645
R402 VDD.n19 VDD.t25 0.3645
R403 VDD.n75 VDD.n22 0.357286
R404 VDD.n34 VDD 0.3505
R405 VDD.t69 VDD.n34 0.3505
R406 VDD VDD.n33 0.3505
R407 VDD.t69 VDD.n33 0.3505
R408 VDD.n62 VDD 0.309071
R409 VDD VDD.n60 0.309071
R410 VDD.n66 VDD 0.2905
R411 VDD VDD.n1 0.2905
R412 VDD.n14 VDD 0.2255
R413 VDD.n74 VDD.n23 0.219071
R414 VDD.n76 VDD 0.206214
R415 VDD.n51 VDD 0.191409
R416 VDD.n53 VDD.n51 0.191409
R417 VDD.n49 VDD 0.191409
R418 VDD.n53 VDD.n49 0.191409
R419 VDD.n37 VDD 0.145143
R420 VDD VDD.n75 0.121036
R421 VDD.n45 VDD.n31 0.1193
R422 VDD VDD.n30 0.11714
R423 VDD.n67 VDD 0.11318
R424 VDD.n21 VDD 0.1121
R425 VDD VDD.n23 0.109786
R426 VDD.n80 VDD 0.0959545
R427 VDD.t40 VDD.n80 0.0959545
R428 VDD.n82 VDD.n81 0.0959545
R429 VDD.n81 VDD.t40 0.0959545
R430 VDD.n77 VDD.n21 0.0905
R431 VDD.n46 VDD.n28 0.08834
R432 VDD VDD.n27 0.0805
R433 VDD.n72 VDD 0.0805
R434 VDD VDD.n32 0.0805
R435 VDD VDD.n38 0.0805
R436 VDD.n55 VDD 0.0805
R437 VDD.n65 VDD 0.0805
R438 VDD.n31 VDD 0.0257
R439 VDD.n30 VDD 0.02246
R440 VDD.n46 VDD.n45 0.02066
R441 VSS.n157 VSS.n156 137020
R442 VSS.n119 VSS.n70 97281
R443 VSS.n158 VSS.n157 37830
R444 VSS.n155 VSS.n154 14306
R445 VSS.n155 VSS.n6 10300.5
R446 VSS.n159 VSS.n158 9652.59
R447 VSS.n156 VSS.n155 4820.07
R448 VSS.n156 VSS.n5 2883.8
R449 VSS.t74 VSS.t62 1725.9
R450 VSS.t62 VSS.t58 1725.9
R451 VSS.t58 VSS.t57 1725.9
R452 VSS.t69 VSS.t0 1725.9
R453 VSS.n158 VSS.t57 1651.55
R454 VSS.n116 VSS.n71 615.806
R455 VSS.n116 VSS.n89 615.806
R456 VSS.n94 VSS.n89 615.806
R457 VSS.n94 VSS.n71 615.806
R458 VSS.n38 VSS.n37 566.049
R459 VSS.n159 VSS.n3 552.319
R460 VSS.n159 VSS.n2 552.319
R461 VSS.n103 VSS.n3 552.222
R462 VSS.n103 VSS.n2 552.222
R463 VSS.n87 VSS.n73 516.932
R464 VSS.n87 VSS.n75 516.932
R465 VSS.n75 VSS.n72 516.932
R466 VSS.n73 VSS.n72 516.932
R467 VSS.n44 VSS.n43 511.365
R468 VSS.n44 VSS.t14 382.103
R469 VSS.n43 VSS.t77 366.478
R470 VSS.n154 VSS.t77 366.478
R471 VSS.n118 VSS.n117 329.67
R472 VSS.t27 VSS.n5 282.671
R473 VSS.n34 VSS.n13 274.75
R474 VSS.n34 VSS.n14 274.75
R475 VSS.n27 VSS.n14 274.75
R476 VSS.n27 VSS.n13 274.75
R477 VSS.n26 VSS.t74 181.202
R478 VSS.n37 VSS.t64 181.202
R479 VSS.n45 VSS.n10 179.764
R480 VSS.n45 VSS.n40 179.764
R481 VSS.n40 VSS.n39 179.764
R482 VSS.n39 VSS.n10 179.764
R483 VSS.t64 VSS.n36 167.46
R484 VSS.n142 VSS.n54 161.389
R485 VSS.n142 VSS.n141 161.389
R486 VSS.n141 VSS.n55 161.389
R487 VSS.n55 VSS.n54 161.389
R488 VSS.t82 VSS.n35 145.18
R489 VSS.t32 VSS.t27 144.887
R490 VSS.t14 VSS.t32 144.887
R491 VSS.t81 VSS.t59 133.096
R492 VSS.t1 VSS.t81 133.096
R493 VSS.t68 VSS.t1 133.096
R494 VSS.t2 VSS.t67 133.096
R495 VSS.t36 VSS.t2 133.096
R496 VSS.t55 VSS.t30 126.344
R497 VSS.t51 VSS.t53 126.344
R498 VSS.t49 VSS.t47 126.344
R499 VSS.t39 VSS.t37 126.344
R500 VSS.t3 VSS.t68 125.93
R501 VSS.n102 VSS.t45 124.266
R502 VSS.n139 VSS.n60 122.306
R503 VSS.n60 VSS.n58 122.306
R504 VSS.n59 VSS.n58 122.306
R505 VSS.n139 VSS.n59 122.306
R506 VSS.n65 VSS.n56 122.306
R507 VSS.n65 VSS.n57 122.306
R508 VSS.n121 VSS.n57 122.306
R509 VSS.n121 VSS.n56 122.306
R510 VSS.n158 VSS.t43 121.356
R511 VSS.t0 VSS.t39 119.694
R512 VSS.t11 VSS.n6 110.163
R513 VSS.n157 VSS.t70 99.5154
R514 VSS.t58 VSS.t51 98.0823
R515 VSS.n153 VSS.n7 90.6116
R516 VSS.n153 VSS.n8 90.6116
R517 VSS.n42 VSS.n8 90.6116
R518 VSS.n42 VSS.n7 90.6116
R519 VSS.t59 VSS.n70 89.2772
R520 VSS.n117 VSS.t71 89.2772
R521 VSS.n35 VSS.t69 88.4022
R522 VSS.t62 VSS.t55 80.6271
R523 VSS.n74 VSS.t36 74.9438
R524 VSS.n12 VSS.t26 70.98
R525 VSS.n46 VSS.t13 70.98
R526 VSS.n120 VSS.t21 68.3914
R527 VSS.n88 VSS.t35 66.5485
R528 VSS.n88 VSS.t70 66.5485
R529 VSS.n36 VSS.t82 66.1222
R530 VSS.t74 VSS.t30 63.1719
R531 VSS.t47 VSS.n25 63.1719
R532 VSS.n38 VSS.n5 58.1846
R533 VSS.n74 VSS.t71 58.1532
R534 VSS.n25 VSS.t57 52.3662
R535 VSS.n111 VSS.t20 49.737
R536 VSS.n53 VSS.t18 49.737
R537 VSS.t62 VSS.t53 45.7166
R538 VSS.t21 VSS.t6 41.7722
R539 VSS.t33 VSS.t11 41.7722
R540 VSS.n120 VSS.n119 35.6293
R541 VSS.n157 VSS.t67 33.5817
R542 VSS.t58 VSS.t49 28.2614
R543 VSS.n62 VSS.t5 27.837
R544 VSS.n137 VSS.t16 27.837
R545 VSS.n68 VSS.t10 27.837
R546 VSS.n69 VSS.t8 27.837
R547 VSS.t69 VSS.t37 24.1054
R548 VSS.n140 VSS.t6 20.8863
R549 VSS.n140 VSS.t33 20.8863
R550 VSS.n28 VSS.t29 16.4048
R551 VSS.n15 VSS.t23 16.4048
R552 VSS.t45 VSS.t57 10.8061
R553 VSS VSS.n24 9.93907
R554 VSS.n24 VSS 9.0005
R555 VSS.n22 VSS 9.0005
R556 VSS.n19 VSS 9.0005
R557 VSS.n17 VSS 9.0005
R558 VSS VSS.n33 9.0005
R559 VSS.n83 VSS 9.0005
R560 VSS VSS.n79 9.0005
R561 VSS.n81 VSS 9.0005
R562 VSS.n124 VSS 9.0005
R563 VSS VSS.n66 9.0005
R564 VSS.n144 VSS 9.0005
R565 VSS.n35 VSS.t24 8.60104
R566 VSS.n36 VSS.n34 7.94073
R567 VSS.t35 VSS.t3 7.16721
R568 VSS.n84 VSS 6.50621
R569 VSS.n119 VSS.n118 6.14339
R570 VSS.t0 VSS.n4 5.75067
R571 VSS.n31 VSS 5.61377
R572 VSS.n41 VSS.t78 5.60241
R573 VSS VSS.n0 5.27032
R574 VSS.n98 VSS 5.27032
R575 VSS VSS.n114 5.27032
R576 VSS VSS.n32 5.26871
R577 VSS.n82 VSS 5.26871
R578 VSS.n78 VSS 5.26123
R579 VSS.n82 VSS 5.15621
R580 VSS.n145 VSS 4.95371
R581 VSS.n107 VSS 4.93121
R582 VSS.n113 VSS 4.93121
R583 VSS.n109 VSS 4.93121
R584 VSS VSS.n151 4.93121
R585 VSS.n48 VSS 4.93121
R586 VSS VSS.n9 4.93121
R587 VSS.n31 VSS 4.93121
R588 VSS VSS.n135 4.93121
R589 VSS.n64 VSS 4.93121
R590 VSS.n135 VSS 4.93121
R591 VSS VSS.n64 4.93121
R592 VSS.n91 VSS 4.93121
R593 VSS VSS.n0 4.93121
R594 VSS VSS.n85 4.78657
R595 VSS.n78 VSS 4.78657
R596 VSS.n1 VSS.t65 4.55212
R597 VSS.n90 VSS.t73 4.5285
R598 VSS.n96 VSS.t61 4.5285
R599 VSS.n115 VSS 4.5005
R600 VSS VSS.n97 4.5005
R601 VSS.n95 VSS 4.5005
R602 VSS.n152 VSS 4.5005
R603 VSS VSS.n47 4.5005
R604 VSS.n11 VSS 4.5005
R605 VSS VSS.n30 4.5005
R606 VSS.n29 VSS 4.5005
R607 VSS.n136 VSS 4.5005
R608 VSS VSS.n63 4.5005
R609 VSS VSS.n76 4.5005
R610 VSS.n86 VSS 4.5005
R611 VSS VSS.n77 4.5005
R612 VSS.n67 VSS 4.5005
R613 VSS VSS.n126 4.5005
R614 VSS.n132 VSS.n131 4.5005
R615 VSS.n134 VSS.n127 4.5005
R616 VSS VSS.n108 4.5005
R617 VSS VSS.n112 4.5005
R618 VSS.n160 VSS 4.5005
R619 VSS VSS.n106 4.5005
R620 VSS VSS.n162 4.5005
R621 VSS.n146 VSS.n50 4.5005
R622 VSS.n150 VSS.n149 4.5005
R623 VSS.n92 VSS.t72 4.416
R624 VSS.n93 VSS.t60 4.416
R625 VSS.n161 VSS.t75 4.37212
R626 VSS.n158 VSS.n4 4.31325
R627 VSS VSS.n93 4.21175
R628 VSS.n105 VSS.n104 4.20675
R629 VSS.n100 VSS.n99 4.20675
R630 VSS.n151 VSS.n150 4.18577
R631 VSS.n95 VSS 4.16912
R632 VSS VSS.n115 4.16912
R633 VSS.n162 VSS 4.16412
R634 VSS.n83 VSS 4.10354
R635 VSS.n104 VSS.t66 4.101
R636 VSS.n101 VSS.t63 4.101
R637 VSS.n100 VSS.t76 4.101
R638 VSS.n131 VSS 3.67847
R639 VSS.n97 VSS.n90 3.64912
R640 VSS.n97 VSS.n96 3.64912
R641 VSS.n93 VSS 3.60675
R642 VSS VSS.n92 3.60675
R643 VSS VSS.n86 3.3455
R644 VSS.n77 VSS 3.3455
R645 VSS.n77 VSS.n76 3.28675
R646 VSS.n86 VSS.n76 3.28675
R647 VSS.n161 VSS.n160 2.83662
R648 VSS.n160 VSS.n1 2.83662
R649 VSS.n104 VSS 2.79425
R650 VSS VSS.t7 2.48646
R651 VSS VSS.t17 2.48646
R652 VSS VSS.t12 2.48646
R653 VSS.t9 VSS 2.48646
R654 VSS VSS.n29 2.3655
R655 VSS.n30 VSS 2.3655
R656 VSS.n133 VSS.n129 2.24472
R657 VSS.n134 VSS.n128 2.23795
R658 VSS.n132 VSS.n130 2.23795
R659 VSS.n147 VSS.n51 2.23795
R660 VSS.n149 VSS.n148 2.23795
R661 VSS.n51 VSS.n49 2.23795
R662 VSS.n102 VSS.t43 2.07851
R663 VSS.n129 VSS 2.07425
R664 VSS.n110 VSS 1.9955
R665 VSS VSS.n101 1.98175
R666 VSS VSS.t31 1.9157
R667 VSS VSS.t25 1.9157
R668 VSS.n80 VSS 1.66746
R669 VSS VSS.n123 1.66746
R670 VSS VSS.n61 1.493
R671 VSS VSS.t15 1.36078
R672 VSS VSS.t28 1.36078
R673 VSS VSS.n23 1.2605
R674 VSS VSS.n21 1.2605
R675 VSS VSS.n20 1.2605
R676 VSS VSS.n18 1.2605
R677 VSS VSS.n16 1.2605
R678 VSS.n46 VSS 1.20925
R679 VSS VSS.n12 1.20925
R680 VSS.n69 VSS 1.103
R681 VSS VSS.n68 1.103
R682 VSS.n143 VSS 1.0905
R683 VSS VSS.n41 1.0655
R684 VSS VSS.t22 1.05006
R685 VSS VSS.t19 1.05006
R686 VSS.n122 VSS.n67 1.0155
R687 VSS VSS.n152 0.9705
R688 VSS.n33 VSS.n17 0.939071
R689 VSS.n19 VSS.n17 0.939071
R690 VSS VSS.n19 0.939071
R691 VSS.n22 VSS 0.939071
R692 VSS.n24 VSS.n22 0.939071
R693 VSS VSS.n53 0.8455
R694 VSS.n111 VSS 0.8455
R695 VSS.t7 VSS.n80 0.8195
R696 VSS.n80 VSS.t34 0.8195
R697 VSS.n123 VSS.t9 0.8195
R698 VSS.n123 VSS.t83 0.8195
R699 VSS.n42 VSS 0.743357
R700 VSS.n43 VSS.n42 0.743357
R701 VSS.n153 VSS 0.743357
R702 VSS.n154 VSS.n153 0.743357
R703 VSS VSS.n52 0.722457
R704 VSS VSS.n138 0.7155
R705 VSS VSS.n125 0.7155
R706 VSS.n101 VSS.n100 0.713
R707 VSS VSS.n61 0.704848
R708 VSS.n138 VSS 0.704848
R709 VSS VSS.n122 0.704848
R710 VSS.n125 VSS 0.704848
R711 VSS.n110 VSS 0.704848
R712 VSS VSS.n143 0.704848
R713 VSS.n23 VSS.t56 0.6557
R714 VSS.n23 VSS.t54 0.6557
R715 VSS.n21 VSS.t52 0.6557
R716 VSS.n21 VSS.t50 0.6557
R717 VSS.n20 VSS.t48 0.6557
R718 VSS.n20 VSS.t46 0.6557
R719 VSS.n18 VSS.t44 0.6557
R720 VSS.n18 VSS.t42 0.6557
R721 VSS.n16 VSS.t40 0.6557
R722 VSS.n16 VSS.t38 0.6557
R723 VSS.n47 VSS.n46 0.6255
R724 VSS.n12 VSS.n11 0.6255
R725 VSS.n30 VSS.n15 0.6255
R726 VSS.n29 VSS.n28 0.6255
R727 VSS.n137 VSS.n136 0.6255
R728 VSS.n63 VSS.n62 0.6255
R729 VSS.n108 VSS.n53 0.6255
R730 VSS.n112 VSS.n111 0.6255
R731 VSS.n144 VSS 0.617643
R732 VSS.n108 VSS 0.5955
R733 VSS.n112 VSS 0.5955
R734 VSS VSS.n121 0.578278
R735 VSS.n121 VSS.n120 0.578278
R736 VSS VSS.n65 0.578278
R737 VSS.n65 VSS.n6 0.578278
R738 VSS VSS.n59 0.578278
R739 VSS.n120 VSS.n59 0.578278
R740 VSS VSS.n60 0.578278
R741 VSS.n60 VSS.n6 0.578278
R742 VSS VSS.n15 0.533
R743 VSS.n28 VSS 0.533
R744 VSS VSS.n144 0.530857
R745 VSS VSS.n27 0.5205
R746 VSS.n27 VSS.n26 0.5205
R747 VSS.n34 VSS 0.5205
R748 VSS VSS.n83 0.497107
R749 VSS VSS.n81 0.479429
R750 VSS VSS.n66 0.479429
R751 VSS VSS.n7 0.473227
R752 VSS.n7 VSS.t77 0.473227
R753 VSS VSS.n8 0.473227
R754 VSS.n8 VSS.t77 0.473227
R755 VSS VSS.n137 0.4705
R756 VSS.n62 VSS 0.4705
R757 VSS VSS.n69 0.4705
R758 VSS.n68 VSS 0.4705
R759 VSS.n11 VSS 0.468
R760 VSS.n47 VSS 0.468
R761 VSS.n63 VSS 0.468
R762 VSS.n136 VSS 0.468
R763 VSS.n67 VSS 0.468
R764 VSS.n126 VSS 0.468
R765 VSS.n33 VSS 0.4505
R766 VSS.n91 VSS.n0 0.42296
R767 VSS.n114 VSS.n113 0.42134
R768 VSS.n84 VSS.n82 0.4037
R769 VSS VSS.n78 0.39272
R770 VSS.n4 VSS.t41 0.386692
R771 VSS VSS.n9 0.35474
R772 VSS VSS.n55 0.347167
R773 VSS.n118 VSS.n55 0.347167
R774 VSS VSS.n142 0.347167
R775 VSS.n142 VSS.n6 0.347167
R776 VSS.n92 VSS 0.3355
R777 VSS.n52 VSS.t80 0.3281
R778 VSS.n52 VSS.t79 0.3281
R779 VSS VSS.n56 0.3255
R780 VSS.t33 VSS.n56 0.3255
R781 VSS VSS.n57 0.3255
R782 VSS.t33 VSS.n57 0.3255
R783 VSS.n139 VSS 0.3255
R784 VSS.t33 VSS.n139 0.3255
R785 VSS VSS.n58 0.3255
R786 VSS.t33 VSS.n58 0.3255
R787 VSS VSS.n10 0.3255
R788 VSS.t32 VSS.n10 0.3255
R789 VSS.n40 VSS 0.3255
R790 VSS.t32 VSS.n40 0.3255
R791 VSS.n151 VSS.n48 0.31586
R792 VSS.n107 VSS.n98 0.30596
R793 VSS.n106 VSS 0.292868
R794 VSS.n126 VSS 0.2905
R795 VSS.n81 VSS.n79 0.289786
R796 VSS.n124 VSS.n66 0.289786
R797 VSS VSS.n54 0.289389
R798 VSS.n140 VSS.n54 0.289389
R799 VSS.n141 VSS 0.289389
R800 VSS.n141 VSS.n140 0.289389
R801 VSS VSS.n45 0.248119
R802 VSS.n45 VSS.n44 0.248119
R803 VSS.n39 VSS 0.248119
R804 VSS.n39 VSS.n38 0.248119
R805 VSS.n146 VSS 0.23675
R806 VSS VSS.t4 0.2324
R807 VSS.t4 VSS 0.2324
R808 VSS.n114 VSS 0.21254
R809 VSS.n145 VSS 0.20825
R810 VSS.n152 VSS 0.1855
R811 VSS.n113 VSS.n109 0.1733
R812 VSS.n79 VSS 0.145143
R813 VSS VSS.n124 0.145143
R814 VSS.n48 VSS.n9 0.13658
R815 VSS.n135 VSS.n64 0.13658
R816 VSS.n98 VSS.n91 0.1175
R817 VSS VSS.n73 0.111138
R818 VSS.n73 VSS.n70 0.111138
R819 VSS VSS.n75 0.111138
R820 VSS.n75 VSS.n74 0.111138
R821 VSS VSS.n13 0.106622
R822 VSS.n25 VSS.n13 0.106622
R823 VSS VSS.n14 0.106622
R824 VSS.n25 VSS.n14 0.106622
R825 VSS.n135 VSS.n134 0.10382
R826 VSS.n109 VSS.n50 0.10292
R827 VSS.n32 VSS 0.1013
R828 VSS.n41 VSS 0.1005
R829 VSS.n85 VSS.n84 0.09446
R830 VSS.n82 VSS.n64 0.0905
R831 VSS.n160 VSS.n159 0.0901552
R832 VSS VSS.n103 0.0901552
R833 VSS.n103 VSS.n102 0.0901552
R834 VSS.n115 VSS.n90 0.0857632
R835 VSS.n96 VSS.n95 0.0857632
R836 VSS.n106 VSS.n1 0.0857632
R837 VSS.n162 VSS.n161 0.0857632
R838 VSS VSS.n94 0.0857459
R839 VSS.n94 VSS.n70 0.0857459
R840 VSS.n116 VSS 0.0857459
R841 VSS.n117 VSS.n116 0.0857459
R842 VSS.n105 VSS.n3 0.0857459
R843 VSS.n37 VSS.n3 0.0857459
R844 VSS.n99 VSS.n2 0.0857459
R845 VSS.n26 VSS.n2 0.0857459
R846 VSS.n32 VSS.n31 0.08402
R847 VSS.n85 VSS 0.08294
R848 VSS.n76 VSS.n72 0.08175
R849 VSS.t3 VSS.n72 0.08175
R850 VSS.n87 VSS 0.08175
R851 VSS.t3 VSS.n87 0.08175
R852 VSS.n138 VSS 0.0805
R853 VSS VSS.n61 0.0805
R854 VSS.n122 VSS 0.0805
R855 VSS.n125 VSS 0.0805
R856 VSS.n143 VSS 0.0805
R857 VSS VSS.n110 0.0805
R858 VSS VSS.n71 0.0727222
R859 VSS.n88 VSS.n71 0.0727222
R860 VSS.n97 VSS.n89 0.0727222
R861 VSS.n89 VSS.n88 0.0727222
R862 VSS.n148 VSS.n147 0.0536955
R863 VSS.n130 VSS.n128 0.0536955
R864 VSS.n148 VSS.n49 0.0536955
R865 VSS.n129 VSS.n127 0.053
R866 VSS VSS.n145 0.041
R867 VSS.n131 VSS.n128 0.0270978
R868 VSS.n130 VSS.n127 0.0270978
R869 VSS.n150 VSS.n49 0.0270978
R870 VSS.n147 VSS.n146 0.0270978
R871 VSS.n149 VSS.n51 0.0257
R872 VSS VSS.n107 0.02246
R873 VSS.n133 VSS.n132 0.0135648
R874 VSS.n134 VSS.n133 0.0135648
R875 VSS VSS.n105 0.00175
R876 VSS.n99 VSS 0.00175
R877 VSS.n149 VSS.n50 0.0014
R878 rb_m3.0.t0 rb_m3.0 3.57
R879 rb_m3.0.t1 rb_m3.0 3.57
R880 rb_m2.0 rb_m2.0.t0 3.57
R881 rb_m2.0 rb_m2.0.t1 3.57
R882 rb_m1.0.t0 rb_m1.0 3.57
R883 rb_m1.0.t1 rb_m1.0 3.57
R884 rf_m1.0.t0 rf_m1.0 3.57
R885 rf_m1.0.t1 rf_m1.0 3.57
R886 vf.0 vf.0.t2 3.57
R887 vf.0.n0 vf.0 0.463045
R888 vf.0.t1 vf.0.n0 0.20758
R889 vf.0.n0 vf.0.t0 0.20758
R890 nrb.0 nrb.0.t9 3.57
R891 nrb.0.n1 nrb.0 1.69604
R892 nrb.0.n3 nrb.0.n1 0.617643
R893 nrb.0 nrb.0.n3 0.617643
R894 nrb.0.n6 nrb.0 0.617643
R895 nrb.0 nrb.0.n6 9.61764
R896 nrb.0 nrb.0.n7 0.612457
R897 nrb.0.t0 nrb.0.n7 0.3645
R898 nrb.0.n7 nrb.0.t3 0.3645
R899 nrb.0 nrb.0.n6 9.0005
R900 nrb.0 nrb.0.n5 0.612457
R901 nrb.0.t4 nrb.0.n5 0.3645
R902 nrb.0.n5 nrb.0.t8 0.3645
R903 nrb.0 nrb.0.n4 0.612457
R904 nrb.0.t7 nrb.0.n4 0.3645
R905 nrb.0.n4 nrb.0.t5 0.3645
R906 nrb.0 nrb.0.n3 9.0005
R907 nrb.0 nrb.0.n2 0.612457
R908 nrb.0.t6 nrb.0.n2 0.3645
R909 nrb.0.n2 nrb.0.t10 0.3645
R910 nrb.0 nrb.0.n1 9.0005
R911 nrb.0 nrb.0.n0 0.612457
R912 nrb.0.t2 nrb.0.n0 0.3645
R913 nrb.0.n0 nrb.0.t1 0.3645
R914 rdb_m1.0 rdb_m1.0.t0 3.57
R915 rdb_m1.0 rdb_m1.0.t1 3.57
R916 rdt_m3.0 rdt_m3.0.t0 3.57
R917 rdt_m3.0 rdt_m3.0.t1 3.57
R918 rdb_m2.0.t0 rdb_m2.0 3.57
R919 rdb_m2.0.t1 rdb_m2.0 3.57
R920 rdb_m3.0 rdb_m3.0.t0 3.57
R921 rdb_m3.0 rdb_m3.0.t1 3.57
R922 rdt_m1.0 rdt_m1.0.t0 3.57
R923 rdt_m1.0 rdt_m1.0.t1 3.57
R924 rdt_m2.0.t0 rdt_m2.0 3.57
R925 rdt_m2.0.t1 rdt_m2.0 3.57
R926 nmid.0.t0 nmid.0 3.57
R927 nmid.0.n1 nmid.0 1.26693
R928 nmid.0 nmid.0.n1 0.309071
R929 nmid.0 nmid.0.n2 0.722457
R930 nmid.0.t1 nmid.0.n2 0.3281
R931 nmid.0.n2 nmid.0.t3 0.3281
R932 nmid.0 nmid.0.n1 9.0005
R933 nmid.0 nmid.0.n0 0.722457
R934 nmid.0.t4 nmid.0.n0 0.3281
R935 nmid.0.n0 nmid.0.t2 0.3281
R936 enb.0 enb.0.t2 4.7885
R937 enb.0 enb.0.n0 1.72336
R938 enb.0.n0 enb.0 0.122643
R939 enb.0 enb.0.n10 4.84764
R940 enb.0.n10 enb.0 0.768714
R941 enb.0 enb.0.n9 6.05621
R942 enb.0.n9 enb.0 0.177286
R943 enb.0.t11 enb.0 27.4066
R944 enb.0 enb.0.n9 4.59371
R945 enb.0.t12 enb.0 27.4066
R946 enb.0 enb.0.n10 1.33121
R947 enb.0 enb.0.n8 1.13246
R948 enb.0.t0 enb.0.n8 0.7285
R949 enb.0.n8 enb.0.t1 0.7285
R950 enb.0 enb.0.n0 4.81229
R951 enb.0.n1 enb.0.n2 0.39963
R952 enb.0.n2 enb.0.n3 0.39963
R953 enb.0.n3 enb.0.n4 0.39963
R954 enb.0.n4 enb.0.n5 0.39963
R955 enb.0.n5 enb.0 0.0122391
R956 enb.0 enb.0.n6 0.387891
R957 enb.0.n6 enb.0.n7 0.39963
R958 enb.0.n7 enb.0 10.1568
R959 enb.0.t3 enb.0.n7 48.7548
R960 enb.0.t4 enb.0.n6 48.7548
R961 enb.0.t5 enb.0.n5 48.7548
R962 enb.0.t6 enb.0.n4 48.7548
R963 enb.0.t7 enb.0.n3 48.7548
R964 enb.0.t8 enb.0.n2 48.7548
R965 enb.0.t9 enb.0.n1 48.7548
R966 enb.0.t10 enb.0.n1 49.154
C0 enb.0 rb_m1.0 0
C1 rdt_m1.0 rdb_m3.0 0.41833f
C2 nrb.0 vf.0 0.76263f
C3 VDD vf.0 0.00294f
C4 nrb.0 VDD 5.10108f
C5 VB2 VBP 5.46578f
C6 VB2 nmid.0 0.91956f
C7 VBP enb.0 1.1468f
C8 nmid.0 enb.0 0.71708f
C9 VBN vf.0 1.54524f
C10 VBN nrb.0 0.04436f
C11 VBN VDD 3.33637f
C12 rdb_m2.0 VDD 0.00594f
C13 rb_m2.0 vf.0 0.08519f
C14 VBP vf.0 0.3587f
C15 nrb.0 rb_m2.0 0.03837f
C16 VBP nrb.0 0.36246f
C17 VBP VDD 19.3599f
C18 nmid.0 VDD 0.89627f
C19 VREF VB2 0.62142f
C20 VREF enb.0 0.14548f
C21 VBN rb_m2.0 0.03954f
C22 VBN VBP 7.61409f
C23 VBN nmid.0 0.11617f
C24 VBP rb_m1.0 0.0038f
C25 rdt_m2.0 VDD 0.00209f
C26 rdt_m3.0 rdb_m1.0 0.22342f
C27 rdb_m2.0 nmid.0 0.04228f
C28 VBP nmid.0 0.03404f
C29 VREF VDD 1.71905f
C30 rdb_m2.0 rdt_m2.0 0.37f
C31 VREF VBN 0.23654f
C32 rdt_m2.0 nmid.0 0.00432f
C33 rdt_m1.0 enb.0 0.0052f
C34 VB2 EN 2.2084f
C35 EN enb.0 4.04436f
C36 VREF rdb_m2.0 0.09091f
C37 VREF VBP 0.0747f
C38 VREF nmid.0 0
C39 rdt_m3.0 rdt_m1.0 0.08167f
C40 rb_m3.0 rb_m1.0 0.06955f
C41 VB2 enb.0 2.12636f
C42 EN vf.0 0.02265f
C43 EN nrb.0 0.24322f
C44 EN VDD 3.6169f
C45 VREF rdt_m2.0 0.00234f
C46 VBN EN 0.42114f
C47 EN rb_m1.0 0.00476f
C48 VB2 vf.0 0.92899f
C49 VB2 nrb.0 0.03936f
C50 enb.0 vf.0 1.18587f
C51 VB2 VDD 6.22905f
C52 nrb.0 enb.0 0.83214f
C53 enb.0 VDD 6.17842f
C54 VBP EN 0.30684f
C55 VBN VB2 0.25785f
C56 EN nmid.0 0.59891f
C57 VBN enb.0 0.2848f
C58 rb_m3.0 rf_m1.0 0.04347f
C59 EN VSS 5.17678f
C60 VREF VSS 16.6548f
C61 VBN VSS 11.8089f
C62 VB2 VSS 6.54238f
C63 VBP VSS 3.54333f
C64 VDD VSS 53.442f
C65 rb_m3.0 VSS 1.29214f
C66 rb_m2.0 VSS 1.11889f
C67 rb_m1.0 VSS 1.26945f
C68 rf_m1.0 VSS 1.38676f
C69 vf.0 VSS 2.57318f
C70 nrb.0 VSS 1.03037f
C71 rdb_m1.0 VSS 1.03822f
C72 rdt_m3.0 VSS 1.74717f
C73 rdb_m2.0 VSS 1.79875f
C74 rdb_m3.0 VSS 1.01451f
C75 rdt_m1.0 VSS 1.55946f
C76 rdt_m2.0 VSS 1.06704f
C77 nmid.0 VSS 3.73808f
C78 enb.0 VSS 6.1125f
C79 enb.0.t2 VSS 0.0234842f
C80 enb.0.n0 VSS 0.0628414f
C81 enb.0.t10 VSS 0.130454f
C82 enb.0.t9 VSS 0.129887f
C83 enb.0.n1 VSS 0.145383f
C84 enb.0.t8 VSS 0.129887f
C85 enb.0.n2 VSS 0.0761684f
C86 enb.0.t7 VSS 0.129887f
C87 enb.0.n3 VSS 0.0761684f
C88 enb.0.t6 VSS 0.129887f
C89 enb.0.n4 VSS 0.0761684f
C90 enb.0.t5 VSS 0.129887f
C91 enb.0.n5 VSS 0.0681635f
C92 enb.0.t4 VSS 0.129887f
C93 enb.0.n6 VSS 0.0759282f
C94 enb.0.t3 VSS 0.129887f
C95 enb.0.n7 VSS 0.126313f
C96 enb.0.t0 VSS 0.0228569f
C97 enb.0.t1 VSS 0.0228569f
C98 enb.0.n8 VSS 0.0475156f
C99 enb.0.n9 VSS 0.196482f
C100 enb.0.t12 VSS 0.0512695f
C101 enb.0.t11 VSS 0.0512695f
C102 enb.0.n10 VSS 0.0712534f
C103 nmid.0.t0 VSS 0.0685602f
C104 nmid.0.t4 VSS 0.0510653f
C105 nmid.0.t2 VSS 0.0510653f
C106 nmid.0.n0 VSS 0.108264f
C107 nmid.0.n1 VSS 0.0663015f
C108 nmid.0.t1 VSS 0.0510653f
C109 nmid.0.t3 VSS 0.0510653f
C110 nmid.0.n2 VSS 0.108264f
C111 rdt_m2.0.t0 VSS 0.0574588f
C112 rdt_m2.0.t1 VSS 0.0574588f
C113 rdt_m1.0.t0 VSS 0.0514765f
C114 rdt_m1.0.t1 VSS 0.0514765f
C115 rdb_m3.0.t0 VSS 0.0612615f
C116 rdb_m3.0.t1 VSS 0.0612615f
C117 rdb_m2.0.t0 VSS 0.046393f
C118 rdb_m2.0.t1 VSS 0.046393f
C119 rdt_m3.0.t0 VSS 0.0327396f
C120 rdt_m3.0.t1 VSS 0.0327396f
C121 rdb_m1.0.t0 VSS 0.0410027f
C122 rdb_m1.0.t1 VSS 0.0410027f
C123 nrb.0.t9 VSS 0.0479488f
C124 nrb.0.t2 VSS 0.0357149f
C125 nrb.0.t1 VSS 0.0357149f
C126 nrb.0.n0 VSS 0.0764917f
C127 nrb.0.n1 VSS 0.0641988f
C128 nrb.0.t6 VSS 0.0357149f
C129 nrb.0.t10 VSS 0.0357149f
C130 nrb.0.n2 VSS 0.0764917f
C131 nrb.0.n3 VSS 0.0384198f
C132 nrb.0.t7 VSS 0.0357149f
C133 nrb.0.t5 VSS 0.0357149f
C134 nrb.0.n4 VSS 0.0764917f
C135 nrb.0.t4 VSS 0.0357149f
C136 nrb.0.t8 VSS 0.0357149f
C137 nrb.0.n5 VSS 0.0764917f
C138 nrb.0.n6 VSS 0.062567f
C139 nrb.0.t0 VSS 0.0357149f
C140 nrb.0.t3 VSS 0.0357149f
C141 nrb.0.n7 VSS 0.0764917f
C142 vf.0.t2 VSS 0.0767582f
C143 vf.0.t1 VSS 0.0904498f
C144 vf.0.t0 VSS 0.0904498f
C145 vf.0.n0 VSS 0.19747f
C146 rf_m1.0.t0 VSS 0.00774976f
C147 rf_m1.0.t1 VSS 0.00774976f
C148 rb_m1.0.t0 VSS 0.0146173f
C149 rb_m1.0.t1 VSS 0.0146173f
C150 rb_m2.0.t0 VSS 0.0315471f
C151 rb_m2.0.t1 VSS 0.0315471f
C152 rb_m3.0.t0 VSS 0.0189127f
C153 rb_m3.0.t1 VSS 0.0189127f
C154 VDD.n0 VSS 1.51639f
C155 VDD.n1 VSS 0.0791114f
C156 VDD.n2 VSS 0.728244f
C157 VDD.n3 VSS 0.728244f
C158 VDD.t1 VSS 0.6431f
C159 VDD.t52 VSS 0.409469f
C160 VDD.t46 VSS 0.409469f
C161 VDD.t50 VSS 0.409469f
C162 VDD.t48 VSS 0.409469f
C163 VDD.t44 VSS 0.409469f
C164 VDD.t42 VSS 0.409469f
C165 VDD.t30 VSS 0.409469f
C166 VDD.t4 VSS 0.6431f
C167 VDD.t24 VSS 0.409469f
C168 VDD.t26 VSS 0.409469f
C169 VDD.t28 VSS 0.409469f
C170 VDD.t32 VSS 0.409469f
C171 VDD.t34 VSS 0.409469f
C172 VDD.t36 VSS 0.409469f
C173 VDD.t38 VSS 0.409469f
C174 VDD.t0 VSS 0.111999f
C175 VDD.n4 VSS 0.171958f
C176 VDD.t3 VSS 0.111999f
C177 VDD.t5 VSS 0.0461288f
C178 VDD.t2 VSS 0.0653322f
C179 VDD.t53 VSS 0.0191971f
C180 VDD.n5 VSS 0.0384006f
C181 VDD.n6 VSS 0.0337991f
C182 VDD.t47 VSS 0.0191971f
C183 VDD.t51 VSS 0.0191971f
C184 VDD.n7 VSS 0.0384006f
C185 VDD.n8 VSS 0.0289254f
C186 VDD.t49 VSS 0.0191971f
C187 VDD.t45 VSS 0.0191971f
C188 VDD.n9 VSS 0.0384006f
C189 VDD.n10 VSS 0.0289254f
C190 VDD.t43 VSS 0.0191971f
C191 VDD.t31 VSS 0.0191971f
C192 VDD.n11 VSS 0.0384006f
C193 VDD.n12 VSS 0.0259886f
C194 VDD.t41 VSS 0.0191971f
C195 VDD.t39 VSS 0.0191971f
C196 VDD.n13 VSS 0.0384006f
C197 VDD.n14 VSS 0.0196212f
C198 VDD.t37 VSS 0.0191971f
C199 VDD.t35 VSS 0.0191971f
C200 VDD.n15 VSS 0.0384006f
C201 VDD.n16 VSS 0.0289254f
C202 VDD.t33 VSS 0.0191971f
C203 VDD.t29 VSS 0.0191971f
C204 VDD.n17 VSS 0.0384006f
C205 VDD.n18 VSS 0.0289254f
C206 VDD.t27 VSS 0.0191971f
C207 VDD.t25 VSS 0.0191971f
C208 VDD.n19 VSS 0.0384006f
C209 VDD.n20 VSS 0.0289254f
C210 VDD.n21 VSS 0.207554f
C211 VDD.n22 VSS 0.0486036f
C212 VDD.n23 VSS 0.00874092f
C213 VDD.t9 VSS 0.015564f
C214 VDD.n24 VSS 0.0567939f
C215 VDD.n25 VSS 0.0709971f
C216 VDD.n26 VSS 0.0709971f
C217 VDD.t8 VSS 0.0239948f
C218 VDD.n27 VSS 0.025786f
C219 VDD.t6 VSS 0.015564f
C220 VDD.t20 VSS 0.0496163f
C221 VDD.t23 VSS 0.0496163f
C222 VDD.n28 VSS 0.400842f
C223 VDD.n29 VSS 0.0245265f
C224 VDD.n30 VSS 0.142944f
C225 VDD.n31 VSS 0.155071f
C226 VDD.t12 VSS 0.0221023f
C227 VDD.n32 VSS 0.0244885f
C228 VDD.n33 VSS 0.0716806f
C229 VDD.n34 VSS 0.0716806f
C230 VDD.t17 VSS 0.0267481f
C231 VDD.t14 VSS 0.0190705f
C232 VDD.n35 VSS 0.017754f
C233 VDD.t70 VSS 0.00767758f
C234 VDD.n36 VSS 0.0158805f
C235 VDD.n37 VSS 0.0195199f
C236 VDD.n38 VSS 0.0434831f
C237 VDD.t15 VSS 0.0221023f
C238 VDD.n39 VSS 0.0262797f
C239 VDD.n40 VSS 0.0578319f
C240 VDD.n41 VSS 0.397443f
C241 VDD.t16 VSS 0.363821f
C242 VDD.t69 VSS 0.184389f
C243 VDD.t13 VSS 0.363821f
C244 VDD.n42 VSS 0.397443f
C245 VDD.n43 VSS 0.0576926f
C246 VDD.n44 VSS 0.026419f
C247 VDD.n45 VSS 0.143311f
C248 VDD.n46 VSS 0.111556f
C249 VDD.n47 VSS 0.0623131f
C250 VDD.t21 VSS 0.0553381f
C251 VDD.n48 VSS 0.108018f
C252 VDD.n49 VSS 0.125436f
C253 VDD.t18 VSS 0.0553381f
C254 VDD.n50 VSS 0.10798f
C255 VDD.n51 VSS 0.125436f
C256 VDD.n52 VSS 0.610865f
C257 VDD.t19 VSS 0.542089f
C258 VDD.t56 VSS 0.274779f
C259 VDD.t58 VSS 0.274779f
C260 VDD.t67 VSS 0.274779f
C261 VDD.t65 VSS 0.206079f
C262 VDD.n53 VSS 0.137386f
C263 VDD.t60 VSS 0.206079f
C264 VDD.t62 VSS 0.274779f
C265 VDD.t73 VSS 0.274779f
C266 VDD.t54 VSS 0.274779f
C267 VDD.t22 VSS 0.542089f
C268 VDD.n54 VSS 0.610865f
C269 VDD.n55 VSS 0.0390588f
C270 VDD.n56 VSS 0.0193427f
C271 VDD.t55 VSS 0.0191971f
C272 VDD.t74 VSS 0.0191971f
C273 VDD.n57 VSS 0.0411222f
C274 VDD.n58 VSS 0.0206529f
C275 VDD.t63 VSS 0.0191971f
C276 VDD.t61 VSS 0.0191971f
C277 VDD.n59 VSS 0.0411222f
C278 VDD.n60 VSS 0.0165957f
C279 VDD.t66 VSS 0.0191971f
C280 VDD.t68 VSS 0.0191971f
C281 VDD.n61 VSS 0.0411222f
C282 VDD.n62 VSS 0.0165957f
C283 VDD.t59 VSS 0.0191971f
C284 VDD.t57 VSS 0.0191971f
C285 VDD.n63 VSS 0.0411222f
C286 VDD.n64 VSS 0.0336345f
C287 VDD.n65 VSS 0.0323243f
C288 VDD.n66 VSS 0.0376284f
C289 VDD.n67 VSS 0.428774f
C290 VDD.n68 VSS 0.0246594f
C291 VDD.n69 VSS 0.0566609f
C292 VDD.n70 VSS 0.412229f
C293 VDD.t7 VSS 0.36127f
C294 VDD.t71 VSS 0.156432f
C295 VDD.t10 VSS 0.36127f
C296 VDD.n71 VSS 0.412229f
C297 VDD.n72 VSS 0.0429704f
C298 VDD.t72 VSS 0.00960173f
C299 VDD.n73 VSS 0.0199567f
C300 VDD.t11 VSS 0.0335965f
C301 VDD.n74 VSS 0.0173299f
C302 VDD.n75 VSS 0.00994984f
C303 VDD.t64 VSS 0.0257734f
C304 VDD.n76 VSS 0.285121f
C305 VDD.n77 VSS 1.78695f
C306 VDD.n78 VSS 0.0236024f
C307 VDD.n79 VSS 0.171932f
C308 VDD.n80 VSS 0.208054f
C309 VDD.t40 VSS 0.409469f
C310 VDD.n81 VSS 0.208054f
C311 VDD.n82 VSS 0.144988f
C312 VDD.n83 VSS 0.105524f
C313 VBP.t29 VSS 0.0123714f
C314 VBP.t24 VSS 0.0123714f
C315 VBP.n0 VSS 0.0267271f
C316 VBP.t26 VSS 0.0123714f
C317 VBP.t25 VSS 0.0123714f
C318 VBP.n1 VSS 0.0267271f
C319 VBP.n2 VSS 0.0294194f
C320 VBP.t27 VSS 0.0123714f
C321 VBP.t23 VSS 0.0123714f
C322 VBP.n3 VSS 0.0267271f
C323 VBP.n4 VSS 0.0662f
C324 VBP.t30 VSS 0.00989829f
C325 VBP.t22 VSS 0.00989829f
C326 VBP.n5 VSS 0.0204677f
C327 VBP.n6 VSS 0.120387f
C328 VBP.t8 VSS 0.140789f
C329 VBP.t16 VSS 0.140789f
C330 VBP.t31 VSS 0.140789f
C331 VBP.t32 VSS 0.140789f
C332 VBP.t12 VSS 0.140789f
C333 VBP.t10 VSS 0.140789f
C334 VBP.t14 VSS 0.140789f
C335 VBP.t18 VSS 0.140789f
C336 VBP.t2 VSS 0.140789f
C337 VBP.t0 VSS 0.140789f
C338 VBP.t33 VSS 0.140789f
C339 VBP.t34 VSS 0.140789f
C340 VBP.t20 VSS 0.140789f
C341 VBP.t6 VSS 0.140789f
C342 VBP.t4 VSS 0.142428f
C343 VBP.n7 VSS 0.142058f
C344 VBP.n8 VSS 0.0746726f
C345 VBP.n9 VSS 0.0746726f
C346 VBP.n10 VSS 0.0746726f
C347 VBP.n11 VSS 0.0746726f
C348 VBP.n12 VSS 0.0746726f
C349 VBP.n13 VSS 0.0746726f
C350 VBP.n14 VSS 0.0698563f
C351 VBP.n15 VSS 0.0728338f
C352 VBP.n16 VSS 0.0746726f
C353 VBP.n17 VSS 0.0746726f
C354 VBP.n18 VSS 0.0746726f
C355 VBP.n19 VSS 0.0746726f
C356 VBP.n20 VSS 0.105211f
C357 VBP.t9 VSS 0.0247428f
C358 VBP.t17 VSS 0.0247428f
C359 VBP.n21 VSS 0.0566877f
C360 VBP.n22 VSS 0.0828873f
C361 VBP.t13 VSS 0.0247428f
C362 VBP.t11 VSS 0.0247428f
C363 VBP.n23 VSS 0.0566877f
C364 VBP.n24 VSS 0.0534756f
C365 VBP.t15 VSS 0.0247428f
C366 VBP.t19 VSS 0.0247428f
C367 VBP.n25 VSS 0.0566877f
C368 VBP.n26 VSS 0.0294194f
C369 VBP.t3 VSS 0.0247428f
C370 VBP.t1 VSS 0.0247428f
C371 VBP.n27 VSS 0.0566877f
C372 VBP.n28 VSS 0.0456198f
C373 VBP.t21 VSS 0.0247428f
C374 VBP.t7 VSS 0.0247428f
C375 VBP.n29 VSS 0.0566877f
C376 VBP.n30 VSS 0.0534756f
C377 VBP.t5 VSS 0.0247428f
C378 VBP.t28 VSS 0.0247428f
C379 VBP.n31 VSS 0.0566877f
C380 VBP.n32 VSS 0.0550312f
C381 VBP.n33 VSS 0.195896f
C382 VB2.t5 VSS 0.0504401f
C383 VB2.t6 VSS 0.0504401f
C384 VB2.n0 VSS 0.115557f
C385 VB2.t7 VSS 0.0504401f
C386 VB2.t4 VSS 0.0504401f
C387 VB2.n1 VSS 0.115557f
C388 VB2.n2 VSS 0.167445f
C389 VB2.t0 VSS 0.229032f
C390 VB2.t1 VSS 0.079793f
C391 VB2.t3 VSS 0.079793f
C392 VB2.n3 VSS 0.174204f
C393 VB2.n4 VSS 0.107545f
C394 VB2.t8 VSS 0.0201767f
C395 VB2.t2 VSS 0.0201767f
C396 VB2.n5 VSS 0.0414961f
C397 VB2.n6 VSS 0.0641845f
C398 VB2.n7 VSS 0.311973f
C399 VBN.t0 VSS 0.0216682f
C400 VBN.t12 VSS 0.0216682f
C401 VBN.n0 VSS 0.044563f
C402 VBN.t11 VSS 0.0727215f
C403 VBN.t14 VSS 0.15116f
C404 VBN.t5 VSS 0.15116f
C405 VBN.t7 VSS 0.15116f
C406 VBN.t15 VSS 0.15116f
C407 VBN.t16 VSS 0.15116f
C408 VBN.t17 VSS 0.15116f
C409 VBN.t18 VSS 0.15116f
C410 VBN.t3 VSS 0.15116f
C411 VBN.t1 VSS 0.15116f
C412 VBN.t9 VSS 0.154888f
C413 VBN.n1 VSS 0.208277f
C414 VBN.n2 VSS 0.112186f
C415 VBN.n3 VSS 0.112186f
C416 VBN.n4 VSS 0.112186f
C417 VBN.n5 VSS 0.107392f
C418 VBN.n6 VSS 0.102411f
C419 VBN.n7 VSS 0.112186f
C420 VBN.n8 VSS 0.112186f
C421 VBN.n9 VSS 0.174023f
C422 VBN.t6 VSS 0.0270812f
C423 VBN.t8 VSS 0.0270812f
C424 VBN.n10 VSS 0.0585089f
C425 VBN.n11 VSS 0.181164f
C426 VBN.t4 VSS 0.0270812f
C427 VBN.t2 VSS 0.0270812f
C428 VBN.n12 VSS 0.0585089f
C429 VBN.n13 VSS 0.0822197f
C430 VBN.t10 VSS 0.0270812f
C431 VBN.t13 VSS 0.0270812f
C432 VBN.n14 VSS 0.0585089f
C433 VBN.n15 VSS 0.0767213f
C434 VBN.n16 VSS 0.304213f
C435 VBN.n17 VSS 0.259165f
C436 VREF.t2 VSS 2.02897f
C437 VREF.t1 VSS 0.00402736f
C438 VREF.t0 VSS 0.00402736f
C439 VREF.n0 VSS 0.00847046f
C440 EN.t2 VSS 0.0433701f
C441 EN.t3 VSS 0.15486f
C442 EN.t4 VSS 0.155536f
C443 EN.n0 VSS 0.172177f
C444 EN.n1 VSS 0.132034f
C445 EN.t1 VSS 0.0612757f
C446 EN.n2 VSS 0.0644993f
C447 EN.t0 VSS 0.0173655f
C448 EN.n3 VSS 0.155962f
.ends lvds_bias
