* LVS schematic of the lane layout: subckt lvds_lane of netlist/lvds_rx_lvs_ref.spice flattened + the layout's dummy devices.
* GENERATED by layout/lane/lane.py (schematic) -- do not edit by hand.
.subckt lvds_lane VDD VSS INP INN EN VBN VBP VB2 VREF OUT
XXESDP_RESD INP gp VDD ppolyf_u r_width=5u r_length=1.8u
DXESDP_DESD_H gp VDD diode_pd2nw_03v3 area=40p pj=26u
DXESDP_DESD_L VSS gp diode_nd2ps_03v3 area=40p pj=26u
XXESDN_RESD INN gn VDD ppolyf_u r_width=5u r_length=1.8u
DXESDN_DESD_H gn VDD diode_pd2nw_03v3 area=40p pj=26u
DXESDN_DESD_L VSS gn diode_nd2ps_03v3 area=40p pj=26u
XXPRE_RLA VDD oa VSS ppolyf_u_1k r_width=2u r_length=18.395u
XXPRE_RLB VDD ob VSS ppolyf_u_1k r_width=2u r_length=18.395u
XXPRE_MPT tp VBP VDD VDD pfet_03v3 w=110u nf=22 l=1u
XXPRE_MP1A fa gp tp tp pfet_03v3 w=105.6u nf=22 l=0.4u
XXPRE_MP1B fb gn tp tp pfet_03v3 w=105.6u nf=22 l=0.4u
XXPRE_MPDA fa VREF tp tp pfet_03v3 w=105.6u nf=22 l=0.4u
XXPRE_MPDB fb VREF tp tp pfet_03v3 w=105.6u nf=22 l=0.4u
XXPRE_M3A fa VBN VSS VSS nfet_03v3 w=30u nf=12 l=1u
XXPRE_M3B fb VBN VSS VSS nfet_03v3 w=30u nf=12 l=1u
XXPRE_M5A oa VB2 fa VSS nfet_03v3 w=31.64u nf=7 l=0.5u
XXPRE_M5B ob VB2 fb VSS nfet_03v3 w=31.64u nf=7 l=0.5u
XXPRE_MNT tn VBN VSS VSS nfet_03v3 w=25u nf=10 l=1u
XXPRE_MN1A oa gp tn VSS nfet_03v3 w=47.5u nf=10 l=0.5u
XXPRE_MN1B ob gn tn VSS nfet_03v3 w=47.5u nf=10 l=0.5u
XXPRE_MNDA oa VREF tn VSS nfet_03v3 w=47.5u nf=10 l=0.5u
XXPRE_MNDB ob VREF tn VSS nfet_03v3 w=47.5u nf=10 l=0.5u
XXHYST_MT2 ts VBN VSS VSS nfet_03v3 w=30u nf=12 l=1u
XXHYST_MS1 d2a oa sa VSS nfet_03v3 w=8.74u nf=2 l=0.5u
XXHYST_MS2 d2b ob sb VSS nfet_03v3 w=8.74u nf=2 l=0.5u
XXHYST_RS1 sa ts VSS ppolyf_u_1k r_width=5u r_length=1.637u
XXHYST_RS2 sb ts VSS ppolyf_u_1k r_width=5u r_length=1.637u
XXHYST_MLD1 d2a d2a VDD VDD pfet_03v3 w=7.4u nf=4 l=0.28u
XXHYST_MLD2 d2b d2b VDD VDD pfet_03v3 w=7.4u nf=4 l=0.28u
XXHYST_MLC1 d2a d2b VDD VDD pfet_03v3 w=11.1u nf=6 l=0.28u
XXHYST_MLC2 d2b d2a VDD VDD pfet_03v3 w=11.1u nf=6 l=0.28u
XXHYST_MPU1 d2a EN VDD VDD pfet_03v3 w=2u l=0.5u
XXHYST_MPU2 d2b EN VDD VDD pfet_03v3 w=2u l=0.5u
XXOUT_MP3A n3a d2a VDD VDD pfet_03v3 w=14.8u nf=8 l=0.28u
XXOUT_MP3B d3 d2b VDD VDD pfet_03v3 w=14.8u nf=8 l=0.28u
XXOUT_MN3A n3a n3a VSS VSS nfet_03v3 w=4.66u l=0.28u
XXOUT_MN3B d3 n3a VSS VSS nfet_03v3 w=4.66u l=0.28u
XXOUT_MNANDP1 nd d3 VDD VDD pfet_03v3 w=3u l=0.28u
XXOUT_MNANDP2 nd EN VDD VDD pfet_03v3 w=3u l=0.28u
XXOUT_MNANDN1 nd d3 nm VSS nfet_03v3 w=2u l=0.28u
XXOUT_MNANDN2 nm EN VSS VSS nfet_03v3 w=2u l=0.28u
XXOUT_MINV1P i1 nd VDD VDD pfet_03v3 w=3.7u l=0.28u
XXOUT_MINV1N i1 nd VSS VSS nfet_03v3 w=1.5u l=0.28u
XXOUT_MINV2P i2 i1 VDD VDD pfet_03v3 w=7.5u nf=2 l=0.28u
XXOUT_MINV2N i2 i1 VSS VSS nfet_03v3 w=3u l=0.28u
XXOUT_MINV3P OUT i2 VDD VDD pfet_03v3 w=20u nf=4 l=0.28u
XXOUT_MINV3N OUT i2 VSS VSS nfet_03v3 w=8u nf=2 l=0.28u
Xnandn_dL nd VSS VSS VSS nfet_03v3 w=2u l=0.28u
Xnandn_dR VSS VSS VSS VSS nfet_03v3 w=2u l=0.28u
Xnandp_dL nd VDD VDD VDD pfet_03v3 w=3u l=0.28u
Xnandp_dR nd VDD VDD VDD pfet_03v3 w=3u l=0.28u
Xinv1n_dL i1 VSS VSS VSS nfet_03v3 w=1.5u l=0.28u
Xinv1n_dR VSS VSS VSS VSS nfet_03v3 w=1.5u l=0.28u
Xinv1p_dL i1 VDD VDD VDD pfet_03v3 w=3.7u l=0.28u
Xinv1p_dR VDD VDD VDD VDD pfet_03v3 w=3.7u l=0.28u
Xinv2n_dL i2 VSS VSS VSS nfet_03v3 w=3u l=0.28u
Xinv2n_dR VSS VSS VSS VSS nfet_03v3 w=3u l=0.28u
Xinv2p_dL i2 VDD VDD VDD pfet_03v3 w=3.75u l=0.28u
Xinv2p_dR i2 VDD VDD VDD pfet_03v3 w=3.75u l=0.28u
Xinv3n_dL OUT VSS VSS VSS nfet_03v3 w=4u l=0.28u
Xinv3n_dR OUT VSS VSS VSS nfet_03v3 w=4u l=0.28u
Xinv3p_dL OUT VDD VDD VDD pfet_03v3 w=5u l=0.28u
Xinv3p_dR OUT VDD VDD VDD pfet_03v3 w=5u l=0.28u
Xld_dL VDD VDD VDD VDD pfet_03v3 w=1.85u l=0.28u
Xld_dR VDD VDD VDD VDD pfet_03v3 w=1.85u l=0.28u
Xmpu2a_dL d2a VDD VDD VDD pfet_03v3 w=2u l=0.5u
Xmpu2a_dR VDD VDD VDD VDD pfet_03v3 w=2u l=0.5u
Xmpu2b_dL d2b VDD VDD VDD pfet_03v3 w=2u l=0.5u
Xmpu2b_dR VDD VDD VDD VDD pfet_03v3 w=2u l=0.5u
Xmp3_dL n3a VDD VDD VDD pfet_03v3 w=1.85u l=0.28u
Xmp3_dR n3a VDD VDD VDD pfet_03v3 w=1.85u l=0.28u
Xmn3_dL n3a VSS VSS VSS nfet_03v3 w=4.66u l=0.28u
Xmn3_dR d3 VSS VSS VSS nfet_03v3 w=4.66u l=0.28u
Xms1_dL d2a VSS VSS VSS nfet_03v3 w=4.37u l=0.5u
Xms1_dR d2a VSS VSS VSS nfet_03v3 w=4.37u l=0.5u
Xms2_dL d2b VSS VSS VSS nfet_03v3 w=4.37u l=0.5u
Xms2_dR d2b VSS VSS VSS nfet_03v3 w=4.37u l=0.5u
Xmnt_dL tn VSS VSS VSS nfet_03v3 w=2.5u l=1u
Xmnt_dR tn VSS VSS VSS nfet_03v3 w=2.5u l=1u
Xmt2_dL ts VSS VSS VSS nfet_03v3 w=2.5u l=1u
Xmt2_dR ts VSS VSS VSS nfet_03v3 w=2.5u l=1u
Xm3_dL fa VSS VSS VSS nfet_03v3 w=2.5u l=1u
Xm3_dR fa VSS VSS VSS nfet_03v3 w=2.5u l=1u
Xm5a_dL oa VSS VSS VSS nfet_03v3 w=4.52u l=0.5u
Xm5a_dR fa VSS VSS VSS nfet_03v3 w=4.52u l=0.5u
Xm5b_dL ob VSS VSS VSS nfet_03v3 w=4.52u l=0.5u
Xm5b_dR fb VSS VSS VSS nfet_03v3 w=4.52u l=0.5u
Xmpt_dL tp VDD VDD VDD pfet_03v3 w=5u l=1u
Xmpt_dR tp VDD VDD VDD pfet_03v3 w=5u l=1u
XRDUM_rl_0 VSS VSS VSS ppolyf_u_1k r_width=2u r_length=9.113u
XRDUM_rl_5 VSS VSS VSS ppolyf_u_1k r_width=2u r_length=9.113u
XRDUM_rs_0 VSS VSS VSS ppolyf_u_1k r_width=5u r_length=1.637u
XRDUM_rs_3 VSS VSS VSS ppolyf_u_1k r_width=5u r_length=1.637u
.ends lvds_lane
