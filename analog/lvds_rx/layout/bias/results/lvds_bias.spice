* LVS schematic of the bias block: subckt lvds_bias of netlist/lvds_rx_lvs_ref.spice flattened + the layout's dummies.
* GENERATED by layout/bias/bias.py (schematic) -- do not edit by hand.
.subckt lvds_bias VDD VSS EN VBN VBP VB2 VREF
XMEN_P enb EN VDD VDD pfet_03v3 w=2.5u l=0.28u
XMEN_N enb EN VSS VSS nfet_03v3 w=1u l=0.28u
XMSW nrb enb VDD VDD pfet_03v3 w=40u nf=8 l=0.5u
XRRB nrb VBN VSS ppolyf_u_1k r_width=2u r_length=89.562u
XMBN VBN VBN VSS VSS nfet_03v3 w=12.5u nf=5 l=1u
XMPD_N VBN enb VSS VSS nfet_03v3 w=2u l=0.5u
XMBS VBP VBN VSS VSS nfet_03v3 w=12.5u nf=5 l=1u
XMBP VBP VBP VDD VDD pfet_03v3 w=55u nf=11 l=1u
XMPU_P VBP EN VDD VDD pfet_03v3 w=2u l=0.5u
XMB2P VB2 VBP VDD VDD pfet_03v3 w=20u nf=4 l=1u
XMB2 VB2 VB2 vf VSS nfet_03v3 w=7.91u l=0.5u
XRRF vf VSS VSS ppolyf_u_1k r_width=2u r_length=46.313u
XMPD_2 VB2 enb VSS VSS nfet_03v3 w=2u l=0.5u
XRRDT VDD VREF VSS ppolyf_u_1k r_width=2u r_length=84.531u
XRRDB VREF nmid VSS ppolyf_u_1k r_width=2u r_length=77.547u
XMVS nmid EN VSS VSS nfet_03v3 w=10u nf=2 l=0.5u
XCVREF VSS VREF VSS VSS nfet_03v3 w=20u l=25.13u
Xmbn_dL VBN VSS VSS VSS nfet_03v3 w=2.5u l=1u
Xmbn_dR VBP VSS VSS VSS nfet_03v3 w=2.5u l=1u
Xmb2_dL VB2 VSS VSS VSS nfet_03v3 w=7.91u l=0.5u
Xmb2_dR vf VSS VSS VSS nfet_03v3 w=7.91u l=0.5u
Xmsw_dL nrb VDD VDD VDD pfet_03v3 w=5u l=0.5u
Xmsw_dR nrb VDD VDD VDD pfet_03v3 w=5u l=0.5u
Xmen_p_dL enb VDD VDD VDD pfet_03v3 w=2.5u l=0.28u
Xmen_p_dR VDD VDD VDD VDD pfet_03v3 w=2.5u l=0.28u
Xmpu_p_dL VBP VDD VDD VDD pfet_03v3 w=2u l=0.5u
Xmpu_p_dR VDD VDD VDD VDD pfet_03v3 w=2u l=0.5u
Xmvs_dL nmid VSS VSS VSS nfet_03v3 w=5u l=0.5u
Xmvs_dR nmid VSS VSS VSS nfet_03v3 w=5u l=0.5u
Xmpd_2_dL VB2 VSS VSS VSS nfet_03v3 w=2u l=0.5u
Xmpd_2_dR VSS VSS VSS VSS nfet_03v3 w=2u l=0.5u
Xmpd_n_dL VBN VSS VSS VSS nfet_03v3 w=2u l=0.5u
Xmpd_n_dR VSS VSS VSS VSS nfet_03v3 w=2u l=0.5u
Xmbp_dL VBP VDD VDD VDD pfet_03v3 w=5u l=1u
Xmbp_dR VDD VDD VDD VDD pfet_03v3 w=5u l=1u
XRDUM_ra1_0 VSS VSS VSS ppolyf_u_1k r_width=2u r_length=22.265u
XRDUM_ra1_7 VSS VSS VSS ppolyf_u_1k r_width=2u r_length=23.072u
XRDUM_ra2_0 VSS VSS VSS ppolyf_u_1k r_width=2u r_length=21.007u
XRDUM_ra2_9 VSS VSS VSS ppolyf_u_1k r_width=2u r_length=21.007u
.ends lvds_bias
