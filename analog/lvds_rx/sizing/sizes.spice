* sizes.spice -- generated by sizing/lvds_rx_sizing.py; DO NOT EDIT BY HAND
* HASH sizing_script=45c4ce9e10e1e3c882528062216b374532995ae2dbc9722845bb9f73c47f1bf4 luts=ed294bfa2ea31bf470c7b065d7ce2a6687c2dc4ab8084a1598c58c56024c2f39 spec=675bef0e692055a27889048e3ad8f372ba50b505a1a4d5f9a531e165053ce857
* flags (from spec/spec.yaml variants; a testbench may redefine them with .param AFTER the include)
.param flag_nmos_pair = 1
.param flag_dump_devices = 1
.param flag_extra_gain_stage = 0
.param flag_bias_constgm = 0
.param flag_failsafe = 0
.param flag_on_die_term = 0
* devices: w_<stem> / l_<stem> in m, nf_<stem> integer; stems are the instance names of netlist/lvds_rx_core.spice
.param w_mbn = 12.5u
.param l_mbn = 1u
.param nf_mbn = 5
.param w_mbs = 12.5u
.param l_mbs = 1u
.param nf_mbs = 5
.param w_mnt = 25u
.param l_mnt = 1u
.param nf_mnt = 10
.param w_m3 = 30u
.param l_m3 = 1u
.param nf_m3 = 12
.param w_mt2 = 30u
.param l_mt2 = 1u
.param nf_mt2 = 12
.param w_mbp = 55u
.param l_mbp = 1u
.param nf_mbp = 11
.param w_mpt = 110u
.param l_mpt = 1u
.param nf_mpt = 22
.param w_mn1 = 47.5u
.param l_mn1 = 0.5u
.param nf_mn1 = 10
.param w_mnd = 47.5u
.param l_mnd = 0.5u
.param nf_mnd = 10
.param w_mp1 = 105.6u
.param l_mp1 = 0.4u
.param nf_mp1 = 22
.param w_mpd = 105.6u
.param l_mpd = 0.4u
.param nf_mpd = 22
.param w_m5 = 31.64u
.param l_m5 = 0.5u
.param nf_m5 = 7
.param w_msw = 40u
.param l_msw = 0.5u
.param nf_msw = 8
.param w_mb2p = 20u
.param l_mb2p = 1u
.param nf_mb2p = 4
.param w_mb2 = 7.91u
.param l_mb2 = 0.5u
.param nf_mb2 = 1
.param w_mvs = 10u
.param l_mvs = 0.5u
.param nf_mvs = 2
.param w_men_n = 1u
.param l_men_n = 0.28u
.param nf_men_n = 1
.param w_men_p = 2.5u
.param l_men_p = 0.28u
.param nf_men_p = 1
.param w_mpd_n = 2u
.param l_mpd_n = 0.5u
.param nf_mpd_n = 1
.param w_mpu_p = 2u
.param l_mpu_p = 0.5u
.param nf_mpu_p = 1
.param w_mpd_2 = 2u
.param l_mpd_2 = 0.5u
.param nf_mpd_2 = 1
.param w_ms = 8.74u
.param l_ms = 0.5u
.param nf_ms = 2
.param w_mld = 7.4u
.param l_mld = 0.28u
.param nf_mld = 4
.param w_mlc = 11.1u
.param l_mlc = 0.28u
.param nf_mlc = 6
.param w_mpu2 = 2u
.param l_mpu2 = 0.5u
.param nf_mpu2 = 1
.param w_mp3 = 14.8u
.param l_mp3 = 0.28u
.param nf_mp3 = 8
.param w_mn3 = 4.66u
.param l_mn3 = 0.28u
.param nf_mn3 = 1
.param w_nand_n = 2u
.param l_nand_n = 0.28u
.param nf_nand_n = 1
.param w_nand_p = 3u
.param l_nand_p = 0.28u
.param nf_nand_p = 1
.param w_inv1_n = 1.5u
.param l_inv1_n = 0.28u
.param nf_inv1_n = 1
.param w_inv1_p = 3.7u
.param l_inv1_p = 0.28u
.param nf_inv1_p = 1
.param w_inv2_n = 3u
.param l_inv2_n = 0.28u
.param nf_inv2_n = 1
.param w_inv2_p = 7.5u
.param l_inv2_p = 0.28u
.param nf_inv2_p = 2
.param w_inv3_n = 8u
.param l_inv3_n = 0.28u
.param nf_inv3_n = 2
.param w_inv3_p = 20u
.param l_inv3_p = 0.28u
.param nf_inv3_p = 4
.param rw_rl = 2u
.param rl_rl = 18.395u
.param rw_rb = 2u
.param rl_rb = 89.562u
.param rw_rf = 2u
.param rl_rf = 46.313u
.param rw_rdt = 2u
.param rl_rdt = 84.531u
.param rw_rdb = 2u
.param rl_rdb = 77.547u
.param rw_rs = 5u
.param rl_rs = 1.637u
.param rw_esd = 5u
.param rl_esd = 1.8u
.param dw_esd = 8u
.param dl_esd = 5u
.param c_vref_ff = 2000
.param cap_vref_w = 20u
.param cap_vref_l = 25.13u
.param vref_ratio = 0.48
.param ldiff = 0.5114u
.param cw_pre_fa = 57.654f
.param cw_pre_fb = 56.742f
.param cw_pre_tp = 238.446f
.param cw_pre_tn = 34.158f
.param cw_hyst_sa = 9.591f
.param cw_hyst_sb = 5.615f
.param cw_hyst_ts = 7.249f
.param cw_out_n3a = 5.672f
.param cw_out_d3 = 12.184f
.param cw_out_nd = 5.9f
.param cw_out_nm = 0.69f
.param cw_out_i1 = 5.385f
.param cw_out_i2 = 6.418f
.param cw_lane_inp = 4.579f
.param cw_lane_inn = 4.233f
.param cw_lane_gp = 45.247f
.param cw_lane_gn = 45.571f
.param cw_lane_oa = 31.161f
.param cw_lane_ob = 30.772f
.param cw_lane_d2a = 13.217f
.param cw_lane_d2b = 12.122f
.param cw_lane_out = 18.143f
.param cw_bias_enb = 22.6f
.param cw_bias_nrb = 5.167f
.param cw_bias_vf = 9.501f
.param cw_bias_nmid = 8.071f
.param cw_top_vbn = 237.635f
.param cw_top_vbp = 57.607f
.param cw_top_vb2 = 111.368f
.param cw_top_vref = 217.572f
.param cw_top_en = 66.064f
.param cwd_pre_fa = 0f
.param cwd_pre_fb = 0f
.param cwd_pre_tp = 13.609f
.param cwd_pre_tn = 0.234f
.param cwd_hyst_sa = 0.007f
.param cwd_hyst_sb = 0f
.param cwd_hyst_ts = 0.66f
.param cwd_out_n3a = 6.365f
.param cwd_out_d3 = 5.106f
.param cwd_out_nd = 3.27f
.param cwd_out_nm = 0f
.param cwd_out_i1 = 3.147f
.param cwd_out_i2 = 5.14f
.param cwd_lane_inp = 2.731f
.param cwd_lane_inn = 3.079f
.param cwd_lane_gp = 5.444f
.param cwd_lane_gn = 5.424f
.param cwd_lane_oa = 1.915f
.param cwd_lane_ob = 2.389f
.param cwd_lane_d2a = 15.628f
.param cwd_lane_d2b = 14.711f
.param cwd_lane_out = 4.8f
.param cwd_bias_enb = 7.414f
.param cwd_bias_nrb = 6.121f
.param cwd_bias_vf = 0.004f
.param cwd_bias_nmid = 1.076f
.param cwd_top_vbn = 4.514f
.param cwd_top_vbp = 136.848f
.param cwd_top_vb2 = 7.933f
.param cwd_top_vref = 2.56f
.param cwd_top_en = 78.146f
.param nf_m3a = 17
.param w_m3a = 42.5u
.param l_m3a = 1u
