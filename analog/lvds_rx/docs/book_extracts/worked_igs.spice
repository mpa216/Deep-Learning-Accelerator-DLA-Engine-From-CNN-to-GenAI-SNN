* worked_igs.spice -- generated by worked_igs_gf180.py (book Ex. 3.1 / Sec. 3.1.7 on GF180)
.include /foss/pdks/gf180mcuD/libs.tech/ngspice/design.ngspice
.lib /foss/pdks/gf180mcuD/libs.tech/ngspice/sm141064.ngspice typical
vdd vdd 0 3.3
Ib vdd d dc 2.665127e-05
* drain-voltage servo: gate DC level = VGS0 + 1000*(Vd - VDS); the RC low-pass blocks the loop at AC (book Fig. 3.5)
Rlp d dlow 1G
Clp dlow 0 1
Eb vb 0 vol='0.801577 + 1000*(v(dlow) - 1.0)'
Vin g vb dc 0 ac 1
XM1 d g 0 0 nfet_03v3 L=0.5u W=9.86221u nf=5 ad='int((nf+1)/2) * W/nf * 0.18u' as='int((nf+2)/2) * W/nf * 0.18u' pd='2*int((nf+1)/2) * (W/nf + 0.18u)'
+ ps='2*int((nf+2)/2) * (W/nf + 0.18u)' nrd='0.18u / W' nrs='0.18u / W' sa=0 sb=0 sd=0 m=1
CL d 0 5.0000e-13
.control
op
print @m.xm1.m0[id] @m.xm1.m0[gm] @m.xm1.m0[gds] v(g) v(d)
ac dec 40 1e3 5e9
meas ac av0 find vdb(d) at=1e4
meas ac fu when vdb(d)=0 fall=1
.endc
.end
