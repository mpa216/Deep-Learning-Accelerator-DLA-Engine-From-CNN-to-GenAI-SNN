* tb6_cm_supply: common-mode step, supply ripple and current-spike train during PRBS7 data on lane 0 (task T4, PLAN_V2 TB6).
* Two macro copies (disturbed _d / reference _r) see the same data through the same input network (50 ohm source, 100 ohm termination, package, asig_5p0 pad);
* the body (supplies, drivers, DUT copies) is generated by hooks.py:prep for the grid value `case` (0 cm_step, 1 ripple, 2 spike, 3 quiet) into body.inc.
* ---- GF180 header (harness): corner=tt_27c_3v30 mc=none ----
.option wnflag=1
.param sw_stat_global=0 sw_stat_mismatch=0 mc_skew=3 res_mc_skew=3 cap_mc_skew=3 fnoicor=0
.lib /foss/pdks/gf180mcuD/libs.tech/ngspice/sm141064.ngspice typical
.lib /foss/pdks/gf180mcuD/libs.tech/ngspice/sm141064.ngspice res_typical
.lib /foss/pdks/gf180mcuD/libs.tech/ngspice/sm141064.ngspice moscap_typical
.lib /foss/pdks/gf180mcuD/libs.tech/ngspice/sm141064.ngspice diode_typical
.lib /foss/pdks/gf180mcuD/libs.tech/ngspice/sm141064.ngspice mimcap_typical
.temp 27
* ---- end header ----

.option rshunt=1e11
.include /foss/designs/.claude/worktrees/lvds-rx/analog/lvds_rx/sim/tb6_cm_supply/../../sizing/sizes.spice
.include /foss/designs/.claude/worktrees/lvds-rx/analog/lvds_rx/sim/tb6_cm_supply/../../netlist/lvds_rx_core.spice
.include /foss/designs/.claude/worktrees/lvds-rx/analog/lvds_rx/sim/tb6_cm_supply/../../netlist/pad_asig_5p0.spice
.include /foss/designs/.claude/worktrees/lvds-rx/analog/lvds_rx/sim/tb6_cm_supply/../../netlist/input_network.spice
.include /foss/designs/.claude/worktrees/lvds-rx/analog/lvds_rx/sim/tb6_cm_supply/diag/body.inc
.control
tran 25p 560n 0 50p
wrdata sim/tb6_cm_supply/diag/d.txt v(rx0_o_d) v(rx0_o_r) v(rx0_p_d) v(xdut_d.xl0.oa) v(xdut_d.xl0.ob) v(xdut_d.xl0.xpre.tp) v(xdut_d.xl0.xpre.tn) v(xdut_d.xl0.d2a) v(xdut_d.xl0.d2b) v(xdut_d.xl0.xpre.fa) v(xdut_d.xl0.xpre.fb)
.endc
.end
