* tb6_cm_supply: common-mode step, supply ripple and current-spike train during PRBS7 data on lane 0 (task T4, PLAN_V2 TB6).
* Two macro copies (disturbed _d / reference _r) see the same data through the same input network (50 ohm source, 100 ohm termination, package, asig_5p0 pad);
* the body (supplies, drivers, DUT copies) is generated by hooks.py:prep for the grid value `case` (0 cm_step, 1 ripple, 2 spike, 3 quiet) into body.inc.
{header}
{seed_line}
.option rshunt=1e11
.include {deck_dir}/../../sizing/sizes.spice
.include {deck_dir}/../../netlist/lvds_rx_core.spice
.include {deck_dir}/../../netlist/pad_asig_5p0.spice
.include {deck_dir}/../../netlist/input_network.spice
.include {run_dir}/body.inc
.control
tran 25p {tstop} 0 50p
wrdata tb6.txt v(rx0_o_d) v(rx0_o_r) v(vddm) v(vssm) v(rx0_p_d) v(rx0_n_d)
.endc
.end
