* tbl_op: post-layout operating point (task T11, gate TBL; the measurable part of TB1).  GENERATED by sim/tbl/make_benches.py.
* Lane 0 at VIC +- VID/2, lanes 1 and 2 at VIC with VID / 2 the other way.  RESULT: idd_a, s1_cm_v, v_<node>.
{header}
{seed_line}
.option rshunt=1e11
.include {deck_dir}/../../sizing/sizes.spice
.include {deck_dir}/../../{core}
Vr r 0 {vdd}
Bv vddi 0 V=v(r)
Vs vdd vddi dc 0
Ben en 0 V=1*v(r)
Bcm cm 0 V={vic}*v(r)/{vdd}
Vp0 rx0_p cm dc {0.5*({vid})}
Vn0 rx0_n cm dc {-0.5*({vid})}
Vp1 rx1_p cm dc {-0.5*({vid})}
Vn1 rx1_n cm dc {0.5*({vid})}
Vp2 rx2_p cm dc {0.5*({vid})}
Vn2 rx2_n cm dc {-0.5*({vid})}
Xdut vdd 0 rx0_p rx0_n rx1_p rx1_n rx2_p rx2_n en rx0_o rx1_o rx2_o lvds_rx_x3
.control
dc Vr 0.3 {vdd} 0.1
let n = length(v(vdd)) - 1
let x = -i(Vs)[n]
echo RESULT idd_a $&x
let x = (v(xdut.xl0.oa)[n] + v(xdut.xl0.ob)[n]) / 2
echo RESULT s1_cm_v $&x
let x = v(xdut.vbn)[n]
echo RESULT v_vbn $&x
let x = v(xdut.vbp)[n]
echo RESULT v_vbp $&x
let x = v(xdut.vb2)[n]
echo RESULT v_vb2 $&x
let x = v(xdut.vref)[n]
echo RESULT v_vref $&x
let x = v(xdut.xbias.enb)[n]
echo RESULT v_xbias_enb $&x
let x = v(xdut.xbias.nrb)[n]
echo RESULT v_xbias_nrb $&x
let x = v(xdut.xbias.vf)[n]
echo RESULT v_xbias_vf $&x
let x = v(xdut.xbias.nmid)[n]
echo RESULT v_xbias_nmid $&x
let x = v(xdut.xl0.xpre.tp)[n]
echo RESULT v_xl0_xpre_tp $&x
let x = v(xdut.xl0.xpre.tn)[n]
echo RESULT v_xl0_xpre_tn $&x
let x = v(xdut.xl0.xpre.fa)[n]
echo RESULT v_xl0_xpre_fa $&x
let x = v(xdut.xl0.xpre.fb)[n]
echo RESULT v_xl0_xpre_fb $&x
let x = v(xdut.xl0.oa)[n]
echo RESULT v_xl0_oa $&x
let x = v(xdut.xl0.ob)[n]
echo RESULT v_xl0_ob $&x
let x = v(xdut.xl0.xhyst.ts)[n]
echo RESULT v_xl0_xhyst_ts $&x
let x = v(xdut.xl0.xhyst.sa)[n]
echo RESULT v_xl0_xhyst_sa $&x
let x = v(xdut.xl0.xhyst.sb)[n]
echo RESULT v_xl0_xhyst_sb $&x
let x = v(xdut.xl0.d2a)[n]
echo RESULT v_xl0_d2a $&x
let x = v(xdut.xl0.d2b)[n]
echo RESULT v_xl0_d2b $&x
let x = v(xdut.xl0.xout.n3a)[n]
echo RESULT v_xl0_xout_n3a $&x
let x = v(xdut.xl0.xout.d3)[n]
echo RESULT v_xl0_xout_d3 $&x
let x = v(xdut.xl0.xout.nd)[n]
echo RESULT v_xl0_xout_nd $&x
let x = v(xdut.xl0.xout.i1)[n]
echo RESULT v_xl0_xout_i1 $&x
let x = v(xdut.xl0.xout.i2)[n]
echo RESULT v_xl0_xout_i2 $&x
let x = v(xdut.xl1.oa)[n]
echo RESULT v_xl1_oa $&x
let x = v(xdut.xl1.ob)[n]
echo RESULT v_xl1_ob $&x
let x = v(xdut.xl2.oa)[n]
echo RESULT v_xl2_oa $&x
let x = v(xdut.xl2.ob)[n]
echo RESULT v_xl2_ob $&x
let x = v(rx0_o)[n]
echo RESULT out0_v $&x
let x = v(rx1_o)[n]
echo RESULT out1_v $&x
let x = v(rx2_o)[n]
echo RESULT out2_v $&x
.endc
.end
