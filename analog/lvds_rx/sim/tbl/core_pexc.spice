* core_pexc.spice -- GENERATED by sim/tbl/make_cores.py (T11); do not edit.
* = netlist/lvds_rx_core.spice (sha256 12b8123ca20db8679600e10ba1676027d46e39c3c76223967911f9096f415f85) without lvds_rx_x3
*   + results/layout/lvds_rx_x3.pex_c.spice (sha256 cd76eeecf31f2de60067b189789861a00053a4882b76698859c5ad29ced18d59) with its nodes renamed to the pre-layout paths.
* lvds_rx_core.spice -- LVDS receiver macro lvds_rx_x3 (3 lanes + shared bias), gf180mcuD 3.3 V devices.
* GENERATED by netlist/gen_core.py from netlist/lvds_circuit.py -- do not edit by hand.
* Every W/L/nf and poly size comes from the parameters of sizing/sizes.spice: the deck must  .include  sizes.spice BEFORE this file
* and the PDK sections (header of sim/harness).  Matched devices are one device with nf fingers (never m).
* Build flags (parameters of sizes.spice, redefine AFTER the include to switch): flag_nmos_pair flag_dump_devices (implemented);
*   flag_extra_gain_stage flag_bias_constgm flag_failsafe flag_on_die_term (NOT implemented in v0: setting one aborts the parse).
* Instance names are hierarchical, e.g. xl0.xpre.xmp1a; the BSIM device inside is  @m.<path>.m0[...] .

.subckt lvds_bias VDD VSS EN VBN VBP VB2 VREF
Xmen_p enb EN VDD VDD pfet_03v3 L={l_men_p} W={w_men_p} nf={nf_men_p} ad='int((nf+1)/2) * W/nf * ldiff' as='int((nf+2)/2) * W/nf * ldiff' pd='2*int((nf+1)/2) * (W/nf + ldiff)' ps='2*int((nf+2)/2) * (W/nf + ldiff)' nrd='0.18u / W' nrs='0.18u / W' sa=0 sb=0 sd=0
Xmen_n enb EN VSS VSS nfet_03v3 L={l_men_n} W={w_men_n} nf={nf_men_n} ad='int((nf+1)/2) * W/nf * ldiff' as='int((nf+2)/2) * W/nf * ldiff' pd='2*int((nf+1)/2) * (W/nf + ldiff)' ps='2*int((nf+2)/2) * (W/nf + ldiff)' nrd='0.18u / W' nrs='0.18u / W' sa=0 sb=0 sd=0
Xmsw nrb enb VDD VDD pfet_03v3 L={l_msw} W={w_msw} nf={nf_msw} ad='int((nf+1)/2) * W/nf * ldiff' as='int((nf+2)/2) * W/nf * ldiff' pd='2*int((nf+1)/2) * (W/nf + ldiff)' ps='2*int((nf+2)/2) * (W/nf + ldiff)' nrd='0.18u / W' nrs='0.18u / W' sa=0 sb=0 sd=0
Xrrb nrb VBN VSS ppolyf_u_1k r_width={rw_rb} r_length={rl_rb}
Xmbn VBN VBN VSS VSS nfet_03v3 L={l_mbn} W={w_mbn} nf={nf_mbn} ad='int((nf+1)/2) * W/nf * ldiff' as='int((nf+2)/2) * W/nf * ldiff' pd='2*int((nf+1)/2) * (W/nf + ldiff)' ps='2*int((nf+2)/2) * (W/nf + ldiff)' nrd='0.18u / W' nrs='0.18u / W' sa=0 sb=0 sd=0
Xmpd_n VBN enb VSS VSS nfet_03v3 L={l_mpd_n} W={w_mpd_n} nf={nf_mpd_n} ad='int((nf+1)/2) * W/nf * ldiff' as='int((nf+2)/2) * W/nf * ldiff' pd='2*int((nf+1)/2) * (W/nf + ldiff)' ps='2*int((nf+2)/2) * (W/nf + ldiff)' nrd='0.18u / W' nrs='0.18u / W' sa=0 sb=0 sd=0
Xmbs VBP VBN VSS VSS nfet_03v3 L={l_mbs} W={w_mbs} nf={nf_mbs} ad='int((nf+1)/2) * W/nf * ldiff' as='int((nf+2)/2) * W/nf * ldiff' pd='2*int((nf+1)/2) * (W/nf + ldiff)' ps='2*int((nf+2)/2) * (W/nf + ldiff)' nrd='0.18u / W' nrs='0.18u / W' sa=0 sb=0 sd=0
Xmbp VBP VBP VDD VDD pfet_03v3 L={l_mbp} W={w_mbp} nf={nf_mbp} ad='int((nf+1)/2) * W/nf * ldiff' as='int((nf+2)/2) * W/nf * ldiff' pd='2*int((nf+1)/2) * (W/nf + ldiff)' ps='2*int((nf+2)/2) * (W/nf + ldiff)' nrd='0.18u / W' nrs='0.18u / W' sa=0 sb=0 sd=0
Xmpu_p VBP EN VDD VDD pfet_03v3 L={l_mpu_p} W={w_mpu_p} nf={nf_mpu_p} ad='int((nf+1)/2) * W/nf * ldiff' as='int((nf+2)/2) * W/nf * ldiff' pd='2*int((nf+1)/2) * (W/nf + ldiff)' ps='2*int((nf+2)/2) * (W/nf + ldiff)' nrd='0.18u / W' nrs='0.18u / W' sa=0 sb=0 sd=0
Xmb2p VB2 VBP VDD VDD pfet_03v3 L={l_mb2p} W={w_mb2p} nf={nf_mb2p} ad='int((nf+1)/2) * W/nf * ldiff' as='int((nf+2)/2) * W/nf * ldiff' pd='2*int((nf+1)/2) * (W/nf + ldiff)' ps='2*int((nf+2)/2) * (W/nf + ldiff)' nrd='0.18u / W' nrs='0.18u / W' sa=0 sb=0 sd=0
Xmb2 VB2 VB2 vf VSS nfet_03v3 L={l_mb2} W={w_mb2} nf={nf_mb2} ad='int((nf+1)/2) * W/nf * ldiff' as='int((nf+2)/2) * W/nf * ldiff' pd='2*int((nf+1)/2) * (W/nf + ldiff)' ps='2*int((nf+2)/2) * (W/nf + ldiff)' nrd='0.18u / W' nrs='0.18u / W' sa=0 sb=0 sd=0
Xrrf vf VSS VSS ppolyf_u_1k r_width={rw_rf} r_length={rl_rf}
Xmpd_2 VB2 enb VSS VSS nfet_03v3 L={l_mpd_2} W={w_mpd_2} nf={nf_mpd_2} ad='int((nf+1)/2) * W/nf * ldiff' as='int((nf+2)/2) * W/nf * ldiff' pd='2*int((nf+1)/2) * (W/nf + ldiff)' ps='2*int((nf+2)/2) * (W/nf + ldiff)' nrd='0.18u / W' nrs='0.18u / W' sa=0 sb=0 sd=0
Xrrdt VDD VREF VSS ppolyf_u_1k r_width={rw_rdt} r_length={rl_rdt}
Xrrdb VREF nmid VSS ppolyf_u_1k r_width={rw_rdb} r_length={rl_rdb}
Xmvs nmid EN VSS VSS nfet_03v3 L={l_mvs} W={w_mvs} nf={nf_mvs} ad='int((nf+1)/2) * W/nf * ldiff' as='int((nf+2)/2) * W/nf * ldiff' pd='2*int((nf+1)/2) * (W/nf + ldiff)' ps='2*int((nf+2)/2) * (W/nf + ldiff)' nrd='0.18u / W' nrs='0.18u / W' sa=0 sb=0 sd=0
Xcvref VREF VSS cap_nmos_03v3 c_length={cap_vref_l} c_width={cap_vref_w}
* layout parasitic estimate (T11): wiring C per net, values from sizes.spice (cw_<stem>)
Ccw_bias_enb enb VSS {cw_bias_enb}
Ccwd_bias_enb enb VDD {cwd_bias_enb}
Ccw_bias_nrb nrb VSS {cw_bias_nrb}
Ccwd_bias_nrb nrb VDD {cwd_bias_nrb}
Ccw_bias_vf vf VSS {cw_bias_vf}
Ccwd_bias_vf vf VDD {cwd_bias_vf}
Ccw_bias_nmid nmid VSS {cw_bias_nmid}
Ccwd_bias_nmid nmid VDD {cwd_bias_nmid}
.ends lvds_bias

.subckt lvds_esd2 A B VDD VSS
Xresd A B VDD ppolyf_u r_width={rw_esd} r_length={rl_esd}
Ddesd_h B VDD diode_pd2nw_03v3 area={dw_esd*dl_esd} pj={2*(dw_esd+dl_esd)}
Ddesd_l VSS B diode_nd2ps_03v3 area={dw_esd*dl_esd} pj={2*(dw_esd+dl_esd)}
.ends lvds_esd2

.subckt lvds_pre VDD VSS INP INN VBN VBP VB2 VREF OA OB
Xrla VDD OA VSS ppolyf_u_1k r_width={rw_rl} r_length={rl_rl}
Xrlb VDD OB VSS ppolyf_u_1k r_width={rw_rl} r_length={rl_rl}
Xmpt tp VBP VDD VDD pfet_03v3 L={l_mpt} W={w_mpt} nf={nf_mpt} ad='int((nf+1)/2) * W/nf * ldiff' as='int((nf+2)/2) * W/nf * ldiff' pd='2*int((nf+1)/2) * (W/nf + ldiff)' ps='2*int((nf+2)/2) * (W/nf + ldiff)' nrd='0.18u / W' nrs='0.18u / W' sa=0 sb=0 sd=0
Xmp1a fa INP tp tp pfet_03v3 L={l_mp1} W={w_mp1} nf={nf_mp1} ad='int((nf+1)/2) * W/nf * ldiff' as='int((nf+2)/2) * W/nf * ldiff' pd='2*int((nf+1)/2) * (W/nf + ldiff)' ps='2*int((nf+2)/2) * (W/nf + ldiff)' nrd='0.18u / W' nrs='0.18u / W' sa=0 sb=0 sd=0
Xmp1b fb INN tp tp pfet_03v3 L={l_mp1} W={w_mp1} nf={nf_mp1} ad='int((nf+1)/2) * W/nf * ldiff' as='int((nf+2)/2) * W/nf * ldiff' pd='2*int((nf+1)/2) * (W/nf + ldiff)' ps='2*int((nf+2)/2) * (W/nf + ldiff)' nrd='0.18u / W' nrs='0.18u / W' sa=0 sb=0 sd=0
.if ((flag_dump_devices == 1))
Xmpda fa VREF tp tp pfet_03v3 L={l_mpd} W={w_mpd} nf={nf_mpd} ad='int((nf+1)/2) * W/nf * ldiff' as='int((nf+2)/2) * W/nf * ldiff' pd='2*int((nf+1)/2) * (W/nf + ldiff)' ps='2*int((nf+2)/2) * (W/nf + ldiff)' nrd='0.18u / W' nrs='0.18u / W' sa=0 sb=0 sd=0
Xmpdb fb VREF tp tp pfet_03v3 L={l_mpd} W={w_mpd} nf={nf_mpd} ad='int((nf+1)/2) * W/nf * ldiff' as='int((nf+2)/2) * W/nf * ldiff' pd='2*int((nf+1)/2) * (W/nf + ldiff)' ps='2*int((nf+2)/2) * (W/nf + ldiff)' nrd='0.18u / W' nrs='0.18u / W' sa=0 sb=0 sd=0
.endif
.if ((flag_nmos_pair == 1))
Xm3a fa VBN VSS VSS nfet_03v3 L={l_m3} W={w_m3} nf={nf_m3} ad='int((nf+1)/2) * W/nf * ldiff' as='int((nf+2)/2) * W/nf * ldiff' pd='2*int((nf+1)/2) * (W/nf + ldiff)' ps='2*int((nf+2)/2) * (W/nf + ldiff)' nrd='0.18u / W' nrs='0.18u / W' sa=0 sb=0 sd=0
Xm3b fb VBN VSS VSS nfet_03v3 L={l_m3} W={w_m3} nf={nf_m3} ad='int((nf+1)/2) * W/nf * ldiff' as='int((nf+2)/2) * W/nf * ldiff' pd='2*int((nf+1)/2) * (W/nf + ldiff)' ps='2*int((nf+2)/2) * (W/nf + ldiff)' nrd='0.18u / W' nrs='0.18u / W' sa=0 sb=0 sd=0
.endif
.if ((flag_nmos_pair != 1))
Xm3a fa VBN VSS VSS nfet_03v3 L={l_m3a} W={w_m3a} nf={nf_m3a} ad='int((nf+1)/2) * W/nf * ldiff' as='int((nf+2)/2) * W/nf * ldiff' pd='2*int((nf+1)/2) * (W/nf + ldiff)' ps='2*int((nf+2)/2) * (W/nf + ldiff)' nrd='0.18u / W' nrs='0.18u / W' sa=0 sb=0 sd=0
Xm3b fb VBN VSS VSS nfet_03v3 L={l_m3a} W={w_m3a} nf={nf_m3a} ad='int((nf+1)/2) * W/nf * ldiff' as='int((nf+2)/2) * W/nf * ldiff' pd='2*int((nf+1)/2) * (W/nf + ldiff)' ps='2*int((nf+2)/2) * (W/nf + ldiff)' nrd='0.18u / W' nrs='0.18u / W' sa=0 sb=0 sd=0
.endif
Xm5a OA VB2 fa VSS nfet_03v3 L={l_m5} W={w_m5} nf={nf_m5} ad='int((nf+1)/2) * W/nf * ldiff' as='int((nf+2)/2) * W/nf * ldiff' pd='2*int((nf+1)/2) * (W/nf + ldiff)' ps='2*int((nf+2)/2) * (W/nf + ldiff)' nrd='0.18u / W' nrs='0.18u / W' sa=0 sb=0 sd=0
Xm5b OB VB2 fb VSS nfet_03v3 L={l_m5} W={w_m5} nf={nf_m5} ad='int((nf+1)/2) * W/nf * ldiff' as='int((nf+2)/2) * W/nf * ldiff' pd='2*int((nf+1)/2) * (W/nf + ldiff)' ps='2*int((nf+2)/2) * (W/nf + ldiff)' nrd='0.18u / W' nrs='0.18u / W' sa=0 sb=0 sd=0
.if ((flag_nmos_pair == 1))
Xmnt tn VBN VSS VSS nfet_03v3 L={l_mnt} W={w_mnt} nf={nf_mnt} ad='int((nf+1)/2) * W/nf * ldiff' as='int((nf+2)/2) * W/nf * ldiff' pd='2*int((nf+1)/2) * (W/nf + ldiff)' ps='2*int((nf+2)/2) * (W/nf + ldiff)' nrd='0.18u / W' nrs='0.18u / W' sa=0 sb=0 sd=0
Xmn1a OA INP tn VSS nfet_03v3 L={l_mn1} W={w_mn1} nf={nf_mn1} ad='int((nf+1)/2) * W/nf * ldiff' as='int((nf+2)/2) * W/nf * ldiff' pd='2*int((nf+1)/2) * (W/nf + ldiff)' ps='2*int((nf+2)/2) * (W/nf + ldiff)' nrd='0.18u / W' nrs='0.18u / W' sa=0 sb=0 sd=0
Xmn1b OB INN tn VSS nfet_03v3 L={l_mn1} W={w_mn1} nf={nf_mn1} ad='int((nf+1)/2) * W/nf * ldiff' as='int((nf+2)/2) * W/nf * ldiff' pd='2*int((nf+1)/2) * (W/nf + ldiff)' ps='2*int((nf+2)/2) * (W/nf + ldiff)' nrd='0.18u / W' nrs='0.18u / W' sa=0 sb=0 sd=0
.endif
.if ((flag_nmos_pair == 1) && (flag_dump_devices == 1))
Xmnda OA VREF tn VSS nfet_03v3 L={l_mnd} W={w_mnd} nf={nf_mnd} ad='int((nf+1)/2) * W/nf * ldiff' as='int((nf+2)/2) * W/nf * ldiff' pd='2*int((nf+1)/2) * (W/nf + ldiff)' ps='2*int((nf+2)/2) * (W/nf + ldiff)' nrd='0.18u / W' nrs='0.18u / W' sa=0 sb=0 sd=0
Xmndb OB VREF tn VSS nfet_03v3 L={l_mnd} W={w_mnd} nf={nf_mnd} ad='int((nf+1)/2) * W/nf * ldiff' as='int((nf+2)/2) * W/nf * ldiff' pd='2*int((nf+1)/2) * (W/nf + ldiff)' ps='2*int((nf+2)/2) * (W/nf + ldiff)' nrd='0.18u / W' nrs='0.18u / W' sa=0 sb=0 sd=0
.endif
* layout parasitic estimate (T11): wiring C per net, values from sizes.spice (cw_<stem>)
Ccw_pre_fa fa VSS {cw_pre_fa}
Ccwd_pre_fa fa VDD {cwd_pre_fa}
Ccw_pre_fb fb VSS {cw_pre_fb}
Ccwd_pre_fb fb VDD {cwd_pre_fb}
Ccw_pre_tp tp VSS {cw_pre_tp}
Ccwd_pre_tp tp VDD {cwd_pre_tp}
Ccw_pre_tn tn VSS {cw_pre_tn}
Ccwd_pre_tn tn VDD {cwd_pre_tn}
.ends lvds_pre

.subckt lvds_hyst VDD VSS OA OB VBN EN D2A D2B
Xmt2 ts VBN VSS VSS nfet_03v3 L={l_mt2} W={w_mt2} nf={nf_mt2} ad='int((nf+1)/2) * W/nf * ldiff' as='int((nf+2)/2) * W/nf * ldiff' pd='2*int((nf+1)/2) * (W/nf + ldiff)' ps='2*int((nf+2)/2) * (W/nf + ldiff)' nrd='0.18u / W' nrs='0.18u / W' sa=0 sb=0 sd=0
Xms1 D2A OA sa VSS nfet_03v3 L={l_ms} W={w_ms} nf={nf_ms} ad='int((nf+1)/2) * W/nf * ldiff' as='int((nf+2)/2) * W/nf * ldiff' pd='2*int((nf+1)/2) * (W/nf + ldiff)' ps='2*int((nf+2)/2) * (W/nf + ldiff)' nrd='0.18u / W' nrs='0.18u / W' sa=0 sb=0 sd=0
Xms2 D2B OB sb VSS nfet_03v3 L={l_ms} W={w_ms} nf={nf_ms} ad='int((nf+1)/2) * W/nf * ldiff' as='int((nf+2)/2) * W/nf * ldiff' pd='2*int((nf+1)/2) * (W/nf + ldiff)' ps='2*int((nf+2)/2) * (W/nf + ldiff)' nrd='0.18u / W' nrs='0.18u / W' sa=0 sb=0 sd=0
Xrs1 sa ts VSS ppolyf_u_1k r_width={rw_rs} r_length={rl_rs}
Xrs2 sb ts VSS ppolyf_u_1k r_width={rw_rs} r_length={rl_rs}
Xmld1 D2A D2A VDD VDD pfet_03v3 L={l_mld} W={w_mld} nf={nf_mld} ad='int((nf+1)/2) * W/nf * ldiff' as='int((nf+2)/2) * W/nf * ldiff' pd='2*int((nf+1)/2) * (W/nf + ldiff)' ps='2*int((nf+2)/2) * (W/nf + ldiff)' nrd='0.18u / W' nrs='0.18u / W' sa=0 sb=0 sd=0
Xmld2 D2B D2B VDD VDD pfet_03v3 L={l_mld} W={w_mld} nf={nf_mld} ad='int((nf+1)/2) * W/nf * ldiff' as='int((nf+2)/2) * W/nf * ldiff' pd='2*int((nf+1)/2) * (W/nf + ldiff)' ps='2*int((nf+2)/2) * (W/nf + ldiff)' nrd='0.18u / W' nrs='0.18u / W' sa=0 sb=0 sd=0
Xmlc1 D2A D2B VDD VDD pfet_03v3 L={l_mlc} W={w_mlc} nf={nf_mlc} ad='int((nf+1)/2) * W/nf * ldiff' as='int((nf+2)/2) * W/nf * ldiff' pd='2*int((nf+1)/2) * (W/nf + ldiff)' ps='2*int((nf+2)/2) * (W/nf + ldiff)' nrd='0.18u / W' nrs='0.18u / W' sa=0 sb=0 sd=0
Xmlc2 D2B D2A VDD VDD pfet_03v3 L={l_mlc} W={w_mlc} nf={nf_mlc} ad='int((nf+1)/2) * W/nf * ldiff' as='int((nf+2)/2) * W/nf * ldiff' pd='2*int((nf+1)/2) * (W/nf + ldiff)' ps='2*int((nf+2)/2) * (W/nf + ldiff)' nrd='0.18u / W' nrs='0.18u / W' sa=0 sb=0 sd=0
Xmpu1 D2A EN VDD VDD pfet_03v3 L={l_mpu2} W={w_mpu2} nf={nf_mpu2} ad='int((nf+1)/2) * W/nf * ldiff' as='int((nf+2)/2) * W/nf * ldiff' pd='2*int((nf+1)/2) * (W/nf + ldiff)' ps='2*int((nf+2)/2) * (W/nf + ldiff)' nrd='0.18u / W' nrs='0.18u / W' sa=0 sb=0 sd=0
Xmpu2 D2B EN VDD VDD pfet_03v3 L={l_mpu2} W={w_mpu2} nf={nf_mpu2} ad='int((nf+1)/2) * W/nf * ldiff' as='int((nf+2)/2) * W/nf * ldiff' pd='2*int((nf+1)/2) * (W/nf + ldiff)' ps='2*int((nf+2)/2) * (W/nf + ldiff)' nrd='0.18u / W' nrs='0.18u / W' sa=0 sb=0 sd=0
* layout parasitic estimate (T11): wiring C per net, values from sizes.spice (cw_<stem>)
Ccw_hyst_sa sa VSS {cw_hyst_sa}
Ccwd_hyst_sa sa VDD {cwd_hyst_sa}
Ccw_hyst_sb sb VSS {cw_hyst_sb}
Ccwd_hyst_sb sb VDD {cwd_hyst_sb}
Ccw_hyst_ts ts VSS {cw_hyst_ts}
Ccwd_hyst_ts ts VDD {cwd_hyst_ts}
.ends lvds_hyst

.subckt lvds_out VDD VSS D2A D2B EN OUT
Xmp3a n3a D2A VDD VDD pfet_03v3 L={l_mp3} W={w_mp3} nf={nf_mp3} ad='int((nf+1)/2) * W/nf * ldiff' as='int((nf+2)/2) * W/nf * ldiff' pd='2*int((nf+1)/2) * (W/nf + ldiff)' ps='2*int((nf+2)/2) * (W/nf + ldiff)' nrd='0.18u / W' nrs='0.18u / W' sa=0 sb=0 sd=0
Xmp3b d3 D2B VDD VDD pfet_03v3 L={l_mp3} W={w_mp3} nf={nf_mp3} ad='int((nf+1)/2) * W/nf * ldiff' as='int((nf+2)/2) * W/nf * ldiff' pd='2*int((nf+1)/2) * (W/nf + ldiff)' ps='2*int((nf+2)/2) * (W/nf + ldiff)' nrd='0.18u / W' nrs='0.18u / W' sa=0 sb=0 sd=0
Xmn3a n3a n3a VSS VSS nfet_03v3 L={l_mn3} W={w_mn3} nf={nf_mn3} ad='int((nf+1)/2) * W/nf * ldiff' as='int((nf+2)/2) * W/nf * ldiff' pd='2*int((nf+1)/2) * (W/nf + ldiff)' ps='2*int((nf+2)/2) * (W/nf + ldiff)' nrd='0.18u / W' nrs='0.18u / W' sa=0 sb=0 sd=0
Xmn3b d3 n3a VSS VSS nfet_03v3 L={l_mn3} W={w_mn3} nf={nf_mn3} ad='int((nf+1)/2) * W/nf * ldiff' as='int((nf+2)/2) * W/nf * ldiff' pd='2*int((nf+1)/2) * (W/nf + ldiff)' ps='2*int((nf+2)/2) * (W/nf + ldiff)' nrd='0.18u / W' nrs='0.18u / W' sa=0 sb=0 sd=0
Xmnandp1 nd d3 VDD VDD pfet_03v3 L={l_nand_p} W={w_nand_p} nf={nf_nand_p} ad='int((nf+1)/2) * W/nf * ldiff' as='int((nf+2)/2) * W/nf * ldiff' pd='2*int((nf+1)/2) * (W/nf + ldiff)' ps='2*int((nf+2)/2) * (W/nf + ldiff)' nrd='0.18u / W' nrs='0.18u / W' sa=0 sb=0 sd=0
Xmnandp2 nd EN VDD VDD pfet_03v3 L={l_nand_p} W={w_nand_p} nf={nf_nand_p} ad='int((nf+1)/2) * W/nf * ldiff' as='int((nf+2)/2) * W/nf * ldiff' pd='2*int((nf+1)/2) * (W/nf + ldiff)' ps='2*int((nf+2)/2) * (W/nf + ldiff)' nrd='0.18u / W' nrs='0.18u / W' sa=0 sb=0 sd=0
Xmnandn1 nd d3 nm VSS nfet_03v3 L={l_nand_n} W={w_nand_n} nf={nf_nand_n} ad='int((nf+1)/2) * W/nf * ldiff' as='int((nf+2)/2) * W/nf * ldiff' pd='2*int((nf+1)/2) * (W/nf + ldiff)' ps='2*int((nf+2)/2) * (W/nf + ldiff)' nrd='0.18u / W' nrs='0.18u / W' sa=0 sb=0 sd=0
Xmnandn2 nm EN VSS VSS nfet_03v3 L={l_nand_n} W={w_nand_n} nf={nf_nand_n} ad='int((nf+1)/2) * W/nf * ldiff' as='int((nf+2)/2) * W/nf * ldiff' pd='2*int((nf+1)/2) * (W/nf + ldiff)' ps='2*int((nf+2)/2) * (W/nf + ldiff)' nrd='0.18u / W' nrs='0.18u / W' sa=0 sb=0 sd=0
Xminv1p i1 nd VDD VDD pfet_03v3 L={l_inv1_p} W={w_inv1_p} nf={nf_inv1_p} ad='int((nf+1)/2) * W/nf * ldiff' as='int((nf+2)/2) * W/nf * ldiff' pd='2*int((nf+1)/2) * (W/nf + ldiff)' ps='2*int((nf+2)/2) * (W/nf + ldiff)' nrd='0.18u / W' nrs='0.18u / W' sa=0 sb=0 sd=0
Xminv1n i1 nd VSS VSS nfet_03v3 L={l_inv1_n} W={w_inv1_n} nf={nf_inv1_n} ad='int((nf+1)/2) * W/nf * ldiff' as='int((nf+2)/2) * W/nf * ldiff' pd='2*int((nf+1)/2) * (W/nf + ldiff)' ps='2*int((nf+2)/2) * (W/nf + ldiff)' nrd='0.18u / W' nrs='0.18u / W' sa=0 sb=0 sd=0
Xminv2p i2 i1 VDD VDD pfet_03v3 L={l_inv2_p} W={w_inv2_p} nf={nf_inv2_p} ad='int((nf+1)/2) * W/nf * ldiff' as='int((nf+2)/2) * W/nf * ldiff' pd='2*int((nf+1)/2) * (W/nf + ldiff)' ps='2*int((nf+2)/2) * (W/nf + ldiff)' nrd='0.18u / W' nrs='0.18u / W' sa=0 sb=0 sd=0
Xminv2n i2 i1 VSS VSS nfet_03v3 L={l_inv2_n} W={w_inv2_n} nf={nf_inv2_n} ad='int((nf+1)/2) * W/nf * ldiff' as='int((nf+2)/2) * W/nf * ldiff' pd='2*int((nf+1)/2) * (W/nf + ldiff)' ps='2*int((nf+2)/2) * (W/nf + ldiff)' nrd='0.18u / W' nrs='0.18u / W' sa=0 sb=0 sd=0
Xminv3p OUT i2 VDD VDD pfet_03v3 L={l_inv3_p} W={w_inv3_p} nf={nf_inv3_p} ad='int((nf+1)/2) * W/nf * ldiff' as='int((nf+2)/2) * W/nf * ldiff' pd='2*int((nf+1)/2) * (W/nf + ldiff)' ps='2*int((nf+2)/2) * (W/nf + ldiff)' nrd='0.18u / W' nrs='0.18u / W' sa=0 sb=0 sd=0
Xminv3n OUT i2 VSS VSS nfet_03v3 L={l_inv3_n} W={w_inv3_n} nf={nf_inv3_n} ad='int((nf+1)/2) * W/nf * ldiff' as='int((nf+2)/2) * W/nf * ldiff' pd='2*int((nf+1)/2) * (W/nf + ldiff)' ps='2*int((nf+2)/2) * (W/nf + ldiff)' nrd='0.18u / W' nrs='0.18u / W' sa=0 sb=0 sd=0
* layout parasitic estimate (T11): wiring C per net, values from sizes.spice (cw_<stem>)
Ccw_out_n3a n3a VSS {cw_out_n3a}
Ccwd_out_n3a n3a VDD {cwd_out_n3a}
Ccw_out_d3 d3 VSS {cw_out_d3}
Ccwd_out_d3 d3 VDD {cwd_out_d3}
Ccw_out_nd nd VSS {cw_out_nd}
Ccwd_out_nd nd VDD {cwd_out_nd}
Ccw_out_nm nm VSS {cw_out_nm}
Ccwd_out_nm nm VDD {cwd_out_nm}
Ccw_out_i1 i1 VSS {cw_out_i1}
Ccwd_out_i1 i1 VDD {cwd_out_i1}
Ccw_out_i2 i2 VSS {cw_out_i2}
Ccwd_out_i2 i2 VDD {cwd_out_i2}
.ends lvds_out

.subckt lvds_lane VDD VSS INP INN EN VBN VBP VB2 VREF OUT
xesdp INP gp VDD VSS lvds_esd2
xesdn INN gn VDD VSS lvds_esd2
xpre VDD VSS gp gn VBN VBP VB2 VREF oa ob lvds_pre
xhyst VDD VSS oa ob VBN EN d2a d2b lvds_hyst
xout VDD VSS d2a d2b EN OUT lvds_out
* layout parasitic estimate (T11): wiring C per net, values from sizes.spice (cw_<stem>)
Ccw_lane_inp INP VSS {cw_lane_inp}
Ccwd_lane_inp INP VDD {cwd_lane_inp}
Ccw_lane_inn INN VSS {cw_lane_inn}
Ccwd_lane_inn INN VDD {cwd_lane_inn}
Ccw_lane_gp gp VSS {cw_lane_gp}
Ccwd_lane_gp gp VDD {cwd_lane_gp}
Ccw_lane_gn gn VSS {cw_lane_gn}
Ccwd_lane_gn gn VDD {cwd_lane_gn}
Ccw_lane_oa oa VSS {cw_lane_oa}
Ccwd_lane_oa oa VDD {cwd_lane_oa}
Ccw_lane_ob ob VSS {cw_lane_ob}
Ccwd_lane_ob ob VDD {cwd_lane_ob}
Ccw_lane_d2a d2a VSS {cw_lane_d2a}
Ccwd_lane_d2a d2a VDD {cwd_lane_d2a}
Ccw_lane_d2b d2b VSS {cw_lane_d2b}
Ccwd_lane_d2b d2b VDD {cwd_lane_d2b}
Ccw_lane_out OUT VSS {cw_lane_out}
Ccwd_lane_out OUT VDD {cwd_lane_out}
.ends lvds_lane

* (subckt lvds_rx_x3 removed: the extracted one follows)

.subckt lvds_rx_x3 VDD VSS RX0_P RX0_N RX1_P RX1_N RX2_P RX2_N EN RX0_O RX1_O RX2_O
X0 VSS VSS xl2.xpre.fa VSS nfet_03v3 ad=1.1p pd=5.88u as=0.65p ps=3.02u w=2.5u l=1u
X1 VSS VSS RX1_O VSS nfet_03v3 ad=1.76p pd=8.88u as=1.04p ps=4.52u w=4u l=0.28u
X2 xl0.xpre.tp xl0.gn xl0.xpre.fb xl0.xpre.tp pfet_03v3 ad=1.248p pd=5.32u as=1.248p ps=5.32u w=4.8u l=0.4u
X3 xl0.d2b xl0.d2a VDD VDD pfet_03v3 ad=0.52p pd=2.52u as=0.52p ps=2.52u w=2u l=0.28u
X4 xl0.xpre.fb vref xl0.xpre.tp xl0.xpre.tp pfet_03v3 ad=1.248p pd=5.32u as=1.248p ps=5.32u w=4.8u l=0.4u
X5 VDD vbp xl2.xpre.tp VDD pfet_03v3 ad=1.3p pd=5.52u as=1.3p ps=5.52u w=5u l=1u
X6 xl1.xpre.tp xl1.gn xl1.xpre.fb xl1.xpre.tp pfet_03v3 ad=1.248p pd=5.32u as=1.248p ps=5.32u w=4.8u l=0.4u
X7 xl1.xpre.fb vbn VSS VSS nfet_03v3 ad=0.65p pd=3.02u as=0.65p ps=3.02u w=2.5u l=1u
X8 vbp vbp VDD VDD pfet_03v3 ad=1.3p pd=5.52u as=1.3p ps=5.52u w=5u l=1u
X9 xl2.xpre.fa vref xl2.xpre.tp xl2.xpre.tp pfet_03v3 ad=1.248p pd=5.32u as=1.248p ps=5.32u w=4.8u l=0.4u
X10 VSS vbn xl0.xpre.fb VSS nfet_03v3 ad=0.65p pd=3.02u as=0.65p ps=3.02u w=2.5u l=1u
X11 VDD VDD VDD VDD pfet_03v3 ad=0.52p pd=2.52u as=0.29839n ps=1.38742m w=2u l=0.5u
X12 xl1.xpre.tp vbp VDD VDD pfet_03v3 ad=1.3p pd=5.52u as=1.3p ps=5.52u w=5u l=1u
X13 xl0.xout.n3a xl0.d2a VDD VDD pfet_03v3 ad=0.52p pd=2.52u as=0.52p ps=2.52u w=2u l=0.28u
X14 VSS VSS xl2.xpre.fa VSS nfet_03v3 ad=1.9888p pd=9.92u as=1.1752p ps=5.04u w=4.52u l=0.5u
X15 xl0.d2a xl0.d2b VDD VDD pfet_03v3 ad=0.52p pd=2.52u as=0.52p ps=2.52u w=2u l=0.28u
X16 xl1.xout.n3a xl1.d2a VDD VDD pfet_03v3 ad=0.52p pd=2.52u as=0.52p ps=2.52u w=2u l=0.28u
X17 xl1.xpre.tn xl1.gp xl1.oa VSS nfet_03v3 ad=1.235p pd=5.27u as=1.235p ps=5.27u w=4.75u l=0.5u
X18 xl1.xpre.fb xl1.gn xl1.xpre.tp xl1.xpre.tp pfet_03v3 ad=1.248p pd=5.32u as=1.248p ps=5.32u w=4.8u l=0.4u
X19 xl2.xpre.tp vref xl2.xpre.fb xl2.xpre.tp pfet_03v3 ad=1.248p pd=5.32u as=1.248p ps=5.32u w=4.8u l=0.4u
X20 VSS vbn xl1.xpre.fb VSS nfet_03v3 ad=0.65p pd=3.02u as=0.65p ps=3.02u w=2.5u l=1u
X21 VSS xl1.xout.n3a xl1.xout.d3 VSS nfet_03v3 ad=0.6734p pd=3.11u as=0.6734p ps=3.11u w=2.59u l=0.28u
X22 xl2.xpre.tn vref xl2.ob VSS nfet_03v3 ad=1.235p pd=5.27u as=1.235p ps=5.27u w=4.75u l=0.5u
X23 xl2.oa vb2 xl2.xpre.fa VSS nfet_03v3 ad=1.1752p pd=5.04u as=1.1752p ps=5.04u w=4.52u l=0.5u
X24 xl0.xpre.tp xl0.gp xl0.xpre.fa xl0.xpre.tp pfet_03v3 ad=1.248p pd=5.32u as=1.248p ps=5.32u w=4.8u l=0.4u
X25 xl0.oa vref xl0.xpre.tn VSS nfet_03v3 ad=1.235p pd=5.27u as=1.235p ps=5.27u w=4.75u l=0.5u
X26 VDD xl1.d2a xl1.d2a VDD pfet_03v3 ad=0.52p pd=2.52u as=0.52p ps=2.52u w=2u l=0.28u
X27 xl1.xpre.fb vref xl1.xpre.tp xl1.xpre.tp pfet_03v3 ad=1.248p pd=5.32u as=1.248p ps=5.32u w=4.8u l=0.4u
X28 xl2.xpre.fb vb2 xl2.ob VSS nfet_03v3 ad=1.1752p pd=5.04u as=1.1752p ps=5.04u w=4.52u l=0.5u
X29 VSS vref VSS VSS nfet_03v3 ad=8.8p pd=40.88u as=0.2658n ps=1.29442m w=20u l=25.13u
X30 xl1.xpre.tn xl1.gp xl1.oa VSS nfet_03v3 ad=1.235p pd=5.27u as=1.235p ps=5.27u w=4.75u l=0.5u
D0 xl0.gp VDD diode_pd2nw_03v3 pj=26u area=40p
X31 xl2.xpre.tp xl2.gp xl2.xpre.fa xl2.xpre.tp pfet_03v3 ad=1.248p pd=5.32u as=1.248p ps=5.32u w=4.8u l=0.4u
X32 xl0.ob vb2 xl0.xpre.fb VSS nfet_03v3 ad=1.1752p pd=5.04u as=1.1752p ps=5.04u w=4.52u l=0.5u
X33 xl0.xout.nm xl0.xout.d3 xl0.xout.nd VSS nfet_03v3 ad=0.52p pd=2.52u as=0.52p ps=2.52u w=2u l=0.28u
X34 xl0.ob vref xl0.xpre.tn VSS nfet_03v3 ad=1.235p pd=5.27u as=1.235p ps=5.27u w=4.75u l=0.5u
X35 xl1.xpre.tn xl1.gn xl1.ob VSS nfet_03v3 ad=1.235p pd=5.27u as=1.235p ps=5.27u w=4.75u l=0.5u
X36 RX0_O xl0.xout.i2 VSS VSS nfet_03v3 ad=1.04p pd=4.52u as=1.04p ps=4.52u w=4u l=0.28u
X37 VSS vbn vbp VSS nfet_03v3 ad=0.65p pd=3.02u as=0.65p ps=3.02u w=2.5u l=1u
X38 VDD xl2.d2b xl2.xout.d3 VDD pfet_03v3 ad=0.52p pd=2.52u as=0.52p ps=2.52u w=2u l=0.28u
X39 VDD xl1.d2b xl1.d2b VDD pfet_03v3 ad=0.52p pd=2.52u as=0.52p ps=2.52u w=2u l=0.28u
X40 xl0.xpre.fa vref xl0.xpre.tp xl0.xpre.tp pfet_03v3 ad=1.248p pd=5.32u as=1.248p ps=5.32u w=4.8u l=0.4u
X41 xl2.d2b VDD VDD VDD pfet_03v3 ad=0.52p pd=2.52u as=0.88p ps=4.88u w=2u l=0.5u
X42 VDD xl0.d2b xl0.xout.d3 VDD pfet_03v3 ad=0.52p pd=2.52u as=0.52p ps=2.52u w=2u l=0.28u
X43 xl1.xpre.fb xl1.gn xl1.xpre.tp xl1.xpre.tp pfet_03v3 ad=1.248p pd=5.32u as=1.248p ps=5.32u w=4.8u l=0.4u
X44 xl0.xpre.fa vbn VSS VSS nfet_03v3 ad=0.65p pd=3.02u as=0.65p ps=3.02u w=2.5u l=1u
X45 xl0.xpre.tn xl0.gp xl0.oa VSS nfet_03v3 ad=1.235p pd=5.27u as=1.235p ps=5.27u w=4.75u l=0.5u
X46 xl2.xout.d3 xl2.xout.n3a VSS VSS nfet_03v3 ad=0.6734p pd=3.11u as=0.6734p ps=3.11u w=2.59u l=0.28u
X47 xl2.xpre.fb vref xl2.xpre.tp xl2.xpre.tp pfet_03v3 ad=1.248p pd=5.32u as=1.248p ps=5.32u w=4.8u l=0.4u
X48 xl0.xpre.fa vref xl0.xpre.tp xl0.xpre.tp pfet_03v3 ad=1.248p pd=5.32u as=1.248p ps=5.32u w=4.8u l=0.4u
X49 xl1.xpre.tp vref xl1.xpre.fa xl1.xpre.tp pfet_03v3 ad=1.248p pd=5.32u as=1.248p ps=5.32u w=4.8u l=0.4u
X50 xl0.xpre.tn vbn VSS VSS nfet_03v3 ad=0.65p pd=3.02u as=0.65p ps=3.02u w=2.5u l=1u
X51 xl2.oa xl2.gp xl2.xpre.tn VSS nfet_03v3 ad=1.235p pd=5.27u as=1.235p ps=5.27u w=4.75u l=0.5u
X52 RX2_O xl2.xout.i2 VSS VSS nfet_03v3 ad=1.04p pd=4.52u as=1.04p ps=4.52u w=4u l=0.28u
X53 VSS vbn xl2.xhyst.ts VSS nfet_03v3 ad=0.65p pd=3.02u as=0.65p ps=3.02u w=2.5u l=1u
X54 xl0.d2a xl0.d2b VDD VDD pfet_03v3 ad=0.52p pd=2.52u as=0.52p ps=2.52u w=2u l=0.28u
X55 VDD xl0.xout.i2 RX0_O VDD pfet_03v3 ad=1.3p pd=5.52u as=1.3p ps=5.52u w=5u l=0.28u
X56 VSS xbias.enb vb2 VSS nfet_03v3 ad=0.52p pd=2.52u as=0.52p ps=2.52u w=2u l=0.5u
X57 VDD xl2.xout.d3 xl2.xout.nd VDD pfet_03v3 ad=0.78p pd=3.52u as=0.78p ps=3.52u w=3u l=0.28u
X58 xl1.xpre.tp vref xl1.xpre.fa xl1.xpre.tp pfet_03v3 ad=1.248p pd=5.32u as=1.248p ps=5.32u w=4.8u l=0.4u
X59 VSS vbn xl0.xhyst.ts VSS nfet_03v3 ad=0.65p pd=3.02u as=0.65p ps=3.02u w=2.5u l=1u
X60 xl2.ob vref xl2.xpre.tn VSS nfet_03v3 ad=1.235p pd=5.27u as=1.235p ps=5.27u w=4.75u l=0.5u
X61 VDD VDD xl0.xout.i2 VDD pfet_03v3 ad=1.65p pd=8.38u as=0.975p ps=4.27u w=3.75u l=0.28u
X62 xl0.xout.d3 xl0.d2b VDD VDD pfet_03v3 ad=0.52p pd=2.52u as=0.52p ps=2.52u w=2u l=0.28u
X63 xl0.xpre.tp xl0.gn xl0.xpre.fb xl0.xpre.tp pfet_03v3 ad=1.248p pd=5.32u as=1.248p ps=5.32u w=4.8u l=0.4u
X64 xl2.d2b xl2.d2b VDD VDD pfet_03v3 ad=0.52p pd=2.52u as=0.52p ps=2.52u w=2u l=0.28u
X65 xl0.xpre.fa vref xl0.xpre.tp xl0.xpre.tp pfet_03v3 ad=1.248p pd=5.32u as=1.248p ps=5.32u w=4.8u l=0.4u
X66 xl1.xpre.fa vref xl1.xpre.tp xl1.xpre.tp pfet_03v3 ad=1.248p pd=5.32u as=1.248p ps=5.32u w=4.8u l=0.4u
X67 xl0.d2a VDD VDD VDD pfet_03v3 ad=0.52p pd=2.52u as=0.88p ps=4.88u w=2u l=0.28u
X68 xl2.xpre.tp xl2.gp xl2.xpre.fa xl2.xpre.tp pfet_03v3 ad=1.248p pd=5.32u as=1.248p ps=5.32u w=4.8u l=0.4u
X69 xl1.xout.d3 xl1.d2b VDD VDD pfet_03v3 ad=0.52p pd=2.52u as=0.52p ps=2.52u w=2u l=0.28u
X70 xl0.xhyst.ts xl0.xhyst.sa VSS ppolyf_u_1k r_width=2u r_length=3.17u
X71 xl1.d2b xl1.d2a VDD VDD pfet_03v3 ad=0.52p pd=2.52u as=0.52p ps=2.52u w=2u l=0.28u
X72 xl0.xpre.tp vref xl0.xpre.fb xl0.xpre.tp pfet_03v3 ad=1.248p pd=5.32u as=1.248p ps=5.32u w=4.8u l=0.4u
X73 xl1.xpre.tp xl1.gn xl1.xpre.fb xl1.xpre.tp pfet_03v3 ad=1.248p pd=5.32u as=1.248p ps=5.32u w=4.8u l=0.4u
X74 VDD xl2.xout.i2 RX2_O VDD pfet_03v3 ad=1.3p pd=5.52u as=1.3p ps=5.52u w=5u l=0.28u
X75 xl2.xpre.fa xl2.gp xl2.xpre.tp xl2.xpre.tp pfet_03v3 ad=1.248p pd=5.32u as=1.248p ps=5.32u w=4.8u l=0.4u
X76 xl1.xhyst.sa xl1.oa xl1.d2a VSS nfet_03v3 ad=1.1362p pd=4.89u as=1.1362p ps=4.89u w=4.37u l=0.5u
X77 VSS VSS VSS ppolyf_u_1k r_width=2u r_length=9.11u
X78 VDD vbp xl0.xpre.tp VDD pfet_03v3 ad=1.3p pd=5.52u as=1.3p ps=5.52u w=5u l=1u
X79 xl1.xpre.fa xl1.gp xl1.xpre.tp xl1.xpre.tp pfet_03v3 ad=1.248p pd=5.32u as=1.248p ps=5.32u w=4.8u l=0.4u
X80 xl1.ob vref xl1.xpre.tn VSS nfet_03v3 ad=2.09p pd=10.38u as=1.235p ps=5.27u w=4.75u l=0.5u
X81 xl0.xpre.tp vref xl0.xpre.fa xl0.xpre.tp pfet_03v3 ad=1.248p pd=5.32u as=1.248p ps=5.32u w=4.8u l=0.4u
X82 VSS VSS RX0_O VSS nfet_03v3 ad=1.76p pd=8.88u as=1.04p ps=4.52u w=4u l=0.28u
X83 VDD xl0.d2b xl0.d2b VDD pfet_03v3 ad=0.52p pd=2.52u as=0.52p ps=2.52u w=2u l=0.28u
X84 xl0.xpre.fb xl0.gn xl0.xpre.tp xl0.xpre.tp pfet_03v3 ad=1.248p pd=5.32u as=1.248p ps=5.32u w=4.8u l=0.4u
X85 xl2.xpre.tp vref xl2.xpre.fb xl2.xpre.tp pfet_03v3 ad=1.248p pd=5.32u as=1.248p ps=5.32u w=4.8u l=0.4u
X86 VSS vbn xl1.xpre.fb VSS nfet_03v3 ad=0.65p pd=3.02u as=0.65p ps=3.02u w=2.5u l=1u
X87 VDD vbp xl1.xpre.tp VDD pfet_03v3 ad=1.3p pd=5.52u as=1.3p ps=5.52u w=5u l=1u
X88 xl1.oa vb2 xl1.xpre.fa VSS nfet_03v3 ad=1.1752p pd=5.04u as=1.1752p ps=5.04u w=4.52u l=0.5u
X89 VDD xl2.d2a xl2.d2b VDD pfet_03v3 ad=0.52p pd=2.52u as=0.52p ps=2.52u w=2u l=0.28u
X90 VSS VSS VSS ppolyf_u_1k r_width=2u r_length=3.17u
X91 xl2.xhyst.ts vbn VSS VSS nfet_03v3 ad=0.65p pd=3.02u as=0.65p ps=3.02u w=2.5u l=1u
X92 VSS VSS xl1.xpre.fb VSS nfet_03v3 ad=1.9888p pd=9.92u as=1.1752p ps=5.04u w=4.52u l=0.5u
X93 xl0.xpre.tn VSS VSS VSS nfet_03v3 ad=0.65p pd=3.02u as=1.1p ps=5.88u w=2.5u l=1u
X94 VDD vbp xl1.xpre.tp VDD pfet_03v3 ad=1.3p pd=5.52u as=1.3p ps=5.52u w=5u l=1u
X95 xl0.oa vref xl0.xpre.tn VSS nfet_03v3 ad=1.235p pd=5.27u as=1.235p ps=5.27u w=4.75u l=0.5u
X96 VDD xl0.d2a xl0.xout.n3a VDD pfet_03v3 ad=0.52p pd=2.52u as=0.52p ps=2.52u w=2u l=0.28u
X97 xl0.xhyst.ts vbn VSS VSS nfet_03v3 ad=0.65p pd=3.02u as=0.65p ps=3.02u w=2.5u l=1u
X98 xl2.xout.i2 xl2.xout.i1 VDD VDD pfet_03v3 ad=0.975p pd=4.27u as=0.975p ps=4.27u w=3.75u l=0.28u
X99 VDD xl2.d2b xl2.d2a VDD pfet_03v3 ad=0.52p pd=2.52u as=0.52p ps=2.52u w=2u l=0.28u
X100 xl1.oa VSS VSS VSS nfet_03v3 ad=1.1752p pd=5.04u as=1.9888p ps=9.92u w=4.52u l=0.5u
X101 VDD xl0.d2a xl0.d2a VDD pfet_03v3 ad=0.52p pd=2.52u as=0.52p ps=2.52u w=2u l=0.28u
X102 xl2.xpre.tp vref xl2.xpre.fb xl2.xpre.tp pfet_03v3 ad=1.248p pd=5.32u as=1.248p ps=5.32u w=4.8u l=0.4u
X103 VDD xl1.d2a xl1.xout.n3a VDD pfet_03v3 ad=0.52p pd=2.52u as=0.52p ps=2.52u w=2u l=0.28u
X104 xl1.xhyst.ts vbn VSS VSS nfet_03v3 ad=0.65p pd=3.02u as=0.65p ps=3.02u w=2.5u l=1u
X105 xl1.xpre.tp xl1.gn xl1.xpre.fb xl1.xpre.tp pfet_03v3 ad=1.248p pd=5.32u as=1.248p ps=5.32u w=4.8u l=0.4u
X106 xl0.ob vref xl0.xpre.tn VSS nfet_03v3 ad=1.235p pd=5.27u as=1.235p ps=5.27u w=4.75u l=0.5u
X107 VSS VSS RX2_O VSS nfet_03v3 ad=1.76p pd=8.88u as=1.04p ps=4.52u w=4u l=0.28u
X108 xl1.xout.n3a xl1.xout.n3a VSS VSS nfet_03v3 ad=0.6734p pd=3.11u as=0.6734p ps=3.11u w=2.59u l=0.28u
X109 xl0.xpre.tp vref xl0.xpre.fa xl0.xpre.tp pfet_03v3 ad=1.248p pd=5.32u as=1.248p ps=5.32u w=4.8u l=0.4u
X110 xl2.xpre.fb vref xl2.xpre.tp xl2.xpre.tp pfet_03v3 ad=1.248p pd=5.32u as=1.248p ps=5.32u w=4.8u l=0.4u
X111 xl1.oa xl1.gp xl1.xpre.tn VSS nfet_03v3 ad=1.235p pd=5.27u as=1.235p ps=5.27u w=4.75u l=0.5u
X112 xl2.xpre.tn vref xl2.oa VSS nfet_03v3 ad=1.235p pd=5.27u as=1.235p ps=5.27u w=4.75u l=0.5u
X113 xl1.d2b xl1.d2b VDD VDD pfet_03v3 ad=0.52p pd=2.52u as=0.52p ps=2.52u w=2u l=0.28u
X114 xl0.oa vref xl0.xpre.tn VSS nfet_03v3 ad=1.235p pd=5.27u as=1.235p ps=5.27u w=4.75u l=0.5u
X115 xl0.xpre.tp vbp VDD VDD pfet_03v3 ad=1.3p pd=5.52u as=1.3p ps=5.52u w=5u l=1u
X116 VSS VSS VSS ppolyf_u_1k r_width=2u r_length=23.07u
X117 xl0.xpre.fa xl0.gp xl0.xpre.tp xl0.xpre.tp pfet_03v3 ad=1.248p pd=5.32u as=1.248p ps=5.32u w=4.8u l=0.4u
X118 xl1.xpre.fa xl1.gp xl1.xpre.tp xl1.xpre.tp pfet_03v3 ad=1.248p pd=5.32u as=1.248p ps=5.32u w=4.8u l=0.4u
X119 xl1.ob xl1.gn xl1.xpre.tn VSS nfet_03v3 ad=1.235p pd=5.27u as=1.235p ps=5.27u w=4.75u l=0.5u
X120 xl1.xpre.tp vbp VDD VDD pfet_03v3 ad=1.3p pd=5.52u as=1.3p ps=5.52u w=5u l=1u
X121 xl2.xpre.tp vref xl2.xpre.fa xl2.xpre.tp pfet_03v3 ad=1.248p pd=5.32u as=1.248p ps=5.32u w=4.8u l=0.4u
X122 xl1.d2a xl1.d2a VDD VDD pfet_03v3 ad=0.52p pd=2.52u as=0.52p ps=2.52u w=2u l=0.28u
X123 xl2.xout.n3a xl2.d2a VDD VDD pfet_03v3 ad=0.52p pd=2.52u as=0.52p ps=2.52u w=2u l=0.28u
X124 xl1.xhyst.ts xl1.xhyst.sb VSS ppolyf_u_1k r_width=2u r_length=3.17u
X125 xl2.gp RX2_P VDD ppolyf_u r_width=5u r_length=1.8u
X126 xl0.xpre.tp xl0.gp xl0.xpre.fa xl0.xpre.tp pfet_03v3 ad=1.248p pd=5.32u as=1.248p ps=5.32u w=4.8u l=0.4u
X127 xl1.ob vref xl1.xpre.tn VSS nfet_03v3 ad=1.235p pd=5.27u as=1.235p ps=5.27u w=4.75u l=0.5u
X128 VSS vbn xl0.xpre.tn VSS nfet_03v3 ad=0.65p pd=3.02u as=0.65p ps=3.02u w=2.5u l=1u
X129 VDD EN xl0.d2a VDD pfet_03v3 ad=0.52p pd=2.52u as=0.52p ps=2.52u w=2u l=0.5u
X130 xl0.xpre.tp xl0.gn xl0.xpre.fb xl0.xpre.tp pfet_03v3 ad=1.248p pd=5.32u as=1.248p ps=5.32u w=4.8u l=0.4u
X131 xl0.xpre.tp xl0.gn xl0.xpre.fb xl0.xpre.tp pfet_03v3 ad=1.248p pd=5.32u as=1.248p ps=5.32u w=4.8u l=0.4u
X132 VSS vbn xl1.xpre.fa VSS nfet_03v3 ad=0.65p pd=3.02u as=0.65p ps=3.02u w=2.5u l=1u
X133 VSS VSS VSS VSS nfet_03v3 ad=1.1396p pd=6.06u as=0 ps=0 w=2.59u l=0.28u
X134 xl2.xhyst.ts vbn VSS VSS nfet_03v3 ad=0.65p pd=3.02u as=0.65p ps=3.02u w=2.5u l=1u
X135 xl1.xpre.fa vref xl1.xpre.tp xl1.xpre.tp pfet_03v3 ad=1.248p pd=5.32u as=1.248p ps=5.32u w=4.8u l=0.4u
X136 xl2.xpre.fa vref xl2.xpre.tp xl2.xpre.tp pfet_03v3 ad=1.248p pd=5.32u as=1.248p ps=5.32u w=4.8u l=0.4u
X137 xbias.nmid EN VSS VSS nfet_03v3 ad=1.3p pd=5.52u as=1.3p ps=5.52u w=5u l=0.5u
X138 VDD VDD VDD VDD pfet_03v3 ad=1.3p pd=5.52u as=0 ps=0 w=5u l=1u
X139 xl0.xpre.fa vbn VSS VSS nfet_03v3 ad=0.65p pd=3.02u as=0.65p ps=3.02u w=2.5u l=1u
X140 VSS vbn xl1.xpre.tn VSS nfet_03v3 ad=0.65p pd=3.02u as=0.65p ps=3.02u w=2.5u l=1u
X141 VSS vbn vbn VSS nfet_03v3 ad=0.65p pd=3.02u as=0.65p ps=3.02u w=2.5u l=1u
X142 xl2.d2a VDD VDD VDD pfet_03v3 ad=0.52p pd=2.52u as=0.88p ps=4.88u w=2u l=0.5u
X143 xl2.d2b xl2.ob xl2.xhyst.sb VSS nfet_03v3 ad=1.1362p pd=4.89u as=1.1362p ps=4.89u w=4.37u l=0.5u
X144 vb2 vbp VDD VDD pfet_03v3 ad=1.3p pd=5.52u as=1.3p ps=5.52u w=5u l=1u
X145 xl0.xpre.fb xl0.gn xl0.xpre.tp xl0.xpre.tp pfet_03v3 ad=1.248p pd=5.32u as=1.248p ps=5.32u w=4.8u l=0.4u
X146 xl2.xpre.tp vref xl2.xpre.fa xl2.xpre.tp pfet_03v3 ad=1.248p pd=5.32u as=1.248p ps=5.32u w=4.8u l=0.4u
X147 VDD xbias.rdt_m1 VSS ppolyf_u_1k r_width=2u r_length=21.01u
X148 VSS vbn xl1.xhyst.ts VSS nfet_03v3 ad=0.65p pd=3.02u as=0.65p ps=3.02u w=2.5u l=1u
X149 xl2.xpre.tn vref xl2.oa VSS nfet_03v3 ad=1.235p pd=5.27u as=1.235p ps=5.27u w=4.75u l=0.5u
X150 xbias.nmid VSS VSS VSS nfet_03v3 ad=1.3p pd=5.52u as=2.2p ps=10.88u w=5u l=0.5u
X151 xl0.xhyst.sb xl0.ob xl0.d2b VSS nfet_03v3 ad=1.1362p pd=4.89u as=1.1362p ps=4.89u w=4.37u l=0.5u
X152 VSS VSS xl0.d2a VSS nfet_03v3 ad=1.9228p pd=9.62u as=1.1362p ps=4.89u w=4.37u l=0.5u
X153 xl2.xpre.fa vref xl2.xpre.tp xl2.xpre.tp pfet_03v3 ad=1.248p pd=5.32u as=1.248p ps=5.32u w=4.8u l=0.4u
X154 xl1.xpre.tn xl1.gn xl1.ob VSS nfet_03v3 ad=1.235p pd=5.27u as=1.235p ps=5.27u w=4.75u l=0.5u
X155 VDD EN xbias.enb VDD pfet_03v3 ad=0.65p pd=3.02u as=0.65p ps=3.02u w=2.5u l=0.28u
X156 xl2.xpre.fb vb2 xl2.ob VSS nfet_03v3 ad=1.1752p pd=5.04u as=1.1752p ps=5.04u w=4.52u l=0.5u
X157 xl2.xpre.tn vref xl2.ob VSS nfet_03v3 ad=1.235p pd=5.27u as=1.235p ps=5.27u w=4.75u l=0.5u
X158 xl2.xpre.fa vref xl2.xpre.tp xl2.xpre.tp pfet_03v3 ad=1.248p pd=5.32u as=1.248p ps=5.32u w=4.8u l=0.4u
X159 xl2.oa vb2 xl2.xpre.fa VSS nfet_03v3 ad=1.1752p pd=5.04u as=1.1752p ps=5.04u w=4.52u l=0.5u
X160 xl0.xpre.fb xl0.gn xl0.xpre.tp xl0.xpre.tp pfet_03v3 ad=1.248p pd=5.32u as=1.248p ps=5.32u w=4.8u l=0.4u
X161 xl1.xpre.fb xl1.gn xl1.xpre.tp xl1.xpre.tp pfet_03v3 ad=1.248p pd=5.32u as=1.248p ps=5.32u w=4.8u l=0.4u
X162 VSS vbn xl2.xpre.fa VSS nfet_03v3 ad=0.65p pd=3.02u as=0.65p ps=3.02u w=2.5u l=1u
X163 xl2.xpre.fb vb2 xl2.ob VSS nfet_03v3 ad=1.1752p pd=5.04u as=1.1752p ps=5.04u w=4.52u l=0.5u
X164 xl1.xpre.tn xl1.gp xl1.oa VSS nfet_03v3 ad=1.235p pd=5.27u as=1.235p ps=5.27u w=4.75u l=0.5u
X165 VDD xl1.d2b xl1.xout.d3 VDD pfet_03v3 ad=0.52p pd=2.52u as=0.52p ps=2.52u w=2u l=0.28u
X166 xl1.xhyst.ts vbn VSS VSS nfet_03v3 ad=0.65p pd=3.02u as=0.65p ps=3.02u w=2.5u l=1u
X167 VDD vbp xl1.xpre.tp VDD pfet_03v3 ad=1.3p pd=5.52u as=1.3p ps=5.52u w=5u l=1u
X168 VSS VSS VSS ppolyf_u_1k r_width=2u r_length=21.01u
X169 xbias.rdb_m2 xbias.rdb_m3 VSS ppolyf_u_1k r_width=2u r_length=19.26u
D1 xl1.gn VDD diode_pd2nw_03v3 pj=26u area=40p
X170 VDD vbp xl2.xpre.tp VDD pfet_03v3 ad=1.3p pd=5.52u as=1.3p ps=5.52u w=5u l=1u
X171 VDD vbp vb2 VDD pfet_03v3 ad=1.3p pd=5.52u as=1.3p ps=5.52u w=5u l=1u
X172 xl2.xpre.tp vref xl2.xpre.fb xl2.xpre.tp pfet_03v3 ad=1.248p pd=5.32u as=1.248p ps=5.32u w=4.8u l=0.4u
X173 VSS vbn xl0.xpre.fa VSS nfet_03v3 ad=0.65p pd=3.02u as=0.65p ps=3.02u w=2.5u l=1u
X174 xl0.ob vb2 xl0.xpre.fb VSS nfet_03v3 ad=1.1752p pd=5.04u as=1.1752p ps=5.04u w=4.52u l=0.5u
X175 xl1.xpre.fb vref xl1.xpre.tp xl1.xpre.tp pfet_03v3 ad=2.112p pd=10.48u as=1.248p ps=5.32u w=4.8u l=0.4u
X176 xl0.oa vref xl0.xpre.tn VSS nfet_03v3 ad=1.235p pd=5.27u as=1.235p ps=5.27u w=4.75u l=0.5u
X177 xl2.ob xl2.rlb_m1 VSS ppolyf_u_1k r_width=2u r_length=9.11u
X178 xl2.gn RX2_N VDD ppolyf_u r_width=5u r_length=1.8u
X179 xl0.xpre.tp xl0.gn xl0.xpre.fb xl0.xpre.tp pfet_03v3 ad=1.248p pd=5.32u as=1.248p ps=5.32u w=4.8u l=0.4u
X180 VSS VSS xbias.vf VSS nfet_03v3 ad=3.4804p pd=16.7u as=2.0566p ps=8.43u w=7.91u l=0.5u
X181 xl0.ob vb2 xl0.xpre.fb VSS nfet_03v3 ad=1.1752p pd=5.04u as=1.1752p ps=5.04u w=4.52u l=0.5u
X182 xl1.xpre.fb vbn VSS VSS nfet_03v3 ad=0.65p pd=3.02u as=0.65p ps=3.02u w=2.5u l=1u
X183 xl2.ob xl2.gn xl2.xpre.tn VSS nfet_03v3 ad=1.235p pd=5.27u as=1.235p ps=5.27u w=4.75u l=0.5u
X184 xl1.xpre.fb vref xl1.xpre.tp xl1.xpre.tp pfet_03v3 ad=1.248p pd=5.32u as=1.248p ps=5.32u w=4.8u l=0.4u
X185 xl1.xpre.tn vbn VSS VSS nfet_03v3 ad=0.65p pd=3.02u as=0.65p ps=3.02u w=2.5u l=1u
X186 VDD xl2.xout.nd xl2.xout.i1 VDD pfet_03v3 ad=0.962p pd=4.22u as=0.962p ps=4.22u w=3.7u l=0.28u
X187 xl1.xpre.tp vbp VDD VDD pfet_03v3 ad=1.3p pd=5.52u as=1.3p ps=5.52u w=5u l=1u
X188 xl2.xpre.fa vbn VSS VSS nfet_03v3 ad=0.65p pd=3.02u as=0.65p ps=3.02u w=2.5u l=1u
X189 VSS VSS xl1.d2b VSS nfet_03v3 ad=1.9228p pd=9.62u as=1.1362p ps=4.89u w=4.37u l=0.5u
X190 xl0.xpre.fa xl0.gp xl0.xpre.tp xl0.xpre.tp pfet_03v3 ad=1.248p pd=5.32u as=1.248p ps=5.32u w=4.8u l=0.4u
X191 xl0.xpre.tp vref xl0.xpre.fa xl0.xpre.tp pfet_03v3 ad=1.248p pd=5.32u as=1.248p ps=5.32u w=4.8u l=0.4u
X192 xl1.xpre.fb xl1.gn xl1.xpre.tp xl1.xpre.tp pfet_03v3 ad=1.248p pd=5.32u as=1.248p ps=5.32u w=4.8u l=0.4u
X193 xl0.ob VSS VSS VSS nfet_03v3 ad=1.1752p pd=5.04u as=1.9888p ps=9.92u w=4.52u l=0.5u
X194 VSS vbn xl1.xpre.fb VSS nfet_03v3 ad=0.65p pd=3.02u as=0.65p ps=3.02u w=2.5u l=1u
X195 xl2.xpre.tn vbn VSS VSS nfet_03v3 ad=0.65p pd=3.02u as=0.65p ps=3.02u w=2.5u l=1u
X196 xl2.xpre.tp vbp VDD VDD pfet_03v3 ad=1.3p pd=5.52u as=1.3p ps=5.52u w=5u l=1u
D2 VSS xl1.gn diode_nd2ps_03v3 pj=26u area=40p
X197 xl2.xpre.fb vref xl2.xpre.tp xl2.xpre.tp pfet_03v3 ad=1.248p pd=5.32u as=1.248p ps=5.32u w=4.8u l=0.4u
X198 VSS vbn xl1.xhyst.ts VSS nfet_03v3 ad=0.65p pd=3.02u as=0.65p ps=3.02u w=2.5u l=1u
X199 xl2.d2a VSS VSS VSS nfet_03v3 ad=1.1362p pd=4.89u as=1.9228p ps=9.62u w=4.37u l=0.5u
X200 xl2.xpre.tp vbp VDD VDD pfet_03v3 ad=1.3p pd=5.52u as=1.3p ps=5.52u w=5u l=1u
X201 xl2.oa vref xl2.xpre.tn VSS nfet_03v3 ad=1.235p pd=5.27u as=1.235p ps=5.27u w=4.75u l=0.5u
X202 xl1.xout.i2 VDD VDD VDD pfet_03v3 ad=0.975p pd=4.27u as=1.65p ps=8.38u w=3.75u l=0.28u
X203 vb2 VSS VSS VSS nfet_03v3 ad=2.0566p pd=8.43u as=3.4804p ps=16.7u w=7.91u l=0.5u
X204 VSS vbn xl1.xhyst.ts VSS nfet_03v3 ad=0.65p pd=3.02u as=0.65p ps=3.02u w=2.5u l=1u
X205 VSS VSS VSS ppolyf_u_1k r_width=2u r_length=9.11u
X206 xl1.xpre.fb vref xl1.xpre.tp xl1.xpre.tp pfet_03v3 ad=1.248p pd=5.32u as=1.248p ps=5.32u w=4.8u l=0.4u
X207 xl0.xpre.tp xl0.gn xl0.xpre.fb xl0.xpre.tp pfet_03v3 ad=1.248p pd=5.32u as=1.248p ps=5.32u w=4.8u l=0.4u
X208 xl2.xpre.fb xl2.gn xl2.xpre.tp xl2.xpre.tp pfet_03v3 ad=1.248p pd=5.32u as=1.248p ps=5.32u w=4.8u l=0.4u
X209 xl0.xpre.fb vbn VSS VSS nfet_03v3 ad=0.65p pd=3.02u as=0.65p ps=3.02u w=2.5u l=1u
X210 xl2.ob xl2.gn xl2.xpre.tn VSS nfet_03v3 ad=1.235p pd=5.27u as=1.235p ps=5.27u w=4.75u l=0.5u
X211 VDD vbp xl1.xpre.tp VDD pfet_03v3 ad=1.3p pd=5.52u as=1.3p ps=5.52u w=5u l=1u
X212 xl1.xpre.fa vref xl1.xpre.tp xl1.xpre.tp pfet_03v3 ad=1.248p pd=5.32u as=1.248p ps=5.32u w=4.8u l=0.4u
X213 xl2.xpre.tp xl2.gp xl2.xpre.fa xl2.xpre.tp pfet_03v3 ad=1.248p pd=5.32u as=1.248p ps=5.32u w=4.8u l=0.4u
X214 xl0.xpre.tp vbp VDD VDD pfet_03v3 ad=1.3p pd=5.52u as=1.3p ps=5.52u w=5u l=1u
X215 VDD VDD VDD VDD pfet_03v3 ad=0.52p pd=2.52u as=0 ps=0 w=2u l=0.5u
X216 vbp VDD VDD VDD pfet_03v3 ad=1.3p pd=5.52u as=2.2p ps=10.88u w=5u l=1u
X217 xl2.oa xl2.gp xl2.xpre.tn VSS nfet_03v3 ad=1.235p pd=5.27u as=1.235p ps=5.27u w=4.75u l=0.5u
X218 VSS VSS xl1.xpre.fa VSS nfet_03v3 ad=1.9888p pd=9.92u as=1.1752p ps=5.04u w=4.52u l=0.5u
X219 xl0.xout.n3a xl0.d2a VDD VDD pfet_03v3 ad=0.52p pd=2.52u as=0.52p ps=2.52u w=2u l=0.28u
X220 VSS vbn xl2.xpre.fa VSS nfet_03v3 ad=0.65p pd=3.02u as=0.65p ps=3.02u w=2.5u l=1u
X221 xl0.xpre.tn xl0.gp xl0.oa VSS nfet_03v3 ad=1.235p pd=5.27u as=1.235p ps=5.27u w=4.75u l=0.5u
X222 VDD vbp vbp VDD pfet_03v3 ad=1.3p pd=5.52u as=1.3p ps=5.52u w=5u l=1u
X223 xl0.xpre.fb xl0.gn xl0.xpre.tp xl0.xpre.tp pfet_03v3 ad=1.248p pd=5.32u as=1.248p ps=5.32u w=4.8u l=0.4u
X224 xl1.xpre.tp vref xl1.xpre.fb xl1.xpre.tp pfet_03v3 ad=1.248p pd=5.32u as=1.248p ps=5.32u w=4.8u l=0.4u
X225 VSS vbn xl0.xpre.fb VSS nfet_03v3 ad=0.65p pd=3.02u as=0.65p ps=3.02u w=2.5u l=1u
X226 VDD vbp xl2.xpre.tp VDD pfet_03v3 ad=1.3p pd=5.52u as=1.3p ps=5.52u w=5u l=1u
X227 xl1.xpre.fa xl1.gp xl1.xpre.tp xl1.xpre.tp pfet_03v3 ad=1.248p pd=5.32u as=1.248p ps=5.32u w=4.8u l=0.4u
X228 xl1.oa vb2 xl1.xpre.fa VSS nfet_03v3 ad=1.1752p pd=5.04u as=1.1752p ps=5.04u w=4.52u l=0.5u
X229 VSS VSS xl2.xpre.tn VSS nfet_03v3 ad=1.1p pd=5.88u as=0.65p ps=3.02u w=2.5u l=1u
X230 VSS vbn xl1.xpre.fa VSS nfet_03v3 ad=0.65p pd=3.02u as=0.65p ps=3.02u w=2.5u l=1u
X231 VSS VSS VSS ppolyf_u_1k r_width=2u r_length=22.27u
X232 xl0.xpre.fb vref xl0.xpre.tp xl0.xpre.tp pfet_03v3 ad=1.248p pd=5.32u as=1.248p ps=5.32u w=4.8u l=0.4u
X233 xl0.xpre.tn xl0.gp xl0.oa VSS nfet_03v3 ad=1.235p pd=5.27u as=1.235p ps=5.27u w=4.75u l=0.5u
X234 VDD xl0.d2a xl0.d2a VDD pfet_03v3 ad=0.52p pd=2.52u as=0.52p ps=2.52u w=2u l=0.28u
X235 VDD vbp xl2.xpre.tp VDD pfet_03v3 ad=1.3p pd=5.52u as=1.3p ps=5.52u w=5u l=1u
X236 xl2.xpre.tp xl2.gn xl2.xpre.fb xl2.xpre.tp pfet_03v3 ad=1.248p pd=5.32u as=1.248p ps=5.32u w=4.8u l=0.4u
X237 xl1.xpre.tp xl1.gp xl1.xpre.fa xl1.xpre.tp pfet_03v3 ad=1.248p pd=5.32u as=1.248p ps=5.32u w=4.8u l=0.4u
X238 xl0.xpre.tn xl0.gn xl0.ob VSS nfet_03v3 ad=1.235p pd=5.27u as=1.235p ps=5.27u w=4.75u l=0.5u
X239 xbias.nrb VDD VDD VDD pfet_03v3 ad=1.3p pd=5.52u as=2.2p ps=10.88u w=5u l=0.5u
X240 xl2.xpre.fa vbn VSS VSS nfet_03v3 ad=0.65p pd=3.02u as=0.65p ps=3.02u w=2.5u l=1u
X241 VSS VSS vbp VSS nfet_03v3 ad=1.1p pd=5.88u as=0.65p ps=3.02u w=2.5u l=1u
X242 VDD xl1.d2b xl1.xout.d3 VDD pfet_03v3 ad=0.52p pd=2.52u as=0.52p ps=2.52u w=2u l=0.28u
X243 VDD xl0.d2b xl0.d2b VDD pfet_03v3 ad=0.52p pd=2.52u as=0.52p ps=2.52u w=2u l=0.28u
X244 xl2.xpre.tn vref xl2.ob VSS nfet_03v3 ad=1.235p pd=5.27u as=2.09p ps=10.38u w=4.75u l=0.5u
X245 xl2.xpre.tn vref xl2.oa VSS nfet_03v3 ad=1.235p pd=5.27u as=1.235p ps=5.27u w=4.75u l=0.5u
X246 xl2.xpre.tp vbp VDD VDD pfet_03v3 ad=1.3p pd=5.52u as=1.3p ps=5.52u w=5u l=1u
X247 xl0.xpre.fb xl0.gn xl0.xpre.tp xl0.xpre.tp pfet_03v3 ad=1.248p pd=5.32u as=1.248p ps=5.32u w=4.8u l=0.4u
X248 xl1.xout.d3 xl1.xout.n3a VSS VSS nfet_03v3 ad=0.6734p pd=3.11u as=0.6734p ps=3.11u w=2.59u l=0.28u
X249 VSS VSS VSS VSS nfet_03v3 ad=0.52p pd=2.52u as=0 ps=0 w=2u l=0.5u
X250 xbias.rb_m1 xbias.nrb VSS ppolyf_u_1k r_width=2u r_length=22.27u
X251 xl0.xpre.tp vref xl0.xpre.fa xl0.xpre.tp pfet_03v3 ad=1.248p pd=5.32u as=1.248p ps=5.32u w=4.8u l=0.4u
X252 VSS xl1.xout.i1 xl1.xout.i2 VSS nfet_03v3 ad=0.78p pd=3.52u as=0.78p ps=3.52u w=3u l=0.28u
X253 VSS xl1.xout.i2 RX1_O VSS nfet_03v3 ad=1.04p pd=4.52u as=1.04p ps=4.52u w=4u l=0.28u
X254 xl2.xpre.fb xl2.gn xl2.xpre.tp xl2.xpre.tp pfet_03v3 ad=1.248p pd=5.32u as=1.248p ps=5.32u w=4.8u l=0.4u
X255 xl1.oa xl1.gp xl1.xpre.tn VSS nfet_03v3 ad=1.235p pd=5.27u as=1.235p ps=5.27u w=4.75u l=0.5u
X256 VDD VDD xl1.xpre.tp VDD pfet_03v3 ad=2.2p pd=10.88u as=1.3p ps=5.52u w=5u l=1u
X257 xl2.xpre.fb vref xl2.xpre.tp xl2.xpre.tp pfet_03v3 ad=1.248p pd=5.32u as=1.248p ps=5.32u w=4.8u l=0.4u
X258 vbn VSS VSS VSS nfet_03v3 ad=0.52p pd=2.52u as=0.88p ps=4.88u w=2u l=0.5u
X259 VDD xl1.xout.d3 xl1.xout.nd VDD pfet_03v3 ad=0.78p pd=3.52u as=0.78p ps=3.52u w=3u l=0.28u
X260 xl0.xpre.tp vref xl0.xpre.fa xl0.xpre.tp pfet_03v3 ad=1.248p pd=5.32u as=1.248p ps=5.32u w=4.8u l=0.4u
X261 xl1.xpre.fb xl1.gn xl1.xpre.tp xl1.xpre.tp pfet_03v3 ad=1.248p pd=5.32u as=1.248p ps=5.32u w=4.8u l=0.4u
X262 xl1.ob vref xl1.xpre.tn VSS nfet_03v3 ad=1.235p pd=5.27u as=1.235p ps=5.27u w=4.75u l=0.5u
X263 xl1.xpre.fb vbn VSS VSS nfet_03v3 ad=0.65p pd=3.02u as=0.65p ps=3.02u w=2.5u l=1u
X264 VSS vbn xl2.xpre.tn VSS nfet_03v3 ad=0.65p pd=3.02u as=0.65p ps=3.02u w=2.5u l=1u
X265 xl2.d2a xl2.d2a VDD VDD pfet_03v3 ad=0.52p pd=2.52u as=0.52p ps=2.52u w=2u l=0.28u
X266 VDD VDD VDD VDD pfet_03v3 ad=0.52p pd=2.52u as=0 ps=0 w=2u l=0.5u
X267 xl1.d2b xl1.d2b VDD VDD pfet_03v3 ad=0.52p pd=2.52u as=0.52p ps=2.52u w=2u l=0.28u
X268 xl0.xpre.fa vref xl0.xpre.tp xl0.xpre.tp pfet_03v3 ad=1.248p pd=5.32u as=1.248p ps=5.32u w=4.8u l=0.4u
X269 xl1.xpre.tp xl1.gp xl1.xpre.fa xl1.xpre.tp pfet_03v3 ad=1.248p pd=5.32u as=1.248p ps=5.32u w=4.8u l=0.4u
X270 xl1.xpre.tp xl1.gp xl1.xpre.fa xl1.xpre.tp pfet_03v3 ad=1.248p pd=5.32u as=1.248p ps=5.32u w=4.8u l=0.4u
X271 xl2.xpre.tp vref xl2.xpre.fa xl2.xpre.tp pfet_03v3 ad=1.248p pd=5.32u as=1.248p ps=5.32u w=4.8u l=0.4u
X272 xl0.xout.d3 xl0.d2b VDD VDD pfet_03v3 ad=0.52p pd=2.52u as=0.52p ps=2.52u w=2u l=0.28u
X273 RX1_O xl1.xout.i2 VDD VDD pfet_03v3 ad=1.3p pd=5.52u as=1.3p ps=5.52u w=5u l=0.28u
X274 xl2.d2b VSS VSS VSS nfet_03v3 ad=1.1362p pd=4.89u as=1.9228p ps=9.62u w=4.37u l=0.5u
X275 xl0.xpre.tp xl0.gn xl0.xpre.fb xl0.xpre.tp pfet_03v3 ad=1.248p pd=5.32u as=1.248p ps=5.32u w=4.8u l=0.4u
X276 VSS xl2.xout.n3a xl2.xout.n3a VSS nfet_03v3 ad=0.6734p pd=3.11u as=0.6734p ps=3.11u w=2.59u l=0.28u
X277 xl0.d2b xl0.d2a VDD VDD pfet_03v3 ad=0.52p pd=2.52u as=0.52p ps=2.52u w=2u l=0.28u
X278 xl1.xpre.fa xl1.gp xl1.xpre.tp xl1.xpre.tp pfet_03v3 ad=1.248p pd=5.32u as=1.248p ps=5.32u w=4.8u l=0.4u
X279 xbias.nmid xbias.rdb_m3 VSS ppolyf_u_1k r_width=2u r_length=19.26u
X280 VSS VSS VSS ppolyf_u_1k r_width=2u r_length=3.17u
X281 xl0.xhyst.sa xl0.oa xl0.d2a VSS nfet_03v3 ad=1.1362p pd=4.89u as=1.1362p ps=4.89u w=4.37u l=0.5u
X282 VSS VSS xl1.xhyst.ts VSS nfet_03v3 ad=1.1p pd=5.88u as=0.65p ps=3.02u w=2.5u l=1u
X283 xl2.xpre.tn vref xl2.oa VSS nfet_03v3 ad=1.235p pd=5.27u as=1.235p ps=5.27u w=4.75u l=0.5u
X284 xl2.xout.nd VDD VDD VDD pfet_03v3 ad=0.78p pd=3.52u as=1.32p ps=6.88u w=3u l=0.28u
X285 xl0.xpre.fa xl0.gp xl0.xpre.tp xl0.xpre.tp pfet_03v3 ad=1.248p pd=5.32u as=1.248p ps=5.32u w=4.8u l=0.4u
X286 VDD VDD xl1.d2b VDD pfet_03v3 ad=0.88p pd=4.88u as=0.52p ps=2.52u w=2u l=0.28u
X287 xl2.xpre.fb vb2 xl2.ob VSS nfet_03v3 ad=1.1752p pd=5.04u as=1.1752p ps=5.04u w=4.52u l=0.5u
X288 xl0.ob vref xl0.xpre.tn VSS nfet_03v3 ad=2.09p pd=10.38u as=1.235p ps=5.27u w=4.75u l=0.5u
X289 xl1.xpre.tn xl1.gn xl1.ob VSS nfet_03v3 ad=1.235p pd=5.27u as=1.235p ps=5.27u w=4.75u l=0.5u
X290 xl2.xout.n3a xl2.d2a VDD VDD pfet_03v3 ad=0.52p pd=2.52u as=0.52p ps=2.52u w=2u l=0.28u
X291 xl1.xout.i2 VSS VSS VSS nfet_03v3 ad=0.78p pd=3.52u as=1.32p ps=6.88u w=3u l=0.28u
X292 VDD vbp xl0.xpre.tp VDD pfet_03v3 ad=1.3p pd=5.52u as=1.3p ps=5.52u w=5u l=1u
X293 xl1.xpre.tp vref xl1.xpre.fb xl1.xpre.tp pfet_03v3 ad=1.248p pd=5.32u as=1.248p ps=5.32u w=4.8u l=0.4u
X294 xl2.xpre.fa xl2.gp xl2.xpre.tp xl2.xpre.tp pfet_03v3 ad=1.248p pd=5.32u as=1.248p ps=5.32u w=4.8u l=0.4u
X295 xl0.oa vb2 xl0.xpre.fa VSS nfet_03v3 ad=1.1752p pd=5.04u as=1.1752p ps=5.04u w=4.52u l=0.5u
X296 VSS vbn xl0.xpre.fb VSS nfet_03v3 ad=0.65p pd=3.02u as=0.65p ps=3.02u w=2.5u l=1u
X297 RX1_O VSS VSS VSS nfet_03v3 ad=1.04p pd=4.52u as=1.76p ps=8.88u w=4u l=0.28u
X298 VSS VSS xl0.xpre.fb VSS nfet_03v3 ad=1.9888p pd=9.92u as=1.1752p ps=5.04u w=4.52u l=0.5u
X299 VSS VSS VSS VSS nfet_03v3 ad=0.39p pd=2.02u as=0 ps=0 w=1.5u l=0.28u
X300 VDD vbp xl1.xpre.tp VDD pfet_03v3 ad=1.3p pd=5.52u as=1.3p ps=5.52u w=5u l=1u
X301 xbias.rb_m1 xbias.rb_m2 VSS ppolyf_u_1k r_width=2u r_length=22.27u
X302 VDD EN vbp VDD pfet_03v3 ad=0.52p pd=2.52u as=0.52p ps=2.52u w=2u l=0.5u
X303 xl2.oa xl2.rla_m1 VSS ppolyf_u_1k r_width=2u r_length=9.11u
X304 xl2.xhyst.ts vbn VSS VSS nfet_03v3 ad=0.65p pd=3.02u as=0.65p ps=3.02u w=2.5u l=1u
X305 VDD vbp xl0.xpre.tp VDD pfet_03v3 ad=1.3p pd=5.52u as=1.3p ps=5.52u w=5u l=1u
X306 xl2.xpre.tp vref xl2.xpre.fa xl2.xpre.tp pfet_03v3 ad=1.248p pd=5.32u as=1.248p ps=5.32u w=4.8u l=0.4u
X307 VDD xl1.d2b xl1.d2a VDD pfet_03v3 ad=0.52p pd=2.52u as=0.52p ps=2.52u w=2u l=0.28u
X308 xl0.oa VSS VSS VSS nfet_03v3 ad=1.1752p pd=5.04u as=1.9888p ps=9.92u w=4.52u l=0.5u
X309 VDD VDD xl2.xout.n3a VDD pfet_03v3 ad=0.88p pd=4.88u as=0.52p ps=2.52u w=2u l=0.28u
X310 xl2.xpre.tp vref xl2.xpre.fb xl2.xpre.tp pfet_03v3 ad=1.248p pd=5.32u as=1.248p ps=5.32u w=4.8u l=0.4u
X311 VSS VSS VSS VSS nfet_03v3 ad=0.78p pd=3.52u as=0 ps=0 w=3u l=0.28u
X312 VSS vbn vbp VSS nfet_03v3 ad=0.65p pd=3.02u as=0.65p ps=3.02u w=2.5u l=1u
X313 VDD xl0.d2a xl0.xout.n3a VDD pfet_03v3 ad=0.52p pd=2.52u as=0.52p ps=2.52u w=2u l=0.28u
X314 xl0.xhyst.ts vbn VSS VSS nfet_03v3 ad=0.65p pd=3.02u as=0.65p ps=3.02u w=2.5u l=1u
X315 VSS VSS VSS VSS nfet_03v3 ad=0.6734p pd=3.11u as=0 ps=0 w=2.59u l=0.28u
X316 xl0.xpre.tp xl0.gn xl0.xpre.fb xl0.xpre.tp pfet_03v3 ad=1.248p pd=5.32u as=1.248p ps=5.32u w=4.8u l=0.4u
X317 xl2.xpre.fa vref xl2.xpre.tp xl2.xpre.tp pfet_03v3 ad=1.248p pd=5.32u as=1.248p ps=5.32u w=4.8u l=0.4u
X318 VDD xl1.xout.i2 RX1_O VDD pfet_03v3 ad=1.3p pd=5.52u as=1.3p ps=5.52u w=5u l=0.28u
X319 xl1.xpre.fb vref xl1.xpre.tp xl1.xpre.tp pfet_03v3 ad=1.248p pd=5.32u as=1.248p ps=5.32u w=4.8u l=0.4u
X320 xl0.oa xl0.gp xl0.xpre.tn VSS nfet_03v3 ad=1.235p pd=5.27u as=1.235p ps=5.27u w=4.75u l=0.5u
X321 xl1.xpre.tn vref xl1.oa VSS nfet_03v3 ad=1.235p pd=5.27u as=1.235p ps=5.27u w=4.75u l=0.5u
X322 xl0.d2b xl0.d2b VDD VDD pfet_03v3 ad=0.52p pd=2.52u as=0.52p ps=2.52u w=2u l=0.28u
X323 xl1.xpre.tp vref xl1.xpre.fb xl1.xpre.tp pfet_03v3 ad=1.248p pd=5.32u as=1.248p ps=5.32u w=4.8u l=0.4u
X324 VDD VDD xl2.xout.nd VDD pfet_03v3 ad=1.32p pd=6.88u as=0.78p ps=3.52u w=3u l=0.28u
X325 xl2.d2b xl2.d2a VDD VDD pfet_03v3 ad=0.52p pd=2.52u as=0.52p ps=2.52u w=2u l=0.28u
X326 xl0.xpre.fa xl0.gp xl0.xpre.tp xl0.xpre.tp pfet_03v3 ad=1.248p pd=5.32u as=1.248p ps=5.32u w=4.8u l=0.4u
X327 xl2.xpre.tp xl2.gn xl2.xpre.fb xl2.xpre.tp pfet_03v3 ad=1.248p pd=5.32u as=1.248p ps=5.32u w=4.8u l=0.4u
X328 xl0.ob xl0.gn xl0.xpre.tn VSS nfet_03v3 ad=1.235p pd=5.27u as=1.235p ps=5.27u w=4.75u l=0.5u
X329 xl0.xpre.tp vbp VDD VDD pfet_03v3 ad=1.3p pd=5.52u as=1.3p ps=5.52u w=5u l=1u
X330 VDD xl2.xout.i1 xl2.xout.i2 VDD pfet_03v3 ad=0.975p pd=4.27u as=0.975p ps=4.27u w=3.75u l=0.28u
X331 xl1.xout.n3a xl1.d2a VDD VDD pfet_03v3 ad=0.52p pd=2.52u as=0.52p ps=2.52u w=2u l=0.28u
X332 xl0.d2a xl0.d2a VDD VDD pfet_03v3 ad=0.52p pd=2.52u as=0.52p ps=2.52u w=2u l=0.28u
X333 xl0.xhyst.ts xl0.xhyst.sb VSS ppolyf_u_1k r_width=2u r_length=3.17u
X334 xl1.gp RX1_P VDD ppolyf_u r_width=5u r_length=1.8u
X335 xl0.ob vref xl0.xpre.tn VSS nfet_03v3 ad=1.235p pd=5.27u as=1.235p ps=5.27u w=4.75u l=0.5u
X336 VSS vbn xl0.xpre.fa VSS nfet_03v3 ad=0.65p pd=3.02u as=0.65p ps=3.02u w=2.5u l=1u
X337 VSS VSS VSS VSS nfet_03v3 ad=1.1396p pd=6.06u as=0 ps=0 w=2.59u l=0.28u
X338 xl2.ob xl2.gn xl2.xpre.tn VSS nfet_03v3 ad=1.235p pd=5.27u as=1.235p ps=5.27u w=4.75u l=0.5u
X339 xl1.xpre.tp vbp VDD VDD pfet_03v3 ad=1.3p pd=5.52u as=1.3p ps=5.52u w=5u l=1u
X340 xl0.xpre.fa vref xl0.xpre.tp xl0.xpre.tp pfet_03v3 ad=1.248p pd=5.32u as=1.248p ps=5.32u w=4.8u l=0.4u
X341 xl1.xpre.fa vref xl1.xpre.tp xl1.xpre.tp pfet_03v3 ad=1.248p pd=5.32u as=1.248p ps=5.32u w=4.8u l=0.4u
X342 xl1.xpre.tp xl1.gp xl1.xpre.fa xl1.xpre.tp pfet_03v3 ad=1.248p pd=5.32u as=1.248p ps=5.32u w=4.8u l=0.4u
X343 VSS vbn xl0.xpre.tn VSS nfet_03v3 ad=0.65p pd=3.02u as=0.65p ps=3.02u w=2.5u l=1u
X344 xl2.xhyst.ts VSS VSS VSS nfet_03v3 ad=0.65p pd=3.02u as=1.1p ps=5.88u w=2.5u l=1u
X345 xl1.d2a VDD VDD VDD pfet_03v3 ad=0.52p pd=2.52u as=0.88p ps=4.88u w=2u l=0.5u
X346 VSS VSS xl1.xpre.fa VSS nfet_03v3 ad=1.1p pd=5.88u as=0.65p ps=3.02u w=2.5u l=1u
X347 xl2.ob xl2.gn xl2.xpre.tn VSS nfet_03v3 ad=1.235p pd=5.27u as=1.235p ps=5.27u w=4.75u l=0.5u
X348 VSS vbn xl0.xhyst.ts VSS nfet_03v3 ad=0.65p pd=3.02u as=0.65p ps=3.02u w=2.5u l=1u
X349 VSS xl0.xout.i2 RX0_O VSS nfet_03v3 ad=1.04p pd=4.52u as=1.04p ps=4.52u w=4u l=0.28u
X350 VSS xl0.xout.i1 xl0.xout.i2 VSS nfet_03v3 ad=0.78p pd=3.52u as=0.78p ps=3.52u w=3u l=0.28u
X351 xl0.xpre.tn xl0.gn xl0.ob VSS nfet_03v3 ad=1.235p pd=5.27u as=1.235p ps=5.27u w=4.75u l=0.5u
X352 xbias.nrb xbias.enb VDD VDD pfet_03v3 ad=1.3p pd=5.52u as=1.3p ps=5.52u w=5u l=0.5u
X353 xl2.oa xl2.gp xl2.xpre.tn VSS nfet_03v3 ad=1.235p pd=5.27u as=1.235p ps=5.27u w=4.75u l=0.5u
X354 VDD xl2.d2b xl2.d2a VDD pfet_03v3 ad=0.52p pd=2.52u as=0.52p ps=2.52u w=2u l=0.28u
X355 xl1.xpre.fa vref xl1.xpre.tp xl1.xpre.tp pfet_03v3 ad=1.248p pd=5.32u as=1.248p ps=5.32u w=4.8u l=0.4u
X356 xl1.oa vb2 xl1.xpre.fa VSS nfet_03v3 ad=1.1752p pd=5.04u as=1.1752p ps=5.04u w=4.52u l=0.5u
X357 xl0.xpre.fb xl0.gn xl0.xpre.tp xl0.xpre.tp pfet_03v3 ad=1.248p pd=5.32u as=1.248p ps=5.32u w=4.8u l=0.4u
X358 xl0.xpre.tn xl0.gp xl0.oa VSS nfet_03v3 ad=1.235p pd=5.27u as=1.235p ps=5.27u w=4.75u l=0.5u
X359 VDD xl2.d2a xl2.d2b VDD pfet_03v3 ad=0.52p pd=2.52u as=0.52p ps=2.52u w=2u l=0.28u
X360 VDD xl0.d2b xl0.xout.d3 VDD pfet_03v3 ad=0.52p pd=2.52u as=0.52p ps=2.52u w=2u l=0.28u
X361 xl2.xpre.tp xl2.gp xl2.xpre.fa xl2.xpre.tp pfet_03v3 ad=1.248p pd=5.32u as=1.248p ps=5.32u w=4.8u l=0.4u
X362 xbias.nrb xbias.enb VDD VDD pfet_03v3 ad=1.3p pd=5.52u as=1.3p ps=5.52u w=5u l=0.5u
X363 xl1.xpre.fa vref xl1.xpre.tp xl1.xpre.tp pfet_03v3 ad=1.248p pd=5.32u as=1.248p ps=5.32u w=4.8u l=0.4u
X364 xl2.xpre.fa xl2.gp xl2.xpre.tp xl2.xpre.tp pfet_03v3 ad=1.248p pd=5.32u as=1.248p ps=5.32u w=4.8u l=0.4u
X365 xl0.xhyst.ts vbn VSS VSS nfet_03v3 ad=0.65p pd=3.02u as=0.65p ps=3.02u w=2.5u l=1u
X366 VDD vbp xl0.xpre.tp VDD pfet_03v3 ad=1.3p pd=5.52u as=1.3p ps=5.52u w=5u l=1u
D3 xl0.gn VDD diode_pd2nw_03v3 pj=26u area=40p
X367 VSS xl2.xout.i1 xl2.xout.i2 VSS nfet_03v3 ad=0.78p pd=3.52u as=0.78p ps=3.52u w=3u l=0.28u
X368 VSS xl2.xout.i2 RX2_O VSS nfet_03v3 ad=1.04p pd=4.52u as=1.04p ps=4.52u w=4u l=0.28u
X369 xl0.xpre.fb vref xl0.xpre.tp xl0.xpre.tp pfet_03v3 ad=2.112p pd=10.48u as=1.248p ps=5.32u w=4.8u l=0.4u
X370 xl2.xpre.fa xl2.gp xl2.xpre.tp xl2.xpre.tp pfet_03v3 ad=1.248p pd=5.32u as=1.248p ps=5.32u w=4.8u l=0.4u
X371 xl2.xpre.tp xl2.gn xl2.xpre.fb xl2.xpre.tp pfet_03v3 ad=1.248p pd=5.32u as=1.248p ps=5.32u w=4.8u l=0.4u
X372 xbias.nrb xbias.enb VDD VDD pfet_03v3 ad=1.3p pd=5.52u as=1.3p ps=5.52u w=5u l=0.5u
X373 RX0_O xl0.xout.i2 VDD VDD pfet_03v3 ad=1.3p pd=5.52u as=1.3p ps=5.52u w=5u l=0.28u
X374 xl1.xpre.tn vref xl1.ob VSS nfet_03v3 ad=1.235p pd=5.27u as=1.235p ps=5.27u w=4.75u l=0.5u
X375 xl0.xpre.fb vbn VSS VSS nfet_03v3 ad=0.65p pd=3.02u as=0.65p ps=3.02u w=2.5u l=1u
X376 xl1.ob xl1.gn xl1.xpre.tn VSS nfet_03v3 ad=1.235p pd=5.27u as=1.235p ps=5.27u w=4.75u l=0.5u
X377 xl2.xpre.tn vref xl2.ob VSS nfet_03v3 ad=1.235p pd=5.27u as=1.235p ps=5.27u w=4.75u l=0.5u
X378 xl0.xpre.fb vref xl0.xpre.tp xl0.xpre.tp pfet_03v3 ad=1.248p pd=5.32u as=1.248p ps=5.32u w=4.8u l=0.4u
X379 VDD xl2.d2a xl2.xout.n3a VDD pfet_03v3 ad=0.52p pd=2.52u as=0.52p ps=2.52u w=2u l=0.28u
X380 xl1.xpre.fa vbn VSS VSS nfet_03v3 ad=0.65p pd=3.02u as=0.65p ps=3.02u w=2.5u l=1u
X381 xl0.xpre.tn vbn VSS VSS nfet_03v3 ad=0.65p pd=3.02u as=0.65p ps=3.02u w=2.5u l=1u
X382 VDD xl1.xout.nd xl1.xout.i1 VDD pfet_03v3 ad=0.962p pd=4.22u as=0.962p ps=4.22u w=3.7u l=0.28u
X383 VSS vbn xl2.xhyst.ts VSS nfet_03v3 ad=0.65p pd=3.02u as=0.65p ps=3.02u w=2.5u l=1u
X384 xl0.xpre.tp vbp VDD VDD pfet_03v3 ad=1.3p pd=5.52u as=1.3p ps=5.52u w=5u l=1u
X385 xl1.xpre.fb vb2 xl1.ob VSS nfet_03v3 ad=1.1752p pd=5.04u as=1.1752p ps=5.04u w=4.52u l=0.5u
X386 VSS VSS xl0.d2b VSS nfet_03v3 ad=1.9228p pd=9.62u as=1.1362p ps=4.89u w=4.37u l=0.5u
X387 xl2.xpre.fa xl2.gp xl2.xpre.tp xl2.xpre.tp pfet_03v3 ad=1.248p pd=5.32u as=1.248p ps=5.32u w=4.8u l=0.4u
X388 VSS vbn xl0.xpre.fb VSS nfet_03v3 ad=0.65p pd=3.02u as=0.65p ps=3.02u w=2.5u l=1u
X389 xl1.xpre.tn vbn VSS VSS nfet_03v3 ad=0.65p pd=3.02u as=0.65p ps=3.02u w=2.5u l=1u
X390 xl1.xpre.tp vbp VDD VDD pfet_03v3 ad=1.3p pd=5.52u as=1.3p ps=5.52u w=5u l=1u
X391 xl0.xpre.fb xl0.gn xl0.xpre.tp xl0.xpre.tp pfet_03v3 ad=1.248p pd=5.32u as=1.248p ps=5.32u w=4.8u l=0.4u
X392 RX2_O xl2.xout.i2 VDD VDD pfet_03v3 ad=1.3p pd=5.52u as=1.3p ps=5.52u w=5u l=0.28u
X393 VDD vbp vbp VDD pfet_03v3 ad=1.3p pd=5.52u as=1.3p ps=5.52u w=5u l=1u
X394 VSS vbn xl0.xhyst.ts VSS nfet_03v3 ad=0.65p pd=3.02u as=0.65p ps=3.02u w=2.5u l=1u
X395 xl0.xout.i2 VSS VSS VSS nfet_03v3 ad=0.78p pd=3.52u as=1.32p ps=6.88u w=3u l=0.28u
X396 xl1.d2a VSS VSS VSS nfet_03v3 ad=1.1362p pd=4.89u as=1.9228p ps=9.62u w=4.37u l=0.5u
D4 VSS xl0.gn diode_nd2ps_03v3 pj=26u area=40p
X397 RX0_O VSS VSS VSS nfet_03v3 ad=1.04p pd=4.52u as=1.76p ps=8.88u w=4u l=0.28u
X398 VSS VSS VSS VSS nfet_03v3 ad=0.39p pd=2.02u as=0 ps=0 w=1.5u l=0.28u
X399 xl1.oa vref xl1.xpre.tn VSS nfet_03v3 ad=1.235p pd=5.27u as=1.235p ps=5.27u w=4.75u l=0.5u
X400 xl0.xout.i2 VDD VDD VDD pfet_03v3 ad=0.975p pd=4.27u as=1.65p ps=8.38u w=3.75u l=0.28u
X401 xl1.d2b VDD VDD VDD pfet_03v3 ad=0.52p pd=2.52u as=0.88p ps=4.88u w=2u l=0.5u
X402 xl2.xpre.fb vbn VSS VSS nfet_03v3 ad=0.65p pd=3.02u as=0.65p ps=3.02u w=2.5u l=1u
X403 VSS vbn xl0.xhyst.ts VSS nfet_03v3 ad=0.65p pd=3.02u as=0.65p ps=3.02u w=2.5u l=1u
X404 VSS VSS VSS VSS nfet_03v3 ad=0.78p pd=3.52u as=0 ps=0 w=3u l=0.28u
X405 VSS VSS VSS ppolyf_u_1k r_width=2u r_length=9.11u
X406 xl0.xpre.fb vref xl0.xpre.tp xl0.xpre.tp pfet_03v3 ad=1.248p pd=5.32u as=1.248p ps=5.32u w=4.8u l=0.4u
X407 xl1.xpre.fb vref xl1.xpre.tp xl1.xpre.tp pfet_03v3 ad=1.248p pd=5.32u as=1.248p ps=5.32u w=4.8u l=0.4u
X408 xl2.xpre.fa vbn VSS VSS nfet_03v3 ad=0.65p pd=3.02u as=0.65p ps=3.02u w=2.5u l=1u
X409 xl2.xout.i1 VDD VDD VDD pfet_03v3 ad=0.962p pd=4.22u as=1.628p ps=8.28u w=3.7u l=0.28u
X410 VDD vbp xl0.xpre.tp VDD pfet_03v3 ad=1.3p pd=5.52u as=1.3p ps=5.52u w=5u l=1u
X411 xl0.xpre.fa vref xl0.xpre.tp xl0.xpre.tp pfet_03v3 ad=1.248p pd=5.32u as=1.248p ps=5.32u w=4.8u l=0.4u
X412 VSS vbn xl1.xhyst.ts VSS nfet_03v3 ad=0.65p pd=3.02u as=0.65p ps=3.02u w=2.5u l=1u
X413 xl2.xout.i2 VSS VSS VSS nfet_03v3 ad=0.78p pd=3.52u as=1.32p ps=6.88u w=3u l=0.28u
X414 RX2_O VSS VSS VSS nfet_03v3 ad=1.04p pd=4.52u as=1.76p ps=8.88u w=4u l=0.28u
X415 vbp vbn VSS VSS nfet_03v3 ad=0.65p pd=3.02u as=0.65p ps=3.02u w=2.5u l=1u
X416 xl2.xpre.tp vbp VDD VDD pfet_03v3 ad=1.3p pd=5.52u as=1.3p ps=5.52u w=5u l=1u
X417 xl1.xpre.tp xl1.gp xl1.xpre.fa xl1.xpre.tp pfet_03v3 ad=1.248p pd=5.32u as=1.248p ps=5.32u w=4.8u l=0.4u
X418 xl2.xpre.tp xl2.gp xl2.xpre.fa xl2.xpre.tp pfet_03v3 ad=1.248p pd=5.32u as=1.248p ps=5.32u w=4.8u l=0.4u
X419 VDD xl0.xout.i2 RX0_O VDD pfet_03v3 ad=1.3p pd=5.52u as=1.3p ps=5.52u w=5u l=0.28u
X420 VDD VDD VDD VDD pfet_03v3 ad=0.52p pd=2.52u as=0 ps=0 w=2u l=0.5u
X421 VSS VSS xl0.xpre.fa VSS nfet_03v3 ad=1.9888p pd=9.92u as=1.1752p ps=5.04u w=4.52u l=0.5u
X422 VSS vbn xl1.xpre.fa VSS nfet_03v3 ad=0.65p pd=3.02u as=0.65p ps=3.02u w=2.5u l=1u
X423 VSS VSS VSS VSS nfet_03v3 ad=0.78p pd=3.52u as=0 ps=0 w=3u l=0.28u
X424 xbias.rdt_m2 xbias.rdt_m1 VSS ppolyf_u_1k r_width=2u r_length=21.01u
X425 xl0.xpre.tp vref xl0.xpre.fb xl0.xpre.tp pfet_03v3 ad=1.248p pd=5.32u as=1.248p ps=5.32u w=4.8u l=0.4u
X426 xl2.xpre.fa vb2 xl2.oa VSS nfet_03v3 ad=1.1752p pd=5.04u as=1.1752p ps=5.04u w=4.52u l=0.5u
X427 xl0.xpre.fa xl0.gp xl0.xpre.tp xl0.xpre.tp pfet_03v3 ad=1.248p pd=5.32u as=1.248p ps=5.32u w=4.8u l=0.4u
X428 xl0.oa vb2 xl0.xpre.fa VSS nfet_03v3 ad=1.1752p pd=5.04u as=1.1752p ps=5.04u w=4.52u l=0.5u
X429 VSS vbn xl2.xpre.fb VSS nfet_03v3 ad=0.65p pd=3.02u as=0.65p ps=3.02u w=2.5u l=1u
X430 VSS VSS xl1.xpre.tn VSS nfet_03v3 ad=1.1p pd=5.88u as=0.65p ps=3.02u w=2.5u l=1u
X431 VDD xl2.rla_m1 VSS ppolyf_u_1k r_width=2u r_length=9.11u
X432 VDD vbp xl1.xpre.tp VDD pfet_03v3 ad=1.3p pd=5.52u as=1.3p ps=5.52u w=5u l=1u
X433 xl2.xpre.tp vref xl2.xpre.fa xl2.xpre.tp pfet_03v3 ad=1.248p pd=5.32u as=1.248p ps=5.32u w=4.8u l=0.4u
X434 VSS vbn xl0.xpre.fa VSS nfet_03v3 ad=0.65p pd=3.02u as=0.65p ps=3.02u w=2.5u l=1u
X435 VDD xl2.xout.i2 RX2_O VDD pfet_03v3 ad=1.3p pd=5.52u as=1.3p ps=5.52u w=5u l=0.28u
X436 xl1.xpre.tp xl1.gn xl1.xpre.fb xl1.xpre.tp pfet_03v3 ad=1.248p pd=5.32u as=1.248p ps=5.32u w=4.8u l=0.4u
X437 xl2.xpre.fa vb2 xl2.oa VSS nfet_03v3 ad=1.1752p pd=5.04u as=1.1752p ps=5.04u w=4.52u l=0.5u
X438 VDD xl2.rlb_m1 VSS ppolyf_u_1k r_width=2u r_length=9.11u
X439 xl0.xpre.tp xl0.gp xl0.xpre.fa xl0.xpre.tp pfet_03v3 ad=1.248p pd=5.32u as=1.248p ps=5.32u w=4.8u l=0.4u
X440 xl2.xpre.fa xl2.gp xl2.xpre.tp xl2.xpre.tp pfet_03v3 ad=1.248p pd=5.32u as=1.248p ps=5.32u w=4.8u l=0.4u
X441 xl2.xpre.fa VSS VSS VSS nfet_03v3 ad=0.65p pd=3.02u as=1.1p ps=5.88u w=2.5u l=1u
X442 xbias.rb_m3 xbias.rb_m2 VSS ppolyf_u_1k r_width=2u r_length=22.27u
X443 VDD EN xl2.d2b VDD pfet_03v3 ad=0.52p pd=2.52u as=0.52p ps=2.52u w=2u l=0.5u
X444 VDD xl0.d2b xl0.xout.d3 VDD pfet_03v3 ad=0.52p pd=2.52u as=0.52p ps=2.52u w=2u l=0.28u
X445 xl2.xpre.fb vbn VSS VSS nfet_03v3 ad=0.65p pd=3.02u as=0.65p ps=3.02u w=2.5u l=1u
X446 xl1.xpre.tn vref xl1.ob VSS nfet_03v3 ad=1.235p pd=5.27u as=2.09p ps=10.38u w=4.75u l=0.5u
X447 xl1.xpre.tn vref xl1.oa VSS nfet_03v3 ad=1.235p pd=5.27u as=1.235p ps=5.27u w=4.75u l=0.5u
X448 xl1.xhyst.ts vbn VSS VSS nfet_03v3 ad=0.65p pd=3.02u as=0.65p ps=3.02u w=2.5u l=1u
X449 VDD xl1.d2a xl1.d2b VDD pfet_03v3 ad=0.52p pd=2.52u as=0.52p ps=2.52u w=2u l=0.28u
X450 VSS VSS VSS ppolyf_u_1k r_width=2u r_length=3.17u
X451 xl2.xpre.tp vbp VDD VDD pfet_03v3 ad=1.3p pd=5.52u as=1.3p ps=5.52u w=5u l=1u
X452 xl1.xpre.fb xl1.gn xl1.xpre.tp xl1.xpre.tp pfet_03v3 ad=1.248p pd=5.32u as=1.248p ps=5.32u w=4.8u l=0.4u
X453 xl0.oa xl0.gp xl0.xpre.tn VSS nfet_03v3 ad=1.235p pd=5.27u as=1.235p ps=5.27u w=4.75u l=0.5u
X454 xl1.xout.i2 xl1.xout.i1 VDD VDD pfet_03v3 ad=0.975p pd=4.27u as=0.975p ps=4.27u w=3.75u l=0.28u
X455 VDD VDD xl0.xpre.tp VDD pfet_03v3 ad=2.2p pd=10.88u as=1.3p ps=5.52u w=5u l=1u
X456 xl1.xpre.tp vref xl1.xpre.fb xl1.xpre.tp pfet_03v3 ad=1.248p pd=5.32u as=1.248p ps=5.32u w=4.8u l=0.4u
D5 xl2.gp VDD diode_pd2nw_03v3 pj=26u area=40p
X457 xl2.xpre.tp vref xl2.xpre.fb xl2.xpre.tp pfet_03v3 ad=1.248p pd=5.32u as=1.248p ps=5.32u w=4.8u l=0.4u
X458 VDD xl0.xout.d3 xl0.xout.nd VDD pfet_03v3 ad=0.78p pd=3.52u as=0.78p ps=3.52u w=3u l=0.28u
X459 xl2.xpre.tn xl2.gn xl2.ob VSS nfet_03v3 ad=1.235p pd=5.27u as=1.235p ps=5.27u w=4.75u l=0.5u
X460 VDD xl2.d2a xl2.xout.n3a VDD pfet_03v3 ad=0.52p pd=2.52u as=0.52p ps=2.52u w=2u l=0.28u
X461 xl0.xpre.fb xl0.gn xl0.xpre.tp xl0.xpre.tp pfet_03v3 ad=1.248p pd=5.32u as=1.248p ps=5.32u w=4.8u l=0.4u
X462 xl2.xpre.fa vbn VSS VSS nfet_03v3 ad=0.65p pd=3.02u as=0.65p ps=3.02u w=2.5u l=1u
X463 xl0.ob vref xl0.xpre.tn VSS nfet_03v3 ad=1.235p pd=5.27u as=1.235p ps=5.27u w=4.75u l=0.5u
X464 vbp vbp VDD VDD pfet_03v3 ad=1.3p pd=5.52u as=1.3p ps=5.52u w=5u l=1u
X465 xl0.xpre.fb vbn VSS VSS nfet_03v3 ad=0.65p pd=3.02u as=0.65p ps=3.02u w=2.5u l=1u
X466 VSS vbn xl1.xpre.tn VSS nfet_03v3 ad=0.65p pd=3.02u as=0.65p ps=3.02u w=2.5u l=1u
X467 VDD VDD VDD VDD pfet_03v3 ad=0.52p pd=2.52u as=0 ps=0 w=2u l=0.5u
X468 xl0.d2b xl0.d2b VDD VDD pfet_03v3 ad=0.52p pd=2.52u as=0.52p ps=2.52u w=2u l=0.28u
X469 xl2.oa xl2.gp xl2.xpre.tn VSS nfet_03v3 ad=1.235p pd=5.27u as=1.235p ps=5.27u w=4.75u l=0.5u
X470 xl2.xpre.tp vbp VDD VDD pfet_03v3 ad=1.3p pd=5.52u as=1.3p ps=5.52u w=5u l=1u
X471 xl0.xpre.tp xl0.gp xl0.xpre.fa xl0.xpre.tp pfet_03v3 ad=1.248p pd=5.32u as=1.248p ps=5.32u w=4.8u l=0.4u
X472 xl0.xpre.tp xl0.gp xl0.xpre.fa xl0.xpre.tp pfet_03v3 ad=1.248p pd=5.32u as=1.248p ps=5.32u w=4.8u l=0.4u
X473 xl1.xpre.tp vref xl1.xpre.fa xl1.xpre.tp pfet_03v3 ad=1.248p pd=5.32u as=1.248p ps=5.32u w=4.8u l=0.4u
X474 xl2.xpre.tn vref xl2.oa VSS nfet_03v3 ad=1.235p pd=5.27u as=1.235p ps=5.27u w=4.75u l=0.5u
X475 VSS xl0.xout.n3a xl0.xout.d3 VSS nfet_03v3 ad=0.6734p pd=3.11u as=0.6734p ps=3.11u w=2.59u l=0.28u
X476 VSS xl1.xout.n3a xl1.xout.n3a VSS nfet_03v3 ad=0.6734p pd=3.11u as=0.6734p ps=3.11u w=2.59u l=0.28u
X477 xl0.xpre.fa xl0.gp xl0.xpre.tp xl0.xpre.tp pfet_03v3 ad=1.248p pd=5.32u as=1.248p ps=5.32u w=4.8u l=0.4u
X478 xl1.xpre.tp vref xl1.xpre.fa xl1.xpre.tp pfet_03v3 ad=1.248p pd=5.32u as=1.248p ps=5.32u w=4.8u l=0.4u
X479 VSS VSS xl0.xhyst.ts VSS nfet_03v3 ad=1.1p pd=5.88u as=0.65p ps=3.02u w=2.5u l=1u
X480 VSS vbn xl2.xpre.fa VSS nfet_03v3 ad=0.65p pd=3.02u as=0.65p ps=3.02u w=2.5u l=1u
X481 VSS vbn vbn VSS nfet_03v3 ad=0.65p pd=3.02u as=0.65p ps=3.02u w=2.5u l=1u
X482 VSS vbn xl2.xpre.fb VSS nfet_03v3 ad=0.65p pd=3.02u as=0.65p ps=3.02u w=2.5u l=1u
X483 VSS vbn xl2.xpre.tn VSS nfet_03v3 ad=0.65p pd=3.02u as=0.65p ps=3.02u w=2.5u l=1u
X484 xl1.xout.nd VDD VDD VDD pfet_03v3 ad=0.78p pd=3.52u as=1.32p ps=6.88u w=3u l=0.28u
X485 VDD VDD xl0.d2b VDD pfet_03v3 ad=0.88p pd=4.88u as=0.52p ps=2.52u w=2u l=0.28u
X486 xl0.xpre.tn xl0.gn xl0.ob VSS nfet_03v3 ad=1.235p pd=5.27u as=1.235p ps=5.27u w=4.75u l=0.5u
X487 xl1.xhyst.ts vbn VSS VSS nfet_03v3 ad=0.65p pd=3.02u as=0.65p ps=3.02u w=2.5u l=1u
X488 VSS VSS VSS VSS nfet_03v3 ad=0.39p pd=2.02u as=0 ps=0 w=1.5u l=0.28u
X489 xl1.xout.n3a xl1.d2a VDD VDD pfet_03v3 ad=0.52p pd=2.52u as=0.52p ps=2.52u w=2u l=0.28u
X490 VDD vbp xl2.xpre.tp VDD pfet_03v3 ad=1.3p pd=5.52u as=1.3p ps=5.52u w=5u l=1u
X491 xl0.xpre.tp vref xl0.xpre.fb xl0.xpre.tp pfet_03v3 ad=1.248p pd=5.32u as=1.248p ps=5.32u w=4.8u l=0.4u
X492 xl1.xpre.fa xl1.gp xl1.xpre.tp xl1.xpre.tp pfet_03v3 ad=1.248p pd=5.32u as=1.248p ps=5.32u w=4.8u l=0.4u
X493 xl1.d2b xl1.ob xl1.xhyst.sb VSS nfet_03v3 ad=1.1362p pd=4.89u as=1.1362p ps=4.89u w=4.37u l=0.5u
X494 xl1.xpre.tp vref xl1.xpre.fa xl1.xpre.tp pfet_03v3 ad=1.248p pd=5.32u as=1.248p ps=5.32u w=4.8u l=0.4u
X495 xl1.xpre.tn vref xl1.oa VSS nfet_03v3 ad=1.235p pd=5.27u as=1.235p ps=5.27u w=4.75u l=0.5u
X496 VDD vbp xl0.xpre.tp VDD pfet_03v3 ad=1.3p pd=5.52u as=1.3p ps=5.52u w=5u l=1u
X497 xl1.oa xl1.rla_m1 VSS ppolyf_u_1k r_width=2u r_length=9.11u
X498 xl2.xpre.tp xl2.gp xl2.xpre.fa xl2.xpre.tp pfet_03v3 ad=1.248p pd=5.32u as=1.248p ps=5.32u w=4.8u l=0.4u
X499 xbias.nrb xbias.enb VDD VDD pfet_03v3 ad=1.3p pd=5.52u as=1.3p ps=5.52u w=5u l=0.5u
X500 VDD xl0.d2b xl0.d2a VDD pfet_03v3 ad=0.52p pd=2.52u as=0.52p ps=2.52u w=2u l=0.28u
X501 xl1.xpre.fa vref xl1.xpre.tp xl1.xpre.tp pfet_03v3 ad=1.248p pd=5.32u as=1.248p ps=5.32u w=4.8u l=0.4u
X502 VDD VDD xl1.xout.n3a VDD pfet_03v3 ad=0.88p pd=4.88u as=0.52p ps=2.52u w=2u l=0.28u
X503 xl1.xpre.fb vb2 xl1.ob VSS nfet_03v3 ad=1.1752p pd=5.04u as=1.1752p ps=5.04u w=4.52u l=0.5u
X504 xl2.xpre.fb vbn VSS VSS nfet_03v3 ad=0.65p pd=3.02u as=0.65p ps=3.02u w=2.5u l=1u
X505 xl1.xpre.tn vref xl1.ob VSS nfet_03v3 ad=1.235p pd=5.27u as=1.235p ps=5.27u w=4.75u l=0.5u
X506 VSS VSS VSS VSS nfet_03v3 ad=0.6734p pd=3.11u as=0 ps=0 w=2.59u l=0.28u
X507 xl1.xpre.fa vref xl1.xpre.tp xl1.xpre.tp pfet_03v3 ad=1.248p pd=5.32u as=1.248p ps=5.32u w=4.8u l=0.4u
X508 VSS vbn xl1.xpre.fa VSS nfet_03v3 ad=0.65p pd=3.02u as=0.65p ps=3.02u w=2.5u l=1u
X509 xl2.xpre.tn vbn VSS VSS nfet_03v3 ad=0.65p pd=3.02u as=0.65p ps=3.02u w=2.5u l=1u
X510 xl2.xpre.tp VDD VDD VDD pfet_03v3 ad=1.3p pd=5.52u as=2.2p ps=10.88u w=5u l=1u
X511 xl1.xpre.fb vb2 xl1.ob VSS nfet_03v3 ad=1.1752p pd=5.04u as=1.1752p ps=5.04u w=4.52u l=0.5u
X512 VDD vbp vbp VDD pfet_03v3 ad=1.3p pd=5.52u as=1.3p ps=5.52u w=5u l=1u
X513 xl0.xpre.tn vref xl0.oa VSS nfet_03v3 ad=1.235p pd=5.27u as=1.235p ps=5.27u w=4.75u l=0.5u
X514 VDD xl2.d2b xl2.xout.d3 VDD pfet_03v3 ad=0.52p pd=2.52u as=0.52p ps=2.52u w=2u l=0.28u
X515 VDD vbp xl1.xpre.tp VDD pfet_03v3 ad=1.3p pd=5.52u as=1.3p ps=5.52u w=5u l=1u
X516 xl0.xpre.fb vref xl0.xpre.tp xl0.xpre.tp pfet_03v3 ad=1.248p pd=5.32u as=1.248p ps=5.32u w=4.8u l=0.4u
X517 xl0.xpre.tp vref xl0.xpre.fb xl0.xpre.tp pfet_03v3 ad=1.248p pd=5.32u as=1.248p ps=5.32u w=4.8u l=0.4u
X518 xl1.xpre.tp vref xl1.xpre.fb xl1.xpre.tp pfet_03v3 ad=1.248p pd=5.32u as=1.248p ps=5.32u w=4.8u l=0.4u
X519 VDD xl2.d2b xl2.d2a VDD pfet_03v3 ad=0.52p pd=2.52u as=0.52p ps=2.52u w=2u l=0.28u
X520 xl1.ob xl1.rlb_m1 VSS ppolyf_u_1k r_width=2u r_length=9.11u
X521 xl2.xpre.tp xl2.gn xl2.xpre.fb xl2.xpre.tp pfet_03v3 ad=1.248p pd=5.32u as=1.248p ps=5.32u w=4.8u l=0.4u
X522 VDD VDD xl1.xout.nd VDD pfet_03v3 ad=1.32p pd=6.88u as=0.78p ps=3.52u w=3u l=0.28u
X523 xl1.gn RX1_N VDD ppolyf_u r_width=5u r_length=1.8u
X524 xl2.xpre.tp vref xl2.xpre.fb xl2.xpre.tp pfet_03v3 ad=1.248p pd=5.32u as=1.248p ps=5.32u w=4.8u l=0.4u
X525 xl2.d2b xl2.d2a VDD VDD pfet_03v3 ad=0.52p pd=2.52u as=0.52p ps=2.52u w=2u l=0.28u
X526 xl0.xout.n3a xl0.d2a VDD VDD pfet_03v3 ad=0.52p pd=2.52u as=0.52p ps=2.52u w=2u l=0.28u
X527 xl0.xpre.tp vbp VDD VDD pfet_03v3 ad=1.3p pd=5.52u as=1.3p ps=5.52u w=5u l=1u
X528 xl0.xpre.fa vref xl0.xpre.tp xl0.xpre.tp pfet_03v3 ad=1.248p pd=5.32u as=1.248p ps=5.32u w=4.8u l=0.4u
X529 VSS VSS xbias.nmid VSS nfet_03v3 ad=2.2p pd=10.88u as=1.3p ps=5.52u w=5u l=0.5u
X530 xl0.xpre.tp xl0.gp xl0.xpre.fa xl0.xpre.tp pfet_03v3 ad=1.248p pd=5.32u as=1.248p ps=5.32u w=4.8u l=0.4u
X531 xl1.xpre.fb vref xl1.xpre.tp xl1.xpre.tp pfet_03v3 ad=1.248p pd=5.32u as=1.248p ps=5.32u w=4.8u l=0.4u
X532 xl2.xpre.fb vref xl2.xpre.tp xl2.xpre.tp pfet_03v3 ad=1.248p pd=5.32u as=1.248p ps=5.32u w=4.8u l=0.4u
X533 xl0.d2a VDD VDD VDD pfet_03v3 ad=0.52p pd=2.52u as=0.88p ps=4.88u w=2u l=0.5u
X534 xl1.xpre.tp vbp VDD VDD pfet_03v3 ad=1.3p pd=5.52u as=1.3p ps=5.52u w=5u l=1u
X535 VSS VSS xl0.xpre.fa VSS nfet_03v3 ad=1.1p pd=5.88u as=0.65p ps=3.02u w=2.5u l=1u
X536 xl2.d2a xl2.oa xl2.xhyst.sa VSS nfet_03v3 ad=1.1362p pd=4.89u as=1.1362p ps=4.89u w=4.37u l=0.5u
X537 xl2.xout.nd EN VDD VDD pfet_03v3 ad=0.78p pd=3.52u as=0.78p ps=3.52u w=3u l=0.28u
X538 VSS EN xbias.nmid VSS nfet_03v3 ad=1.3p pd=5.52u as=1.3p ps=5.52u w=5u l=0.5u
X539 VDD vbp vbp VDD pfet_03v3 ad=1.3p pd=5.52u as=1.3p ps=5.52u w=5u l=1u
X540 xl2.xpre.tp xl2.gp xl2.xpre.fa xl2.xpre.tp pfet_03v3 ad=1.248p pd=5.32u as=1.248p ps=5.32u w=4.8u l=0.4u
X541 xl2.xout.d3 xl2.d2b VDD VDD pfet_03v3 ad=0.52p pd=2.52u as=0.52p ps=2.52u w=2u l=0.28u
X542 VSS vbn xl2.xpre.tn VSS nfet_03v3 ad=0.65p pd=3.02u as=0.65p ps=3.02u w=2.5u l=1u
X543 xl2.oa vref xl2.xpre.tn VSS nfet_03v3 ad=1.235p pd=5.27u as=1.235p ps=5.27u w=4.75u l=0.5u
X544 VDD vbp xl2.xpre.tp VDD pfet_03v3 ad=1.3p pd=5.52u as=1.3p ps=5.52u w=5u l=1u
X545 xl0.xpre.fa vref xl0.xpre.tp xl0.xpre.tp pfet_03v3 ad=1.248p pd=5.32u as=1.248p ps=5.32u w=4.8u l=0.4u
X546 xl0.oa vb2 xl0.xpre.fa VSS nfet_03v3 ad=1.1752p pd=5.04u as=1.1752p ps=5.04u w=4.52u l=0.5u
X547 xl2.xout.i1 VSS VSS VSS nfet_03v3 ad=0.39p pd=2.02u as=0.66p ps=3.88u w=1.5u l=0.28u
X548 xl1.ob xl1.gn xl1.xpre.tn VSS nfet_03v3 ad=1.235p pd=5.27u as=1.235p ps=5.27u w=4.75u l=0.5u
X549 xl1.xpre.fb xl1.gn xl1.xpre.tp xl1.xpre.tp pfet_03v3 ad=1.248p pd=5.32u as=1.248p ps=5.32u w=4.8u l=0.4u
X550 xl2.ob vb2 xl2.xpre.fb VSS nfet_03v3 ad=1.1752p pd=5.04u as=1.1752p ps=5.04u w=4.52u l=0.5u
X551 VDD xl1.d2a xl1.d2b VDD pfet_03v3 ad=0.52p pd=2.52u as=0.52p ps=2.52u w=2u l=0.28u
X552 xl0.xout.n3a xl0.xout.n3a VSS VSS nfet_03v3 ad=0.6734p pd=3.11u as=0.6734p ps=3.11u w=2.59u l=0.28u
X553 xl2.ob vref xl2.xpre.tn VSS nfet_03v3 ad=1.235p pd=5.27u as=1.235p ps=5.27u w=4.75u l=0.5u
X554 xl0.xpre.fa vref xl0.xpre.tp xl0.xpre.tp pfet_03v3 ad=1.248p pd=5.32u as=1.248p ps=5.32u w=4.8u l=0.4u
X555 xl1.xpre.fa xl1.gp xl1.xpre.tp xl1.xpre.tp pfet_03v3 ad=1.248p pd=5.32u as=1.248p ps=5.32u w=4.8u l=0.4u
X556 xl2.xpre.fa vb2 xl2.oa VSS nfet_03v3 ad=1.1752p pd=5.04u as=1.1752p ps=5.04u w=4.52u l=0.5u
X557 xl2.xpre.tp vref xl2.xpre.fa xl2.xpre.tp pfet_03v3 ad=1.248p pd=5.32u as=1.248p ps=5.32u w=4.8u l=0.4u
D6 VSS xl2.gp diode_nd2ps_03v3 pj=26u area=40p
X558 xl1.oa xl1.gp xl1.xpre.tn VSS nfet_03v3 ad=1.235p pd=5.27u as=1.235p ps=5.27u w=4.75u l=0.5u
X559 xl2.xpre.tn vbn VSS VSS nfet_03v3 ad=0.65p pd=3.02u as=0.65p ps=3.02u w=2.5u l=1u
X560 VSS VSS VSS VSS nfet_03v3 ad=0.52p pd=2.52u as=0 ps=0 w=2u l=0.28u
X561 xl1.xpre.tp xl1.gn xl1.xpre.fb xl1.xpre.tp pfet_03v3 ad=1.248p pd=5.32u as=1.248p ps=5.32u w=4.8u l=0.4u
X562 xl2.xpre.fa vb2 xl2.oa VSS nfet_03v3 ad=1.1752p pd=5.04u as=1.1752p ps=5.04u w=4.52u l=0.5u
X563 xl2.xpre.fa vref xl2.xpre.tp xl2.xpre.tp pfet_03v3 ad=1.248p pd=5.32u as=1.248p ps=5.32u w=4.8u l=0.4u
X564 xl0.ob xl0.gn xl0.xpre.tn VSS nfet_03v3 ad=1.235p pd=5.27u as=1.235p ps=5.27u w=4.75u l=0.5u
X565 xl0.xpre.tn vref xl0.ob VSS nfet_03v3 ad=1.235p pd=5.27u as=1.235p ps=5.27u w=4.75u l=0.5u
X566 xl1.xpre.tn vref xl1.ob VSS nfet_03v3 ad=1.235p pd=5.27u as=1.235p ps=5.27u w=4.75u l=0.5u
X567 VDD xl1.d2a xl1.xout.n3a VDD pfet_03v3 ad=0.52p pd=2.52u as=0.52p ps=2.52u w=2u l=0.28u
X568 xl0.xpre.fa vbn VSS VSS nfet_03v3 ad=0.65p pd=3.02u as=0.65p ps=3.02u w=2.5u l=1u
X569 VDD xl0.xout.nd xl0.xout.i1 VDD pfet_03v3 ad=0.962p pd=4.22u as=0.962p ps=4.22u w=3.7u l=0.28u
X570 xl2.d2a xl2.d2b VDD VDD pfet_03v3 ad=0.52p pd=2.52u as=0.52p ps=2.52u w=2u l=0.28u
X571 VDD vbp xl1.xpre.tp VDD pfet_03v3 ad=1.3p pd=5.52u as=1.3p ps=5.52u w=5u l=1u
X572 xl0.xpre.fb vb2 xl0.ob VSS nfet_03v3 ad=1.1752p pd=5.04u as=1.1752p ps=5.04u w=4.52u l=0.5u
X573 xl0.xpre.tn vbn VSS VSS nfet_03v3 ad=0.65p pd=3.02u as=0.65p ps=3.02u w=2.5u l=1u
X574 xl2.xpre.tn xl2.gp xl2.oa VSS nfet_03v3 ad=1.235p pd=5.27u as=1.235p ps=5.27u w=4.75u l=0.5u
X575 xl0.xpre.tp vbp VDD VDD pfet_03v3 ad=1.3p pd=5.52u as=1.3p ps=5.52u w=5u l=1u
X576 VDD VDD xl2.xout.i2 VDD pfet_03v3 ad=1.65p pd=8.38u as=0.975p ps=4.27u w=3.75u l=0.28u
X577 VSS vbn xl2.xhyst.ts VSS nfet_03v3 ad=0.65p pd=3.02u as=0.65p ps=3.02u w=2.5u l=1u
X578 xl2.xpre.tp vref xl2.xpre.fb xl2.xpre.tp pfet_03v3 ad=1.248p pd=5.32u as=2.112p ps=10.48u w=4.8u l=0.4u
X579 xl0.d2a VSS VSS VSS nfet_03v3 ad=1.1362p pd=4.89u as=1.9228p ps=9.62u w=4.37u l=0.5u
X580 xl2.xpre.fa vref xl2.xpre.tp xl2.xpre.tp pfet_03v3 ad=1.248p pd=5.32u as=1.248p ps=5.32u w=4.8u l=0.4u
X581 xl1.xpre.fa vbn VSS VSS nfet_03v3 ad=0.65p pd=3.02u as=0.65p ps=3.02u w=2.5u l=1u
X582 xl2.xpre.tn xl2.gn xl2.ob VSS nfet_03v3 ad=1.235p pd=5.27u as=1.235p ps=5.27u w=4.75u l=0.5u
X583 xl0.oa vref xl0.xpre.tn VSS nfet_03v3 ad=1.235p pd=5.27u as=1.235p ps=5.27u w=4.75u l=0.5u
X584 xl2.xout.nd VSS VSS VSS nfet_03v3 ad=0.52p pd=2.52u as=0.88p ps=4.88u w=2u l=0.28u
X585 xl0.d2b VDD VDD VDD pfet_03v3 ad=0.52p pd=2.52u as=0.88p ps=4.88u w=2u l=0.5u
X586 VSS VSS VSS ppolyf_u_1k r_width=2u r_length=21.01u
X587 xl2.xhyst.ts xl2.xhyst.sa VSS ppolyf_u_1k r_width=2u r_length=3.17u
X588 xl1.xpre.tp vbp VDD VDD pfet_03v3 ad=1.3p pd=5.52u as=1.3p ps=5.52u w=5u l=1u
X589 xl2.xpre.tp vref xl2.xpre.fb xl2.xpre.tp pfet_03v3 ad=1.248p pd=5.32u as=1.248p ps=5.32u w=4.8u l=0.4u
X590 xl1.xpre.fb vbn VSS VSS nfet_03v3 ad=0.65p pd=3.02u as=0.65p ps=3.02u w=2.5u l=1u
X591 xl2.xpre.tn vref xl2.ob VSS nfet_03v3 ad=1.235p pd=5.27u as=1.235p ps=5.27u w=4.75u l=0.5u
X592 xl0.xpre.fb vref xl0.xpre.tp xl0.xpre.tp pfet_03v3 ad=1.248p pd=5.32u as=1.248p ps=5.32u w=4.8u l=0.4u
X593 xl2.xout.n3a VDD VDD VDD pfet_03v3 ad=0.52p pd=2.52u as=0.88p ps=4.88u w=2u l=0.28u
X594 vref xbias.rdb_m1 VSS ppolyf_u_1k r_width=2u r_length=19.26u
X595 xl2.xpre.tp vref xl2.xpre.fb xl2.xpre.tp pfet_03v3 ad=1.248p pd=5.32u as=1.248p ps=5.32u w=4.8u l=0.4u
X596 xl1.xout.i1 VDD VDD VDD pfet_03v3 ad=0.962p pd=4.22u as=1.628p ps=8.28u w=3.7u l=0.28u
X597 VSS vbn xl0.xhyst.ts VSS nfet_03v3 ad=0.65p pd=3.02u as=0.65p ps=3.02u w=2.5u l=1u
X598 VSS EN xl2.xout.nm VSS nfet_03v3 ad=0.52p pd=2.52u as=0.52p ps=2.52u w=2u l=0.28u
X599 VSS xl2.xout.nd xl2.xout.i1 VSS nfet_03v3 ad=0.39p pd=2.02u as=0.39p ps=2.02u w=1.5u l=0.28u
X600 xl0.xpre.tp xl0.gp xl0.xpre.fa xl0.xpre.tp pfet_03v3 ad=1.248p pd=5.32u as=1.248p ps=5.32u w=4.8u l=0.4u
X601 xl1.xpre.tp xl1.gp xl1.xpre.fa xl1.xpre.tp pfet_03v3 ad=1.248p pd=5.32u as=1.248p ps=5.32u w=4.8u l=0.4u
X602 xl1.xpre.fb vref xl1.xpre.tp xl1.xpre.tp pfet_03v3 ad=1.248p pd=5.32u as=1.248p ps=5.32u w=4.8u l=0.4u
X603 xl2.xpre.fb vref xl2.xpre.tp xl2.xpre.tp pfet_03v3 ad=1.248p pd=5.32u as=1.248p ps=5.32u w=4.8u l=0.4u
X604 VDD xl2.d2b xl2.d2b VDD pfet_03v3 ad=0.52p pd=2.52u as=0.52p ps=2.52u w=2u l=0.28u
X605 xl2.xpre.fb xl2.gn xl2.xpre.tp xl2.xpre.tp pfet_03v3 ad=1.248p pd=5.32u as=1.248p ps=5.32u w=4.8u l=0.4u
X606 xl1.d2a xl1.d2a VDD VDD pfet_03v3 ad=0.52p pd=2.52u as=0.52p ps=2.52u w=2u l=0.28u
X607 VSS vbn xl0.xpre.fa VSS nfet_03v3 ad=0.65p pd=3.02u as=0.65p ps=3.02u w=2.5u l=1u
X608 xl1.xpre.fa vb2 xl1.oa VSS nfet_03v3 ad=1.1752p pd=5.04u as=1.1752p ps=5.04u w=4.52u l=0.5u
X609 VSS vbn xl1.xpre.fb VSS nfet_03v3 ad=0.65p pd=3.02u as=0.65p ps=3.02u w=2.5u l=1u
X610 VSS VSS xl0.xpre.tn VSS nfet_03v3 ad=1.1p pd=5.88u as=0.65p ps=3.02u w=2.5u l=1u
X611 RX1_O VDD VDD VDD pfet_03v3 ad=1.3p pd=5.52u as=2.2p ps=10.88u w=5u l=0.28u
X612 xl1.d2b VSS VSS VSS nfet_03v3 ad=1.1362p pd=4.89u as=1.9228p ps=9.62u w=4.37u l=0.5u
X613 xl2.xhyst.ts vbn VSS VSS nfet_03v3 ad=0.65p pd=3.02u as=0.65p ps=3.02u w=2.5u l=1u
X614 VDD vbp xl0.xpre.tp VDD pfet_03v3 ad=1.3p pd=5.52u as=1.3p ps=5.52u w=5u l=1u
X615 xl1.xpre.tp vref xl1.xpre.fa xl1.xpre.tp pfet_03v3 ad=1.248p pd=5.32u as=1.248p ps=5.32u w=4.8u l=0.4u
X616 VSS VSS VSS ppolyf_u_1k r_width=2u r_length=3.17u
X617 xl0.xpre.tp xl0.gn xl0.xpre.fb xl0.xpre.tp pfet_03v3 ad=1.248p pd=5.32u as=1.248p ps=5.32u w=4.8u l=0.4u
X618 xl1.xpre.fa vb2 xl1.oa VSS nfet_03v3 ad=1.1752p pd=5.04u as=1.1752p ps=5.04u w=4.52u l=0.5u
X619 xl2.xout.d3 xl2.d2b VDD VDD pfet_03v3 ad=0.52p pd=2.52u as=0.52p ps=2.52u w=2u l=0.28u
X620 VDD xl1.rlb_m1 VSS ppolyf_u_1k r_width=2u r_length=9.11u
X621 xl1.xpre.tn vref xl1.oa VSS nfet_03v3 ad=1.235p pd=5.27u as=1.235p ps=5.27u w=4.75u l=0.5u
X622 xbias.rf_m1 xbias.vf VSS ppolyf_u_1k r_width=2u r_length=23.07u
X623 xl2.xpre.tp vref xl2.xpre.fa xl2.xpre.tp pfet_03v3 ad=1.248p pd=5.32u as=1.248p ps=5.32u w=4.8u l=0.4u
X624 xl1.xpre.fa VSS VSS VSS nfet_03v3 ad=0.65p pd=3.02u as=1.1p ps=5.88u w=2.5u l=1u
X625 xl1.xpre.fb vb2 xl1.ob VSS nfet_03v3 ad=1.1752p pd=5.04u as=1.1752p ps=5.04u w=4.52u l=0.5u
X626 xl0.xpre.tn vref xl0.ob VSS nfet_03v3 ad=1.235p pd=5.27u as=2.09p ps=10.38u w=4.75u l=0.5u
X627 xl0.xpre.tn vref xl0.oa VSS nfet_03v3 ad=1.235p pd=5.27u as=1.235p ps=5.27u w=4.75u l=0.5u
X628 xl0.xhyst.ts vbn VSS VSS nfet_03v3 ad=0.65p pd=3.02u as=0.65p ps=3.02u w=2.5u l=1u
X629 VDD xl0.d2a xl0.d2b VDD pfet_03v3 ad=0.52p pd=2.52u as=0.52p ps=2.52u w=2u l=0.28u
X630 VSS VSS VSS ppolyf_u_1k r_width=2u r_length=3.17u
X631 xl1.xpre.tp vref xl1.xpre.fa xl1.xpre.tp pfet_03v3 ad=1.248p pd=5.32u as=1.248p ps=5.32u w=4.8u l=0.4u
X632 xl1.xhyst.ts vbn VSS VSS nfet_03v3 ad=0.65p pd=3.02u as=0.65p ps=3.02u w=2.5u l=1u
X633 xl1.xout.i1 VSS VSS VSS nfet_03v3 ad=0.39p pd=2.02u as=0.66p ps=3.88u w=1.5u l=0.28u
X634 xl0.xout.i2 xl0.xout.i1 VDD VDD pfet_03v3 ad=0.975p pd=4.27u as=0.975p ps=4.27u w=3.75u l=0.28u
X635 xl0.xpre.fb xl0.gn xl0.xpre.tp xl0.xpre.tp pfet_03v3 ad=1.248p pd=5.32u as=1.248p ps=5.32u w=4.8u l=0.4u
X636 xl1.xpre.tp vref xl1.xpre.fb xl1.xpre.tp pfet_03v3 ad=1.248p pd=5.32u as=1.248p ps=5.32u w=4.8u l=0.4u
X637 xl2.xpre.tp xl2.gp xl2.xpre.fa xl2.xpre.tp pfet_03v3 ad=1.248p pd=5.32u as=1.248p ps=5.32u w=4.8u l=0.4u
X638 xl0.xpre.tp vref xl0.xpre.fb xl0.xpre.tp pfet_03v3 ad=1.248p pd=5.32u as=1.248p ps=5.32u w=4.8u l=0.4u
X639 VSS xbias.enb vbn VSS nfet_03v3 ad=0.52p pd=2.52u as=0.52p ps=2.52u w=2u l=0.5u
X640 xl2.xpre.tp xl2.gn xl2.xpre.fb xl2.xpre.tp pfet_03v3 ad=1.248p pd=5.32u as=1.248p ps=5.32u w=4.8u l=0.4u
D7 xl1.gp VDD diode_pd2nw_03v3 pj=26u area=40p
X641 xl1.xpre.tn xl1.gn xl1.ob VSS nfet_03v3 ad=1.235p pd=5.27u as=1.235p ps=5.27u w=4.75u l=0.5u
X642 VSS VSS VSS VSS nfet_03v3 ad=0.52p pd=2.52u as=0 ps=0 w=2u l=0.28u
X643 VDD xl1.d2a xl1.xout.n3a VDD pfet_03v3 ad=0.52p pd=2.52u as=0.52p ps=2.52u w=2u l=0.28u
X644 xl2.xpre.fb xl2.gn xl2.xpre.tp xl2.xpre.tp pfet_03v3 ad=1.248p pd=5.32u as=1.248p ps=5.32u w=4.8u l=0.4u
X645 xl1.xpre.fa vbn VSS VSS nfet_03v3 ad=0.65p pd=3.02u as=0.65p ps=3.02u w=2.5u l=1u
X646 xl2.xpre.fa vbn VSS VSS nfet_03v3 ad=0.65p pd=3.02u as=0.65p ps=3.02u w=2.5u l=1u
X647 VDD VDD VDD VDD pfet_03v3 ad=0.962p pd=4.22u as=0 ps=0 w=3.7u l=0.28u
X648 VSS vbn xl0.xpre.tn VSS nfet_03v3 ad=0.65p pd=3.02u as=0.65p ps=3.02u w=2.5u l=1u
X649 xl1.xpre.tp vbp VDD VDD pfet_03v3 ad=1.3p pd=5.52u as=1.3p ps=5.52u w=5u l=1u
X650 xl0.xpre.tp vref xl0.xpre.fa xl0.xpre.tp pfet_03v3 ad=1.248p pd=5.32u as=1.248p ps=5.32u w=4.8u l=0.4u
X651 xl1.xpre.tn vref xl1.oa VSS nfet_03v3 ad=1.235p pd=5.27u as=1.235p ps=5.27u w=4.75u l=0.5u
X652 xl2.xhyst.sb xl2.ob xl2.d2b VSS nfet_03v3 ad=1.1362p pd=4.89u as=1.1362p ps=4.89u w=4.37u l=0.5u
X653 xl1.d2b xl1.d2a VDD VDD pfet_03v3 ad=0.52p pd=2.52u as=0.52p ps=2.52u w=2u l=0.28u
X654 xl1.xpre.tp xl1.gn xl1.xpre.fb xl1.xpre.tp pfet_03v3 ad=1.248p pd=5.32u as=1.248p ps=5.32u w=4.8u l=0.4u
X655 xl0.xpre.tp vref xl0.xpre.fa xl0.xpre.tp pfet_03v3 ad=1.248p pd=5.32u as=1.248p ps=5.32u w=4.8u l=0.4u
X656 VDD xl1.xout.i1 xl1.xout.i2 VDD pfet_03v3 ad=0.975p pd=4.27u as=0.975p ps=4.27u w=3.75u l=0.28u
X657 VSS EN xbias.enb VSS nfet_03v3 ad=0.44p pd=2.88u as=0.44p ps=2.88u w=1u l=0.28u
X658 xl2.xpre.fb vref xl2.xpre.tp xl2.xpre.tp pfet_03v3 ad=1.248p pd=5.32u as=1.248p ps=5.32u w=4.8u l=0.4u
X659 VSS vbn xl1.xpre.fa VSS nfet_03v3 ad=0.65p pd=3.02u as=0.65p ps=3.02u w=2.5u l=1u
X660 VSS vbn xl2.xpre.fb VSS nfet_03v3 ad=0.65p pd=3.02u as=0.65p ps=3.02u w=2.5u l=1u
X661 VSS vbn xl1.xpre.tn VSS nfet_03v3 ad=0.65p pd=3.02u as=0.65p ps=3.02u w=2.5u l=1u
X662 VDD VDD RX1_O VDD pfet_03v3 ad=2.2p pd=10.88u as=1.3p ps=5.52u w=5u l=0.28u
X663 xl1.ob xl1.gn xl1.xpre.tn VSS nfet_03v3 ad=1.235p pd=5.27u as=1.235p ps=5.27u w=4.75u l=0.5u
X664 xl0.xout.nd VDD VDD VDD pfet_03v3 ad=0.78p pd=3.52u as=1.32p ps=6.88u w=3u l=0.28u
X665 xl2.xout.n3a xl2.d2a VDD VDD pfet_03v3 ad=0.52p pd=2.52u as=0.52p ps=2.52u w=2u l=0.28u
X666 VSS vbn xl2.xpre.fa VSS nfet_03v3 ad=0.65p pd=3.02u as=0.65p ps=3.02u w=2.5u l=1u
X667 xl2.ob vb2 xl2.xpre.fb VSS nfet_03v3 ad=1.1752p pd=5.04u as=1.1752p ps=5.04u w=4.52u l=0.5u
X668 xl0.xhyst.ts vbn VSS VSS nfet_03v3 ad=0.65p pd=3.02u as=0.65p ps=3.02u w=2.5u l=1u
X669 xl0.xout.n3a xl0.d2a VDD VDD pfet_03v3 ad=0.52p pd=2.52u as=0.52p ps=2.52u w=2u l=0.28u
X670 xl1.xout.nd VSS VSS VSS nfet_03v3 ad=0.52p pd=2.52u as=0.88p ps=4.88u w=2u l=0.28u
X671 xl2.d2a xl2.d2b VDD VDD pfet_03v3 ad=0.52p pd=2.52u as=0.52p ps=2.52u w=2u l=0.28u
X672 xl2.oa vref xl2.xpre.tn VSS nfet_03v3 ad=1.235p pd=5.27u as=1.235p ps=5.27u w=4.75u l=0.5u
X673 xl0.xpre.fa xl0.gp xl0.xpre.tp xl0.xpre.tp pfet_03v3 ad=1.248p pd=5.32u as=1.248p ps=5.32u w=4.8u l=0.4u
X674 xl1.xhyst.ts VSS VSS VSS nfet_03v3 ad=0.65p pd=3.02u as=1.1p ps=5.88u w=2.5u l=1u
X675 xl0.d2b xl0.ob xl0.xhyst.sb VSS nfet_03v3 ad=1.1362p pd=4.89u as=1.1362p ps=4.89u w=4.37u l=0.5u
X676 xl0.xpre.tp vref xl0.xpre.fa xl0.xpre.tp pfet_03v3 ad=1.248p pd=5.32u as=1.248p ps=5.32u w=4.8u l=0.4u
X677 xl2.xpre.tp xl2.gn xl2.xpre.fb xl2.xpre.tp pfet_03v3 ad=1.248p pd=5.32u as=1.248p ps=5.32u w=4.8u l=0.4u
X678 xl2.ob vb2 xl2.xpre.fb VSS nfet_03v3 ad=1.1752p pd=5.04u as=1.1752p ps=5.04u w=4.52u l=0.5u
X679 xl0.xpre.tn vref xl0.oa VSS nfet_03v3 ad=1.235p pd=5.27u as=1.235p ps=5.27u w=4.75u l=0.5u
X680 xl1.ob xl1.gn xl1.xpre.tn VSS nfet_03v3 ad=1.235p pd=5.27u as=1.235p ps=5.27u w=4.75u l=0.5u
X681 xl0.xout.d3 xl0.xout.n3a VSS VSS nfet_03v3 ad=0.6734p pd=3.11u as=0.6734p ps=3.11u w=2.59u l=0.28u
X682 xl0.oa xl0.rla_m1 VSS ppolyf_u_1k r_width=2u r_length=9.11u
X683 xl0.xpre.fa vref xl0.xpre.tp xl0.xpre.tp pfet_03v3 ad=1.248p pd=5.32u as=1.248p ps=5.32u w=4.8u l=0.4u
X684 VDD VDD xl0.xout.n3a VDD pfet_03v3 ad=0.88p pd=4.88u as=0.52p ps=2.52u w=2u l=0.28u
X685 xl2.xpre.tp xl2.gp xl2.xpre.fa xl2.xpre.tp pfet_03v3 ad=1.248p pd=5.32u as=1.248p ps=5.32u w=4.8u l=0.4u
X686 xl0.xpre.fb vb2 xl0.ob VSS nfet_03v3 ad=1.1752p pd=5.04u as=1.1752p ps=5.04u w=4.52u l=0.5u
X687 VSS EN xl1.xout.nm VSS nfet_03v3 ad=0.52p pd=2.52u as=0.52p ps=2.52u w=2u l=0.28u
X688 VSS xl1.xout.nd xl1.xout.i1 VSS nfet_03v3 ad=0.39p pd=2.02u as=0.39p ps=2.02u w=1.5u l=0.28u
X689 xl1.xpre.fb vbn VSS VSS nfet_03v3 ad=0.65p pd=3.02u as=0.65p ps=3.02u w=2.5u l=1u
X690 xl0.xpre.tn vref xl0.ob VSS nfet_03v3 ad=1.235p pd=5.27u as=1.235p ps=5.27u w=4.75u l=0.5u
X691 xl1.oa xl1.gp xl1.xpre.tn VSS nfet_03v3 ad=1.235p pd=5.27u as=1.235p ps=5.27u w=4.75u l=0.5u
X692 VDD xl1.d2b xl1.d2a VDD pfet_03v3 ad=0.52p pd=2.52u as=0.52p ps=2.52u w=2u l=0.28u
X693 xl2.xpre.tp vref xl2.xpre.fa xl2.xpre.tp pfet_03v3 ad=1.248p pd=5.32u as=1.248p ps=5.32u w=4.8u l=0.4u
X694 xl2.ob VSS VSS VSS nfet_03v3 ad=1.1752p pd=5.04u as=1.9888p ps=9.92u w=4.52u l=0.5u
X695 xl1.xpre.tn vbn VSS VSS nfet_03v3 ad=0.65p pd=3.02u as=0.65p ps=3.02u w=2.5u l=1u
X696 xl1.xpre.tp VDD VDD VDD pfet_03v3 ad=1.3p pd=5.52u as=2.2p ps=10.88u w=5u l=1u
X697 xl0.xpre.fa vref xl0.xpre.tp xl0.xpre.tp pfet_03v3 ad=1.248p pd=5.32u as=1.248p ps=5.32u w=4.8u l=0.4u
X698 VSS vbn xl0.xpre.fa VSS nfet_03v3 ad=0.65p pd=3.02u as=0.65p ps=3.02u w=2.5u l=1u
X699 xl0.xpre.fb vb2 xl0.ob VSS nfet_03v3 ad=1.1752p pd=5.04u as=1.1752p ps=5.04u w=4.52u l=0.5u
X700 VDD vbp vb2 VDD pfet_03v3 ad=1.3p pd=5.52u as=1.3p ps=5.52u w=5u l=1u
X701 xl1.xpre.tp xl1.gp xl1.xpre.fa xl1.xpre.tp pfet_03v3 ad=1.248p pd=5.32u as=1.248p ps=5.32u w=4.8u l=0.4u
X702 VDD xl1.d2b xl1.xout.d3 VDD pfet_03v3 ad=0.52p pd=2.52u as=0.52p ps=2.52u w=2u l=0.28u
X703 VDD vbp xl0.xpre.tp VDD pfet_03v3 ad=1.3p pd=5.52u as=1.3p ps=5.52u w=5u l=1u
X704 xl0.xpre.tp vref xl0.xpre.fb xl0.xpre.tp pfet_03v3 ad=1.248p pd=5.32u as=1.248p ps=5.32u w=4.8u l=0.4u
X705 xl1.xpre.fa xl1.gp xl1.xpre.tp xl1.xpre.tp pfet_03v3 ad=1.248p pd=5.32u as=1.248p ps=5.32u w=4.8u l=0.4u
X706 VDD xl1.d2b xl1.d2a VDD pfet_03v3 ad=0.52p pd=2.52u as=0.52p ps=2.52u w=2u l=0.28u
X707 xl2.xpre.fa vref xl2.xpre.tp xl2.xpre.tp pfet_03v3 ad=1.248p pd=5.32u as=1.248p ps=5.32u w=4.8u l=0.4u
X708 xbias.vf vb2 vb2 VSS nfet_03v3 ad=2.0566p pd=8.43u as=2.0566p ps=8.43u w=7.91u l=0.5u
X709 RX0_O VDD VDD VDD pfet_03v3 ad=1.3p pd=5.52u as=2.2p ps=10.88u w=5u l=0.28u
X710 VDD VDD xl0.xout.nd VDD pfet_03v3 ad=1.32p pd=6.88u as=0.78p ps=3.52u w=3u l=0.28u
X711 VDD xl2.d2b xl2.xout.d3 VDD pfet_03v3 ad=0.52p pd=2.52u as=0.52p ps=2.52u w=2u l=0.28u
X712 xl0.ob xl0.rlb_m1 VSS ppolyf_u_1k r_width=2u r_length=9.11u
X713 xl2.xpre.tn xl2.gp xl2.oa VSS nfet_03v3 ad=1.235p pd=5.27u as=1.235p ps=5.27u w=4.75u l=0.5u
X714 xl0.gn RX0_N VDD ppolyf_u r_width=5u r_length=1.8u
X715 xl2.xpre.fa vbn VSS VSS nfet_03v3 ad=0.65p pd=3.02u as=0.65p ps=3.02u w=2.5u l=1u
X716 xl1.xpre.tp vref xl1.xpre.fb xl1.xpre.tp pfet_03v3 ad=1.248p pd=5.32u as=1.248p ps=5.32u w=4.8u l=0.4u
X717 RX1_O xl1.xout.i2 VDD VDD pfet_03v3 ad=1.3p pd=5.52u as=1.3p ps=5.52u w=5u l=0.28u
X718 VSS VSS VSS VSS nfet_03v3 ad=0.52p pd=2.52u as=0 ps=0 w=2u l=0.5u
X719 xl2.xpre.fb vbn VSS VSS nfet_03v3 ad=0.65p pd=3.02u as=0.65p ps=3.02u w=2.5u l=1u
X720 xl2.xpre.tn vbn VSS VSS nfet_03v3 ad=0.65p pd=3.02u as=0.65p ps=3.02u w=2.5u l=1u
X721 VSS vbn xl1.xhyst.ts VSS nfet_03v3 ad=0.65p pd=3.02u as=0.65p ps=3.02u w=2.5u l=1u
X722 xl2.xpre.tp vbp VDD VDD pfet_03v3 ad=1.3p pd=5.52u as=1.3p ps=5.52u w=5u l=1u
X723 xl1.xpre.fa xl1.gp xl1.xpre.tp xl1.xpre.tp pfet_03v3 ad=1.248p pd=5.32u as=1.248p ps=5.32u w=4.8u l=0.4u
X724 vb2 VSS VSS VSS nfet_03v3 ad=0.52p pd=2.52u as=0.88p ps=4.88u w=2u l=0.5u
X725 RX2_O VDD VDD VDD pfet_03v3 ad=1.3p pd=5.52u as=2.2p ps=10.88u w=5u l=0.28u
X726 xbias.enb VDD VDD VDD pfet_03v3 ad=0.65p pd=3.02u as=1.1p ps=5.88u w=2.5u l=0.28u
X727 vref xbias.rdt_m3 VSS ppolyf_u_1k r_width=2u r_length=21.01u
X728 xl0.xpre.fb vref xl0.xpre.tp xl0.xpre.tp pfet_03v3 ad=1.248p pd=5.32u as=1.248p ps=5.32u w=4.8u l=0.4u
X729 xl1.xpre.fb vref xl1.xpre.tp xl1.xpre.tp pfet_03v3 ad=1.248p pd=5.32u as=1.248p ps=5.32u w=4.8u l=0.4u
X730 xl2.xout.d3 xl2.d2b VDD VDD pfet_03v3 ad=0.52p pd=2.52u as=0.52p ps=2.52u w=2u l=0.28u
X731 xl0.xpre.tp vbp VDD VDD pfet_03v3 ad=1.3p pd=5.52u as=1.3p ps=5.52u w=5u l=1u
X732 xl2.xpre.tp xl2.gn xl2.xpre.fb xl2.xpre.tp pfet_03v3 ad=1.248p pd=5.32u as=1.248p ps=5.32u w=4.8u l=0.4u
X733 xl2.xpre.tn xl2.gp xl2.oa VSS nfet_03v3 ad=1.235p pd=5.27u as=1.235p ps=5.27u w=4.75u l=0.5u
X734 VSS vbn xl2.xpre.fb VSS nfet_03v3 ad=0.65p pd=3.02u as=0.65p ps=3.02u w=2.5u l=1u
X735 xl1.xout.nd EN VDD VDD pfet_03v3 ad=0.78p pd=3.52u as=0.78p ps=3.52u w=3u l=0.28u
X736 xl2.d2a VDD VDD VDD pfet_03v3 ad=0.52p pd=2.52u as=0.88p ps=4.88u w=2u l=0.28u
X737 xl1.d2a xl1.oa xl1.xhyst.sa VSS nfet_03v3 ad=1.1362p pd=4.89u as=1.1362p ps=4.89u w=4.37u l=0.5u
X738 xl1.xpre.tp xl1.gp xl1.xpre.fa xl1.xpre.tp pfet_03v3 ad=1.248p pd=5.32u as=1.248p ps=5.32u w=4.8u l=0.4u
X739 VSS vbn vbn VSS nfet_03v3 ad=0.65p pd=3.02u as=0.65p ps=3.02u w=2.5u l=1u
X740 xl0.xout.i1 VSS VSS VSS nfet_03v3 ad=0.39p pd=2.02u as=0.66p ps=3.88u w=1.5u l=0.28u
X741 VSS vbn xl1.xpre.tn VSS nfet_03v3 ad=0.65p pd=3.02u as=0.65p ps=3.02u w=2.5u l=1u
X742 vbp vbn VSS VSS nfet_03v3 ad=0.65p pd=3.02u as=0.65p ps=3.02u w=2.5u l=1u
X743 xl1.xout.d3 xl1.d2b VDD VDD pfet_03v3 ad=0.52p pd=2.52u as=0.52p ps=2.52u w=2u l=0.28u
X744 VDD vbp xl1.xpre.tp VDD pfet_03v3 ad=1.3p pd=5.52u as=1.3p ps=5.52u w=5u l=1u
X745 xl2.xpre.fb vref xl2.xpre.tp xl2.xpre.tp pfet_03v3 ad=1.248p pd=5.32u as=1.248p ps=5.32u w=4.8u l=0.4u
X746 xl2.xpre.tn xl2.gp xl2.oa VSS nfet_03v3 ad=1.235p pd=5.27u as=1.235p ps=5.27u w=4.75u l=0.5u
X747 VDD xl2.d2a xl2.d2a VDD pfet_03v3 ad=0.52p pd=2.52u as=0.52p ps=2.52u w=2u l=0.28u
X748 VSS VSS VSS ppolyf_u_1k r_width=2u r_length=9.11u
X749 VDD vbp xl2.xpre.tp VDD pfet_03v3 ad=1.3p pd=5.52u as=1.3p ps=5.52u w=5u l=1u
X750 xl1.xpre.fa vbn VSS VSS nfet_03v3 ad=0.65p pd=3.02u as=0.65p ps=3.02u w=2.5u l=1u
X751 xl0.ob xl0.gn xl0.xpre.tn VSS nfet_03v3 ad=1.235p pd=5.27u as=1.235p ps=5.27u w=4.75u l=0.5u
X752 xl0.xpre.fb xl0.gn xl0.xpre.tp xl0.xpre.tp pfet_03v3 ad=1.248p pd=5.32u as=1.248p ps=5.32u w=4.8u l=0.4u
X753 VSS VSS VSS VSS nfet_03v3 ad=0.52p pd=2.52u as=0 ps=0 w=2u l=0.28u
X754 xl2.xpre.tn xl2.gn xl2.ob VSS nfet_03v3 ad=1.235p pd=5.27u as=1.235p ps=5.27u w=4.75u l=0.5u
X755 VDD xl0.d2a xl0.d2b VDD pfet_03v3 ad=0.52p pd=2.52u as=0.52p ps=2.52u w=2u l=0.28u
X756 xl1.xpre.tp vbp VDD VDD pfet_03v3 ad=1.3p pd=5.52u as=1.3p ps=5.52u w=5u l=1u
X757 xl1.xpre.fa vb2 xl1.oa VSS nfet_03v3 ad=1.1752p pd=5.04u as=1.1752p ps=5.04u w=4.52u l=0.5u
X758 xl0.xpre.fa xl0.gp xl0.xpre.tp xl0.xpre.tp pfet_03v3 ad=1.248p pd=5.32u as=1.248p ps=5.32u w=4.8u l=0.4u
X759 xl1.xpre.tp vref xl1.xpre.fa xl1.xpre.tp pfet_03v3 ad=1.248p pd=5.32u as=1.248p ps=5.32u w=4.8u l=0.4u
X760 xl2.xpre.tp vref xl2.xpre.fa xl2.xpre.tp pfet_03v3 ad=1.248p pd=5.32u as=1.248p ps=5.32u w=4.8u l=0.4u
D8 VSS xl1.gp diode_nd2ps_03v3 pj=26u area=40p
X761 xl0.oa xl0.gp xl0.xpre.tn VSS nfet_03v3 ad=1.235p pd=5.27u as=1.235p ps=5.27u w=4.75u l=0.5u
X762 xl1.xpre.tn vbn VSS VSS nfet_03v3 ad=0.65p pd=3.02u as=0.65p ps=3.02u w=2.5u l=1u
X763 VDD xbias.enb xbias.nrb VDD pfet_03v3 ad=1.3p pd=5.52u as=1.3p ps=5.52u w=5u l=0.5u
X764 xl0.xpre.tp xl0.gn xl0.xpre.fb xl0.xpre.tp pfet_03v3 ad=1.248p pd=5.32u as=1.248p ps=5.32u w=4.8u l=0.4u
X765 xl2.xpre.fb xl2.gn xl2.xpre.tp xl2.xpre.tp pfet_03v3 ad=1.248p pd=5.32u as=1.248p ps=5.32u w=4.8u l=0.4u
X766 xl1.xpre.fa vb2 xl1.oa VSS nfet_03v3 ad=1.1752p pd=5.04u as=1.1752p ps=5.04u w=4.52u l=0.5u
X767 xl2.xpre.tn VSS VSS VSS nfet_03v3 ad=0.65p pd=3.02u as=1.1p ps=5.88u w=2.5u l=1u
X768 xl2.xpre.tp vref xl2.xpre.fa xl2.xpre.tp pfet_03v3 ad=1.248p pd=5.32u as=1.248p ps=5.32u w=4.8u l=0.4u
X769 xl2.oa vref xl2.xpre.tn VSS nfet_03v3 ad=1.235p pd=5.27u as=1.235p ps=5.27u w=4.75u l=0.5u
X770 VDD xl2.d2a xl2.xout.n3a VDD pfet_03v3 ad=0.52p pd=2.52u as=0.52p ps=2.52u w=2u l=0.28u
X771 xl0.xpre.tn vref xl0.ob VSS nfet_03v3 ad=1.235p pd=5.27u as=1.235p ps=5.27u w=4.75u l=0.5u
X772 VDD xl0.d2a xl0.xout.n3a VDD pfet_03v3 ad=0.52p pd=2.52u as=0.52p ps=2.52u w=2u l=0.28u
X773 VDD xl1.rla_m1 VSS ppolyf_u_1k r_width=2u r_length=9.11u
X774 VDD xl2.d2a xl2.d2a VDD pfet_03v3 ad=0.52p pd=2.52u as=0.52p ps=2.52u w=2u l=0.28u
X775 xl0.gp RX0_P VDD ppolyf_u r_width=5u r_length=1.8u
X776 VDD VDD RX0_O VDD pfet_03v3 ad=2.2p pd=10.88u as=1.3p ps=5.52u w=5u l=0.28u
X777 VDD vbp xl0.xpre.tp VDD pfet_03v3 ad=1.3p pd=5.52u as=1.3p ps=5.52u w=5u l=1u
X778 xl1.xpre.tn xl1.gp xl1.oa VSS nfet_03v3 ad=1.235p pd=5.27u as=1.235p ps=5.27u w=4.75u l=0.5u
X779 xl2.ob vref xl2.xpre.tn VSS nfet_03v3 ad=1.235p pd=5.27u as=1.235p ps=5.27u w=4.75u l=0.5u
X780 VSS VSS VSS VSS nfet_03v3 ad=1.1396p pd=6.06u as=0 ps=0 w=2.59u l=0.28u
X781 xl1.xpre.tp vref xl1.xpre.fb xl1.xpre.tp pfet_03v3 ad=1.248p pd=5.32u as=2.112p ps=10.48u w=4.8u l=0.4u
X782 xl0.xout.nd VSS VSS VSS nfet_03v3 ad=0.52p pd=2.52u as=0.88p ps=4.88u w=2u l=0.28u
X783 xl1.xpre.fa xl1.gp xl1.xpre.tp xl1.xpre.tp pfet_03v3 ad=1.248p pd=5.32u as=1.248p ps=5.32u w=4.8u l=0.4u
X784 vb2 vbp VDD VDD pfet_03v3 ad=1.3p pd=5.52u as=1.3p ps=5.52u w=5u l=1u
X785 xl2.xpre.fa vref xl2.xpre.tp xl2.xpre.tp pfet_03v3 ad=1.248p pd=5.32u as=1.248p ps=5.32u w=4.8u l=0.4u
X786 xl1.xpre.tn xl1.gn xl1.ob VSS nfet_03v3 ad=1.235p pd=5.27u as=1.235p ps=5.27u w=4.75u l=0.5u
X787 xl2.oa vref xl2.xpre.tn VSS nfet_03v3 ad=1.235p pd=5.27u as=1.235p ps=5.27u w=4.75u l=0.5u
X788 xl0.xpre.fa vbn VSS VSS nfet_03v3 ad=0.65p pd=3.02u as=0.65p ps=3.02u w=2.5u l=1u
X789 xl2.xpre.tp vbp VDD VDD pfet_03v3 ad=1.3p pd=5.52u as=1.3p ps=5.52u w=5u l=1u
X790 xl2.xpre.fa xl2.gp xl2.xpre.tp xl2.xpre.tp pfet_03v3 ad=1.248p pd=5.32u as=1.248p ps=5.32u w=4.8u l=0.4u
X791 VDD EN xl1.d2b VDD pfet_03v3 ad=0.52p pd=2.52u as=0.52p ps=2.52u w=2u l=0.5u
X792 xl0.xpre.tp vbp VDD VDD pfet_03v3 ad=1.3p pd=5.52u as=1.3p ps=5.52u w=5u l=1u
X793 xl0.xpre.fb vbn VSS VSS nfet_03v3 ad=0.65p pd=3.02u as=0.65p ps=3.02u w=2.5u l=1u
X794 xl1.xpre.fb vbn VSS VSS nfet_03v3 ad=0.65p pd=3.02u as=0.65p ps=3.02u w=2.5u l=1u
X795 VDD VDD RX2_O VDD pfet_03v3 ad=2.2p pd=10.88u as=1.3p ps=5.52u w=5u l=0.28u
X796 VSS xl0.xout.nd xl0.xout.i1 VSS nfet_03v3 ad=0.39p pd=2.02u as=0.39p ps=2.02u w=1.5u l=0.28u
X797 VSS EN xl0.xout.nm VSS nfet_03v3 ad=0.52p pd=2.52u as=0.52p ps=2.52u w=2u l=0.28u
X798 xl1.xpre.tn vref xl1.ob VSS nfet_03v3 ad=1.235p pd=5.27u as=1.235p ps=5.27u w=4.75u l=0.5u
X799 xl1.xout.n3a VDD VDD VDD pfet_03v3 ad=0.52p pd=2.52u as=0.88p ps=4.88u w=2u l=0.28u
X800 xl1.xpre.tp vbp VDD VDD pfet_03v3 ad=1.3p pd=5.52u as=1.3p ps=5.52u w=5u l=1u
X801 xl1.xpre.tp vref xl1.xpre.fb xl1.xpre.tp pfet_03v3 ad=1.248p pd=5.32u as=1.248p ps=5.32u w=4.8u l=0.4u
X802 xl0.xout.i1 VDD VDD VDD pfet_03v3 ad=0.962p pd=4.22u as=1.628p ps=8.28u w=3.7u l=0.28u
X803 xl0.xpre.tp xl0.gp xl0.xpre.fa xl0.xpre.tp pfet_03v3 ad=1.248p pd=5.32u as=1.248p ps=5.32u w=4.8u l=0.4u
X804 VDD EN xl2.d2a VDD pfet_03v3 ad=0.52p pd=2.52u as=0.52p ps=2.52u w=2u l=0.5u
X805 xl0.xpre.fb vref xl0.xpre.tp xl0.xpre.tp pfet_03v3 ad=1.248p pd=5.32u as=1.248p ps=5.32u w=4.8u l=0.4u
X806 xl1.xpre.fb vref xl1.xpre.tp xl1.xpre.tp pfet_03v3 ad=1.248p pd=5.32u as=1.248p ps=5.32u w=4.8u l=0.4u
X807 xl2.xpre.fa xl2.gp xl2.xpre.tp xl2.xpre.tp pfet_03v3 ad=1.248p pd=5.32u as=1.248p ps=5.32u w=4.8u l=0.4u
X808 VSS vbn xl2.xpre.tn VSS nfet_03v3 ad=0.65p pd=3.02u as=0.65p ps=3.02u w=2.5u l=1u
X809 xl1.xpre.tp vref xl1.xpre.fb xl1.xpre.tp pfet_03v3 ad=1.248p pd=5.32u as=1.248p ps=5.32u w=4.8u l=0.4u
X810 xl2.xpre.tp xl2.gn xl2.xpre.fb xl2.xpre.tp pfet_03v3 ad=1.248p pd=5.32u as=1.248p ps=5.32u w=4.8u l=0.4u
X811 xl2.ob vref xl2.xpre.tn VSS nfet_03v3 ad=2.09p pd=10.38u as=1.235p ps=5.27u w=4.75u l=0.5u
X812 VDD vbp xl2.xpre.tp VDD pfet_03v3 ad=1.3p pd=5.52u as=1.3p ps=5.52u w=5u l=1u
X813 xl1.oa xl1.gp xl1.xpre.tn VSS nfet_03v3 ad=1.235p pd=5.27u as=1.235p ps=5.27u w=4.75u l=0.5u
X814 xl2.xpre.fb xl2.gn xl2.xpre.tp xl2.xpre.tp pfet_03v3 ad=1.248p pd=5.32u as=1.248p ps=5.32u w=4.8u l=0.4u
X815 VSS VSS xl2.xpre.fb VSS nfet_03v3 ad=1.9888p pd=9.92u as=1.1752p ps=5.04u w=4.52u l=0.5u
X816 xl0.d2a xl0.d2a VDD VDD pfet_03v3 ad=0.52p pd=2.52u as=0.52p ps=2.52u w=2u l=0.28u
X817 VSS VSS xl2.d2a VSS nfet_03v3 ad=1.9228p pd=9.62u as=1.1362p ps=4.89u w=4.37u l=0.5u
X818 xl0.xpre.fa vb2 xl0.oa VSS nfet_03v3 ad=1.1752p pd=5.04u as=1.1752p ps=5.04u w=4.52u l=0.5u
X819 VSS vbn xl0.xpre.fb VSS nfet_03v3 ad=0.65p pd=3.02u as=0.65p ps=3.02u w=2.5u l=1u
X820 RX0_O xl0.xout.i2 VDD VDD pfet_03v3 ad=1.3p pd=5.52u as=1.3p ps=5.52u w=5u l=0.28u
X821 xl0.d2b VSS VSS VSS nfet_03v3 ad=1.1362p pd=4.89u as=1.9228p ps=9.62u w=4.37u l=0.5u
X822 xl0.xpre.tp vref xl0.xpre.fa xl0.xpre.tp pfet_03v3 ad=1.248p pd=5.32u as=1.248p ps=5.32u w=4.8u l=0.4u
X823 VSS VSS VSS ppolyf_u_1k r_width=2u r_length=3.17u
X824 xl2.xhyst.ts vbn VSS VSS nfet_03v3 ad=0.65p pd=3.02u as=0.65p ps=3.02u w=2.5u l=1u
X825 xl0.xpre.fa vb2 xl0.oa VSS nfet_03v3 ad=1.1752p pd=5.04u as=1.1752p ps=5.04u w=4.52u l=0.5u
X826 xl1.xout.d3 xl1.d2b VDD VDD pfet_03v3 ad=0.52p pd=2.52u as=0.52p ps=2.52u w=2u l=0.28u
X827 xl2.xpre.tp xl2.gn xl2.xpre.fb xl2.xpre.tp pfet_03v3 ad=1.248p pd=5.32u as=1.248p ps=5.32u w=4.8u l=0.4u
X828 VDD xl0.rlb_m1 VSS ppolyf_u_1k r_width=2u r_length=9.11u
X829 xl2.xpre.fb xl2.gn xl2.xpre.tp xl2.xpre.tp pfet_03v3 ad=1.248p pd=5.32u as=1.248p ps=5.32u w=4.8u l=0.4u
X830 xl0.xpre.tn vref xl0.oa VSS nfet_03v3 ad=1.235p pd=5.27u as=1.235p ps=5.27u w=4.75u l=0.5u
X831 VSS vbn xl1.xpre.fb VSS nfet_03v3 ad=0.65p pd=3.02u as=0.65p ps=3.02u w=2.5u l=1u
X832 xl2.d2b xl2.d2b VDD VDD pfet_03v3 ad=0.52p pd=2.52u as=0.52p ps=2.52u w=2u l=0.28u
X833 xl0.xpre.fa VSS VSS VSS nfet_03v3 ad=0.65p pd=3.02u as=1.1p ps=5.88u w=2.5u l=1u
X834 RX2_O xl2.xout.i2 VDD VDD pfet_03v3 ad=1.3p pd=5.52u as=1.3p ps=5.52u w=5u l=0.28u
X835 xl0.xpre.fb vb2 xl0.ob VSS nfet_03v3 ad=1.1752p pd=5.04u as=1.1752p ps=5.04u w=4.52u l=0.5u
X836 VDD vbp xl1.xpre.tp VDD pfet_03v3 ad=1.3p pd=5.52u as=1.3p ps=5.52u w=5u l=1u
X837 xl1.xpre.tp xl1.gp xl1.xpre.fa xl1.xpre.tp pfet_03v3 ad=1.248p pd=5.32u as=1.248p ps=5.32u w=4.8u l=0.4u
X838 xl0.xhyst.ts vbn VSS VSS nfet_03v3 ad=0.65p pd=3.02u as=0.65p ps=3.02u w=2.5u l=1u
X839 vbp vbn VSS VSS nfet_03v3 ad=0.65p pd=3.02u as=0.65p ps=3.02u w=2.5u l=1u
X840 xl0.xpre.tp vref xl0.xpre.fa xl0.xpre.tp pfet_03v3 ad=1.248p pd=5.32u as=1.248p ps=5.32u w=4.8u l=0.4u
X841 xl2.xhyst.ts xl2.xhyst.sb VSS ppolyf_u_1k r_width=2u r_length=3.17u
X842 xl0.xpre.tp vref xl0.xpre.fb xl0.xpre.tp pfet_03v3 ad=1.248p pd=5.32u as=1.248p ps=5.32u w=4.8u l=0.4u
X843 xl2.xpre.fa xl2.gp xl2.xpre.tp xl2.xpre.tp pfet_03v3 ad=1.248p pd=5.32u as=1.248p ps=5.32u w=4.8u l=0.4u
X844 xbias.rb_m3 vbn VSS ppolyf_u_1k r_width=2u r_length=22.27u
X845 xl0.xpre.tn xl0.gn xl0.ob VSS nfet_03v3 ad=1.235p pd=5.27u as=1.235p ps=5.27u w=4.75u l=0.5u
X846 VDD xl0.d2a xl0.xout.n3a VDD pfet_03v3 ad=0.52p pd=2.52u as=0.52p ps=2.52u w=2u l=0.28u
X847 xl1.xpre.fb xl1.gn xl1.xpre.tp xl1.xpre.tp pfet_03v3 ad=1.248p pd=5.32u as=1.248p ps=5.32u w=4.8u l=0.4u
X848 xl0.xpre.fa vbn VSS VSS nfet_03v3 ad=0.65p pd=3.02u as=0.65p ps=3.02u w=2.5u l=1u
X849 VDD VDD VDD VDD pfet_03v3 ad=0.962p pd=4.22u as=0 ps=0 w=3.7u l=0.28u
X850 xl0.xpre.tp vbp VDD VDD pfet_03v3 ad=1.3p pd=5.52u as=1.3p ps=5.52u w=5u l=1u
X851 VSS vbn xl2.xhyst.ts VSS nfet_03v3 ad=0.65p pd=3.02u as=0.65p ps=3.02u w=2.5u l=1u
X852 xl0.xpre.tn vref xl0.oa VSS nfet_03v3 ad=1.235p pd=5.27u as=1.235p ps=5.27u w=4.75u l=0.5u
X853 xl0.d2b xl0.d2a VDD VDD pfet_03v3 ad=0.52p pd=2.52u as=0.52p ps=2.52u w=2u l=0.28u
X854 xl0.xpre.tp xl0.gn xl0.xpre.fb xl0.xpre.tp pfet_03v3 ad=1.248p pd=5.32u as=1.248p ps=5.32u w=4.8u l=0.4u
X855 xl1.xpre.tp xl1.gn xl1.xpre.fb xl1.xpre.tp pfet_03v3 ad=1.248p pd=5.32u as=1.248p ps=5.32u w=4.8u l=0.4u
X856 xl2.xpre.tn xl2.gn xl2.ob VSS nfet_03v3 ad=1.235p pd=5.27u as=1.235p ps=5.27u w=4.75u l=0.5u
X857 xl1.d2b xl1.d2a VDD VDD pfet_03v3 ad=0.52p pd=2.52u as=0.52p ps=2.52u w=2u l=0.28u
X858 xl1.xpre.fb vref xl1.xpre.tp xl1.xpre.tp pfet_03v3 ad=1.248p pd=5.32u as=1.248p ps=5.32u w=4.8u l=0.4u
X859 xl2.xpre.tp xl2.gn xl2.xpre.fb xl2.xpre.tp pfet_03v3 ad=1.248p pd=5.32u as=1.248p ps=5.32u w=4.8u l=0.4u
X860 VSS vbn xl0.xpre.fa VSS nfet_03v3 ad=0.65p pd=3.02u as=0.65p ps=3.02u w=2.5u l=1u
X861 VDD xl0.xout.i1 xl0.xout.i2 VDD pfet_03v3 ad=0.975p pd=4.27u as=0.975p ps=4.27u w=3.75u l=0.28u
X862 xl2.xpre.tn xl2.gp xl2.oa VSS nfet_03v3 ad=1.235p pd=5.27u as=1.235p ps=5.27u w=4.75u l=0.5u
X863 VSS vbn xl1.xpre.fb VSS nfet_03v3 ad=0.65p pd=3.02u as=0.65p ps=3.02u w=2.5u l=1u
X864 VSS vbn xl0.xpre.tn VSS nfet_03v3 ad=0.65p pd=3.02u as=0.65p ps=3.02u w=2.5u l=1u
X865 xl1.xout.n3a xl1.d2a VDD VDD pfet_03v3 ad=0.52p pd=2.52u as=0.52p ps=2.52u w=2u l=0.28u
X866 xl2.xhyst.ts vbn VSS VSS nfet_03v3 ad=0.65p pd=3.02u as=0.65p ps=3.02u w=2.5u l=1u
D9 xl2.gn VDD diode_pd2nw_03v3 pj=26u area=40p
X867 xl0.ob xl0.gn xl0.xpre.tn VSS nfet_03v3 ad=1.235p pd=5.27u as=1.235p ps=5.27u w=4.75u l=0.5u
X868 xl2.xpre.fb vref xl2.xpre.tp xl2.xpre.tp pfet_03v3 ad=2.112p pd=10.48u as=1.248p ps=5.32u w=4.8u l=0.4u
X869 xl1.d2a xl1.d2b VDD VDD pfet_03v3 ad=0.52p pd=2.52u as=0.52p ps=2.52u w=2u l=0.28u
X870 xl0.xhyst.ts VSS VSS VSS nfet_03v3 ad=0.65p pd=3.02u as=1.1p ps=5.88u w=2.5u l=1u
X871 xl2.xout.n3a xl2.d2a VDD VDD pfet_03v3 ad=0.52p pd=2.52u as=0.52p ps=2.52u w=2u l=0.28u
X872 xl2.xpre.fb xl2.gn xl2.xpre.tp xl2.xpre.tp pfet_03v3 ad=1.248p pd=5.32u as=1.248p ps=5.32u w=4.8u l=0.4u
X873 xl0.ob xl0.gn xl0.xpre.tn VSS nfet_03v3 ad=1.235p pd=5.27u as=1.235p ps=5.27u w=4.75u l=0.5u
X874 VDD xbias.enb xbias.nrb VDD pfet_03v3 ad=1.3p pd=5.52u as=1.3p ps=5.52u w=5u l=0.5u
X875 VDD VDD xbias.nrb VDD pfet_03v3 ad=2.2p pd=10.88u as=1.3p ps=5.52u w=5u l=0.5u
X876 VSS xl2.xout.n3a xl2.xout.d3 VSS nfet_03v3 ad=0.6734p pd=3.11u as=0.6734p ps=3.11u w=2.59u l=0.28u
X877 xl1.xpre.tp xl1.gp xl1.xpre.fa xl1.xpre.tp pfet_03v3 ad=1.248p pd=5.32u as=1.248p ps=5.32u w=4.8u l=0.4u
X878 xl1.oa vref xl1.xpre.tn VSS nfet_03v3 ad=1.235p pd=5.27u as=1.235p ps=5.27u w=4.75u l=0.5u
X879 xl0.xpre.fb vbn VSS VSS nfet_03v3 ad=0.65p pd=3.02u as=0.65p ps=3.02u w=2.5u l=1u
X880 xl0.oa xl0.gp xl0.xpre.tn VSS nfet_03v3 ad=1.235p pd=5.27u as=1.235p ps=5.27u w=4.75u l=0.5u
X881 VDD xl0.d2b xl0.d2a VDD pfet_03v3 ad=0.52p pd=2.52u as=0.52p ps=2.52u w=2u l=0.28u
X882 VSS VSS xl2.d2b VSS nfet_03v3 ad=1.9228p pd=9.62u as=1.1362p ps=4.89u w=4.37u l=0.5u
X883 VSS vbn xl2.xpre.fb VSS nfet_03v3 ad=0.65p pd=3.02u as=0.65p ps=3.02u w=2.5u l=1u
X884 VDD xbias.enb xbias.nrb VDD pfet_03v3 ad=1.3p pd=5.52u as=1.3p ps=5.52u w=5u l=0.5u
X885 xl2.xpre.fb xl2.gn xl2.xpre.tp xl2.xpre.tp pfet_03v3 ad=1.248p pd=5.32u as=1.248p ps=5.32u w=4.8u l=0.4u
X886 xl0.xpre.tn vbn VSS VSS nfet_03v3 ad=0.65p pd=3.02u as=0.65p ps=3.02u w=2.5u l=1u
X887 xl0.xpre.tp VDD VDD VDD pfet_03v3 ad=1.3p pd=5.52u as=2.2p ps=10.88u w=5u l=1u
X888 xl1.ob vb2 xl1.xpre.fb VSS nfet_03v3 ad=1.1752p pd=5.04u as=1.1752p ps=5.04u w=4.52u l=0.5u
X889 VSS vbn xl2.xhyst.ts VSS nfet_03v3 ad=0.65p pd=3.02u as=0.65p ps=3.02u w=2.5u l=1u
D10 VSS xl2.gn diode_nd2ps_03v3 pj=26u area=40p
X890 xl0.xpre.tp xl0.gp xl0.xpre.fa xl0.xpre.tp pfet_03v3 ad=1.248p pd=5.32u as=1.248p ps=5.32u w=4.8u l=0.4u
X891 xl1.ob vref xl1.xpre.tn VSS nfet_03v3 ad=1.235p pd=5.27u as=1.235p ps=5.27u w=4.75u l=0.5u
X892 vbn VSS VSS VSS nfet_03v3 ad=0.65p pd=3.02u as=1.1p ps=5.88u w=2.5u l=1u
X893 VDD xl2.d2b xl2.d2b VDD pfet_03v3 ad=0.52p pd=2.52u as=0.52p ps=2.52u w=2u l=0.28u
X894 VDD xl0.d2b xl0.xout.d3 VDD pfet_03v3 ad=0.52p pd=2.52u as=0.52p ps=2.52u w=2u l=0.28u
X895 VDD vbp vbp VDD pfet_03v3 ad=1.3p pd=5.52u as=1.3p ps=5.52u w=5u l=1u
X896 xl2.xout.nm xl2.xout.d3 xl2.xout.nd VSS nfet_03v3 ad=0.52p pd=2.52u as=0.52p ps=2.52u w=2u l=0.28u
X897 xl2.xout.i2 VDD VDD VDD pfet_03v3 ad=0.975p pd=4.27u as=1.65p ps=8.38u w=3.75u l=0.28u
X898 xl0.xpre.fa xl0.gp xl0.xpre.tp xl0.xpre.tp pfet_03v3 ad=1.248p pd=5.32u as=1.248p ps=5.32u w=4.8u l=0.4u
X899 xl1.xpre.fa vref xl1.xpre.tp xl1.xpre.tp pfet_03v3 ad=1.248p pd=5.32u as=1.248p ps=5.32u w=4.8u l=0.4u
X900 VDD xl1.d2b xl1.xout.d3 VDD pfet_03v3 ad=0.52p pd=2.52u as=0.52p ps=2.52u w=2u l=0.28u
X901 VDD xl0.d2b xl0.d2a VDD pfet_03v3 ad=0.52p pd=2.52u as=0.52p ps=2.52u w=2u l=0.28u
X902 xl1.xpre.tn xl1.gp xl1.oa VSS nfet_03v3 ad=1.235p pd=5.27u as=1.235p ps=5.27u w=4.75u l=0.5u
X903 xbias.rdt_m2 xbias.rdt_m3 VSS ppolyf_u_1k r_width=2u r_length=21.01u
X904 xl1.xpre.fa vbn VSS VSS nfet_03v3 ad=0.65p pd=3.02u as=0.65p ps=3.02u w=2.5u l=1u
X905 VSS xl0.xout.n3a xl0.xout.n3a VSS nfet_03v3 ad=0.6734p pd=3.11u as=0.6734p ps=3.11u w=2.59u l=0.28u
X906 VSS vbn xl2.xhyst.ts VSS nfet_03v3 ad=0.65p pd=3.02u as=0.65p ps=3.02u w=2.5u l=1u
X907 xl0.xpre.tp vref xl0.xpre.fb xl0.xpre.tp pfet_03v3 ad=1.248p pd=5.32u as=1.248p ps=5.32u w=4.8u l=0.4u
X908 xl2.xpre.fb vref xl2.xpre.tp xl2.xpre.tp pfet_03v3 ad=1.248p pd=5.32u as=1.248p ps=5.32u w=4.8u l=0.4u
X909 VSS VSS VSS ppolyf_u_1k r_width=2u r_length=9.11u
X910 xl1.xpre.fa vref xl1.xpre.tp xl1.xpre.tp pfet_03v3 ad=1.248p pd=5.32u as=1.248p ps=5.32u w=4.8u l=0.4u
X911 xl1.xpre.tn vbn VSS VSS nfet_03v3 ad=0.65p pd=3.02u as=0.65p ps=3.02u w=2.5u l=1u
X912 xl2.xpre.fa vref xl2.xpre.tp xl2.xpre.tp pfet_03v3 ad=1.248p pd=5.32u as=1.248p ps=5.32u w=4.8u l=0.4u
X913 VSS vbn xl0.xhyst.ts VSS nfet_03v3 ad=0.65p pd=3.02u as=0.65p ps=3.02u w=2.5u l=1u
X914 xl1.d2a xl1.d2b VDD VDD pfet_03v3 ad=0.52p pd=2.52u as=0.52p ps=2.52u w=2u l=0.28u
X915 xl0.xpre.fa xl0.gp xl0.xpre.tp xl0.xpre.tp pfet_03v3 ad=1.248p pd=5.32u as=1.248p ps=5.32u w=4.8u l=0.4u
X916 xl2.xpre.tp vref xl2.xpre.fa xl2.xpre.tp pfet_03v3 ad=1.248p pd=5.32u as=1.248p ps=5.32u w=4.8u l=0.4u
X917 VSS vbn xl1.xhyst.ts VSS nfet_03v3 ad=0.65p pd=3.02u as=0.65p ps=3.02u w=2.5u l=1u
X918 VDD VDD xl1.xout.i2 VDD pfet_03v3 ad=1.65p pd=8.38u as=0.975p ps=4.27u w=3.75u l=0.28u
X919 xl1.xout.d3 xl1.d2b VDD VDD pfet_03v3 ad=0.52p pd=2.52u as=0.52p ps=2.52u w=2u l=0.28u
X920 xl0.xpre.fb vref xl0.xpre.tp xl0.xpre.tp pfet_03v3 ad=1.248p pd=5.32u as=1.248p ps=5.32u w=4.8u l=0.4u
X921 xl1.xpre.tp xl1.gn xl1.xpre.fb xl1.xpre.tp pfet_03v3 ad=1.248p pd=5.32u as=1.248p ps=5.32u w=4.8u l=0.4u
X922 xl1.xpre.fa vref xl1.xpre.tp xl1.xpre.tp pfet_03v3 ad=1.248p pd=5.32u as=1.248p ps=5.32u w=4.8u l=0.4u
X923 xl0.xout.nd EN VDD VDD pfet_03v3 ad=0.78p pd=3.52u as=0.78p ps=3.52u w=3u l=0.28u
X924 xl1.d2a VDD VDD VDD pfet_03v3 ad=0.52p pd=2.52u as=0.88p ps=4.88u w=2u l=0.28u
X925 xl0.d2a xl0.oa xl0.xhyst.sa VSS nfet_03v3 ad=1.1362p pd=4.89u as=1.1362p ps=4.89u w=4.37u l=0.5u
X926 xl0.xpre.tp xl0.gp xl0.xpre.fa xl0.xpre.tp pfet_03v3 ad=1.248p pd=5.32u as=1.248p ps=5.32u w=4.8u l=0.4u
X927 xl2.xpre.fa xl2.gp xl2.xpre.tp xl2.xpre.tp pfet_03v3 ad=1.248p pd=5.32u as=1.248p ps=5.32u w=4.8u l=0.4u
X928 xl2.xout.d3 xl2.d2b VDD VDD pfet_03v3 ad=0.52p pd=2.52u as=0.52p ps=2.52u w=2u l=0.28u
X929 xl1.xhyst.ts xl1.xhyst.sa VSS ppolyf_u_1k r_width=2u r_length=3.17u
X930 VSS vbn xl0.xpre.tn VSS nfet_03v3 ad=0.65p pd=3.02u as=0.65p ps=3.02u w=2.5u l=1u
X931 vbn vbn VSS VSS nfet_03v3 ad=0.65p pd=3.02u as=0.65p ps=3.02u w=2.5u l=1u
X932 xl2.d2b xl2.d2a VDD VDD pfet_03v3 ad=0.52p pd=2.52u as=0.52p ps=2.52u w=2u l=0.28u
X933 xl0.xout.d3 xl0.d2b VDD VDD pfet_03v3 ad=0.52p pd=2.52u as=0.52p ps=2.52u w=2u l=0.28u
X934 VDD vbp xl0.xpre.tp VDD pfet_03v3 ad=1.3p pd=5.52u as=1.3p ps=5.52u w=5u l=1u
X935 xl1.xpre.tp vref xl1.xpre.fb xl1.xpre.tp pfet_03v3 ad=1.248p pd=5.32u as=1.248p ps=5.32u w=4.8u l=0.4u
X936 xl2.xpre.tp xl2.gn xl2.xpre.fb xl2.xpre.tp pfet_03v3 ad=1.248p pd=5.32u as=1.248p ps=5.32u w=4.8u l=0.4u
X937 VSS vbn xl2.xpre.fa VSS nfet_03v3 ad=0.65p pd=3.02u as=0.65p ps=3.02u w=2.5u l=1u
X938 xl2.xhyst.sa xl2.oa xl2.d2a VSS nfet_03v3 ad=1.1362p pd=4.89u as=1.1362p ps=4.89u w=4.37u l=0.5u
X939 VSS VSS VSS ppolyf_u_1k r_width=2u r_length=9.11u
X940 VDD vbp xl1.xpre.tp VDD pfet_03v3 ad=1.3p pd=5.52u as=1.3p ps=5.52u w=5u l=1u
X941 xl0.xpre.fa vbn VSS VSS nfet_03v3 ad=0.65p pd=3.02u as=0.65p ps=3.02u w=2.5u l=1u
X942 vbp vbp VDD VDD pfet_03v3 ad=1.3p pd=5.52u as=1.3p ps=5.52u w=5u l=1u
X943 VSS VSS VSS VSS nfet_03v3 ad=0.6734p pd=3.11u as=0 ps=0 w=2.59u l=0.28u
X944 xl0.xpre.tp vbp VDD VDD pfet_03v3 ad=1.3p pd=5.52u as=1.3p ps=5.52u w=5u l=1u
X945 xl0.xpre.fa vb2 xl0.oa VSS nfet_03v3 ad=1.1752p pd=5.04u as=1.1752p ps=5.04u w=4.52u l=0.5u
X946 xl0.xpre.tp vref xl0.xpre.fa xl0.xpre.tp pfet_03v3 ad=1.248p pd=5.32u as=1.248p ps=5.32u w=4.8u l=0.4u
X947 xl1.xpre.tp vref xl1.xpre.fa xl1.xpre.tp pfet_03v3 ad=1.248p pd=5.32u as=1.248p ps=5.32u w=4.8u l=0.4u
D11 VSS xl0.gp diode_nd2ps_03v3 pj=26u area=40p
X948 xl1.xpre.fb xl1.gn xl1.xpre.tp xl1.xpre.tp pfet_03v3 ad=1.248p pd=5.32u as=1.248p ps=5.32u w=4.8u l=0.4u
X949 xl0.xpre.tn vbn VSS VSS nfet_03v3 ad=0.65p pd=3.02u as=0.65p ps=3.02u w=2.5u l=1u
X950 VDD VDD VDD VDD pfet_03v3 ad=0.52p pd=2.52u as=0 ps=0 w=2u l=0.5u
X951 VDD xl1.d2b xl1.d2b VDD pfet_03v3 ad=0.52p pd=2.52u as=0.52p ps=2.52u w=2u l=0.28u
X952 VSS vbn xl2.xpre.fb VSS nfet_03v3 ad=0.65p pd=3.02u as=0.65p ps=3.02u w=2.5u l=1u
X953 xl0.xpre.fa vb2 xl0.oa VSS nfet_03v3 ad=1.1752p pd=5.04u as=1.1752p ps=5.04u w=4.52u l=0.5u
X954 xl2.oa vb2 xl2.xpre.fa VSS nfet_03v3 ad=1.1752p pd=5.04u as=1.1752p ps=5.04u w=4.52u l=0.5u
X955 xl1.xpre.tn VSS VSS VSS nfet_03v3 ad=0.65p pd=3.02u as=1.1p ps=5.88u w=2.5u l=1u
X956 VDD vbp xl2.xpre.tp VDD pfet_03v3 ad=1.3p pd=5.52u as=1.3p ps=5.52u w=5u l=1u
X957 xl1.oa vref xl1.xpre.tn VSS nfet_03v3 ad=1.235p pd=5.27u as=1.235p ps=5.27u w=4.75u l=0.5u
X958 VDD xl1.d2a xl1.xout.n3a VDD pfet_03v3 ad=0.52p pd=2.52u as=0.52p ps=2.52u w=2u l=0.28u
X959 xl1.xhyst.ts vbn VSS VSS nfet_03v3 ad=0.65p pd=3.02u as=0.65p ps=3.02u w=2.5u l=1u
X960 vbp VDD VDD VDD pfet_03v3 ad=0.52p pd=2.52u as=0.88p ps=4.88u w=2u l=0.5u
X961 VDD xl0.rla_m1 VSS ppolyf_u_1k r_width=2u r_length=9.11u
X962 VDD VDD xl2.xpre.tp VDD pfet_03v3 ad=2.2p pd=10.88u as=1.3p ps=5.52u w=5u l=1u
X963 xl2.oa VSS VSS VSS nfet_03v3 ad=1.1752p pd=5.04u as=1.9888p ps=9.92u w=4.52u l=0.5u
X964 VDD xl1.d2a xl1.d2a VDD pfet_03v3 ad=0.52p pd=2.52u as=0.52p ps=2.52u w=2u l=0.28u
X965 VDD xl2.d2a xl2.xout.n3a VDD pfet_03v3 ad=0.52p pd=2.52u as=0.52p ps=2.52u w=2u l=0.28u
X966 xl0.xpre.tn xl0.gp xl0.oa VSS nfet_03v3 ad=1.235p pd=5.27u as=1.235p ps=5.27u w=4.75u l=0.5u
X967 xl1.ob vref xl1.xpre.tn VSS nfet_03v3 ad=1.235p pd=5.27u as=1.235p ps=5.27u w=4.75u l=0.5u
X968 xl2.xout.n3a xl2.xout.n3a VSS VSS nfet_03v3 ad=0.6734p pd=3.11u as=0.6734p ps=3.11u w=2.59u l=0.28u
X969 xl0.xpre.tp vref xl0.xpre.fb xl0.xpre.tp pfet_03v3 ad=1.248p pd=5.32u as=2.112p ps=10.48u w=4.8u l=0.4u
X970 xl2.xpre.fb xl2.gn xl2.xpre.tp xl2.xpre.tp pfet_03v3 ad=1.248p pd=5.32u as=1.248p ps=5.32u w=4.8u l=0.4u
X971 xl0.xpre.fa xl0.gp xl0.xpre.tp xl0.xpre.tp pfet_03v3 ad=1.248p pd=5.32u as=1.248p ps=5.32u w=4.8u l=0.4u
X972 xl1.xpre.tp vref xl1.xpre.fa xl1.xpre.tp pfet_03v3 ad=1.248p pd=5.32u as=1.248p ps=5.32u w=4.8u l=0.4u
X973 xl2.xpre.fb vbn VSS VSS nfet_03v3 ad=0.65p pd=3.02u as=0.65p ps=3.02u w=2.5u l=1u
X974 VDD VDD VDD VDD pfet_03v3 ad=0.52p pd=2.52u as=0 ps=0 w=2u l=0.5u
X975 xl2.oa xl2.gp xl2.xpre.tn VSS nfet_03v3 ad=1.235p pd=5.27u as=1.235p ps=5.27u w=4.75u l=0.5u
X976 xl2.xpre.tp xl2.gp xl2.xpre.fa xl2.xpre.tp pfet_03v3 ad=1.248p pd=5.32u as=1.248p ps=5.32u w=4.8u l=0.4u
X977 xl0.xpre.tn xl0.gn xl0.ob VSS nfet_03v3 ad=1.235p pd=5.27u as=1.235p ps=5.27u w=4.75u l=0.5u
X978 xl1.oa vref xl1.xpre.tn VSS nfet_03v3 ad=1.235p pd=5.27u as=1.235p ps=5.27u w=4.75u l=0.5u
X979 xl1.xpre.tp vbp VDD VDD pfet_03v3 ad=1.3p pd=5.52u as=1.3p ps=5.52u w=5u l=1u
X980 xl1.xpre.fa xl1.gp xl1.xpre.tp xl1.xpre.tp pfet_03v3 ad=1.248p pd=5.32u as=1.248p ps=5.32u w=4.8u l=0.4u
X981 xl2.xpre.fa xl2.gp xl2.xpre.tp xl2.xpre.tp pfet_03v3 ad=1.248p pd=5.32u as=1.248p ps=5.32u w=4.8u l=0.4u
X982 VDD EN xl0.d2b VDD pfet_03v3 ad=0.52p pd=2.52u as=0.52p ps=2.52u w=2u l=0.5u
X983 vbp vbp VDD VDD pfet_03v3 ad=1.3p pd=5.52u as=1.3p ps=5.52u w=5u l=1u
X984 xl0.xpre.fb vbn VSS VSS nfet_03v3 ad=0.65p pd=3.02u as=0.65p ps=3.02u w=2.5u l=1u
X985 VDD VDD VDD VDD pfet_03v3 ad=0.65p pd=3.02u as=0 ps=0 w=2.5u l=0.28u
X986 xl2.xpre.tp vbp VDD VDD pfet_03v3 ad=1.3p pd=5.52u as=1.3p ps=5.52u w=5u l=1u
X987 xl2.ob xl2.gn xl2.xpre.tn VSS nfet_03v3 ad=1.235p pd=5.27u as=1.235p ps=5.27u w=4.75u l=0.5u
X988 xl0.xpre.tn vref xl0.ob VSS nfet_03v3 ad=1.235p pd=5.27u as=1.235p ps=5.27u w=4.75u l=0.5u
X989 xl0.xpre.tp vbp VDD VDD pfet_03v3 ad=1.3p pd=5.52u as=1.3p ps=5.52u w=5u l=1u
X990 xl0.xpre.tp vref xl0.xpre.fb xl0.xpre.tp pfet_03v3 ad=1.248p pd=5.32u as=1.248p ps=5.32u w=4.8u l=0.4u
X991 xl2.d2a xl2.d2a VDD VDD pfet_03v3 ad=0.52p pd=2.52u as=0.52p ps=2.52u w=2u l=0.28u
X992 xl0.xout.n3a VDD VDD VDD pfet_03v3 ad=0.52p pd=2.52u as=0.88p ps=4.88u w=2u l=0.28u
X993 VSS VSS xl2.xhyst.ts VSS nfet_03v3 ad=1.1p pd=5.88u as=0.65p ps=3.02u w=2.5u l=1u
X994 xl1.xpre.tp xl1.gp xl1.xpre.fa xl1.xpre.tp pfet_03v3 ad=1.248p pd=5.32u as=1.248p ps=5.32u w=4.8u l=0.4u
X995 xl2.ob vref xl2.xpre.tn VSS nfet_03v3 ad=1.235p pd=5.27u as=1.235p ps=5.27u w=4.75u l=0.5u
X996 xl0.xpre.fb vref xl0.xpre.tp xl0.xpre.tp pfet_03v3 ad=1.248p pd=5.32u as=1.248p ps=5.32u w=4.8u l=0.4u
X997 VSS vbn xl2.xpre.fa VSS nfet_03v3 ad=0.65p pd=3.02u as=0.65p ps=3.02u w=2.5u l=1u
X998 VSS vbn xl1.xpre.tn VSS nfet_03v3 ad=0.65p pd=3.02u as=0.65p ps=3.02u w=2.5u l=1u
X999 VDD VDD xl2.d2b VDD pfet_03v3 ad=0.88p pd=4.88u as=0.52p ps=2.52u w=2u l=0.28u
X1000 VDD EN xl1.d2a VDD pfet_03v3 ad=0.52p pd=2.52u as=0.52p ps=2.52u w=2u l=0.5u
X1001 xl0.xpre.tp vref xl0.xpre.fb xl0.xpre.tp pfet_03v3 ad=1.248p pd=5.32u as=1.248p ps=5.32u w=4.8u l=0.4u
X1002 xl1.xpre.tp xl1.gn xl1.xpre.fb xl1.xpre.tp pfet_03v3 ad=1.248p pd=5.32u as=1.248p ps=5.32u w=4.8u l=0.4u
X1003 xl1.xpre.tp xl1.gn xl1.xpre.fb xl1.xpre.tp pfet_03v3 ad=1.248p pd=5.32u as=1.248p ps=5.32u w=4.8u l=0.4u
X1004 vbn vbn VSS VSS nfet_03v3 ad=0.65p pd=3.02u as=0.65p ps=3.02u w=2.5u l=1u
X1005 xl2.xpre.tn xl2.gn xl2.ob VSS nfet_03v3 ad=1.235p pd=5.27u as=1.235p ps=5.27u w=4.75u l=0.5u
X1006 vbp vbp VDD VDD pfet_03v3 ad=1.3p pd=5.52u as=1.3p ps=5.52u w=5u l=1u
X1007 xl2.xpre.fa vref xl2.xpre.tp xl2.xpre.tp pfet_03v3 ad=1.248p pd=5.32u as=1.248p ps=5.32u w=4.8u l=0.4u
X1008 VSS vbn xl2.xpre.tn VSS nfet_03v3 ad=0.65p pd=3.02u as=0.65p ps=3.02u w=2.5u l=1u
X1009 xl1.xout.nm xl1.xout.d3 xl1.xout.nd VSS nfet_03v3 ad=0.52p pd=2.52u as=0.52p ps=2.52u w=2u l=0.28u
X1010 xl1.xpre.fa vbn VSS VSS nfet_03v3 ad=0.65p pd=3.02u as=0.65p ps=3.02u w=2.5u l=1u
X1011 RX1_O xl1.xout.i2 VSS VSS nfet_03v3 ad=1.04p pd=4.52u as=1.04p ps=4.52u w=4u l=0.28u
X1012 xl1.xpre.fb xl1.gn xl1.xpre.tp xl1.xpre.tp pfet_03v3 ad=1.248p pd=5.32u as=1.248p ps=5.32u w=4.8u l=0.4u
X1013 xl0.oa xl0.gp xl0.xpre.tn VSS nfet_03v3 ad=1.235p pd=5.27u as=1.235p ps=5.27u w=4.75u l=0.5u
X1014 VSS VSS xl1.d2a VSS nfet_03v3 ad=1.9228p pd=9.62u as=1.1362p ps=4.89u w=4.37u l=0.5u
X1015 VDD vbp xl2.xpre.tp VDD pfet_03v3 ad=1.3p pd=5.52u as=1.3p ps=5.52u w=5u l=1u
X1016 xl1.xhyst.sb xl1.ob xl1.d2b VSS nfet_03v3 ad=1.1362p pd=4.89u as=1.1362p ps=4.89u w=4.37u l=0.5u
X1017 VDD xbias.enb xbias.nrb VDD pfet_03v3 ad=1.3p pd=5.52u as=1.3p ps=5.52u w=5u l=0.5u
X1018 VDD xl2.d2b xl2.xout.d3 VDD pfet_03v3 ad=0.52p pd=2.52u as=0.52p ps=2.52u w=2u l=0.28u
X1019 xl0.xout.d3 xl0.d2b VDD VDD pfet_03v3 ad=0.52p pd=2.52u as=0.52p ps=2.52u w=2u l=0.28u
X1020 VDD vbp vbp VDD pfet_03v3 ad=1.3p pd=5.52u as=1.3p ps=5.52u w=5u l=1u
X1021 xl1.xpre.fb xl1.gn xl1.xpre.tp xl1.xpre.tp pfet_03v3 ad=1.248p pd=5.32u as=1.248p ps=5.32u w=4.8u l=0.4u
X1022 xl2.xpre.fb xl2.gn xl2.xpre.tp xl2.xpre.tp pfet_03v3 ad=1.248p pd=5.32u as=1.248p ps=5.32u w=4.8u l=0.4u
X1023 VSS vbn xl0.xpre.fb VSS nfet_03v3 ad=0.65p pd=3.02u as=0.65p ps=3.02u w=2.5u l=1u
X1024 VDD xl1.xout.i2 RX1_O VDD pfet_03v3 ad=1.3p pd=5.52u as=1.3p ps=5.52u w=5u l=0.28u
X1025 VDD vbp xl2.xpre.tp VDD pfet_03v3 ad=1.3p pd=5.52u as=1.3p ps=5.52u w=5u l=1u
X1026 xl2.xpre.tp vref xl2.xpre.fb xl2.xpre.tp pfet_03v3 ad=1.248p pd=5.32u as=1.248p ps=5.32u w=4.8u l=0.4u
X1027 VSS vbn xl1.xpre.fa VSS nfet_03v3 ad=0.65p pd=3.02u as=0.65p ps=3.02u w=2.5u l=1u
X1028 xl1.ob vb2 xl1.xpre.fb VSS nfet_03v3 ad=1.1752p pd=5.04u as=1.1752p ps=5.04u w=4.52u l=0.5u
X1029 VDD vbp xl0.xpre.tp VDD pfet_03v3 ad=1.3p pd=5.52u as=1.3p ps=5.52u w=5u l=1u
X1030 xl1.oa vref xl1.xpre.tn VSS nfet_03v3 ad=1.235p pd=5.27u as=1.235p ps=5.27u w=4.75u l=0.5u
X1031 xl1.xpre.tp xl1.gn xl1.xpre.fb xl1.xpre.tp pfet_03v3 ad=1.248p pd=5.32u as=1.248p ps=5.32u w=4.8u l=0.4u
X1032 xl1.ob vb2 xl1.xpre.fb VSS nfet_03v3 ad=1.1752p pd=5.04u as=1.1752p ps=5.04u w=4.52u l=0.5u
X1033 xl2.xpre.fb vbn VSS VSS nfet_03v3 ad=0.65p pd=3.02u as=0.65p ps=3.02u w=2.5u l=1u
X1034 xbias.rf_m1 VSS VSS ppolyf_u_1k r_width=2u r_length=23.07u
X1035 xl0.xpre.tp xl0.gp xl0.xpre.fa xl0.xpre.tp pfet_03v3 ad=1.248p pd=5.32u as=1.248p ps=5.32u w=4.8u l=0.4u
X1036 xl2.xpre.fb vref xl2.xpre.tp xl2.xpre.tp pfet_03v3 ad=1.248p pd=5.32u as=1.248p ps=5.32u w=4.8u l=0.4u
X1037 xl2.xpre.tn vbn VSS VSS nfet_03v3 ad=0.65p pd=3.02u as=0.65p ps=3.02u w=2.5u l=1u
X1038 xl2.xpre.tp vbp VDD VDD pfet_03v3 ad=1.3p pd=5.52u as=1.3p ps=5.52u w=5u l=1u
X1039 xbias.rdb_m2 xbias.rdb_m1 VSS ppolyf_u_1k r_width=2u r_length=19.26u
X1040 xl1.xpre.fa xl1.gp xl1.xpre.tp xl1.xpre.tp pfet_03v3 ad=1.248p pd=5.32u as=1.248p ps=5.32u w=4.8u l=0.4u
X1041 xl1.ob VSS VSS VSS nfet_03v3 ad=1.1752p pd=5.04u as=1.9888p ps=9.92u w=4.52u l=0.5u
X1042 xl2.xpre.tp vbp VDD VDD pfet_03v3 ad=1.3p pd=5.52u as=1.3p ps=5.52u w=5u l=1u
X1043 xl1.xpre.tp vref xl1.xpre.fa xl1.xpre.tp pfet_03v3 ad=1.248p pd=5.32u as=1.248p ps=5.32u w=4.8u l=0.4u
X1044 xl0.xpre.fb xl0.gn xl0.xpre.tp xl0.xpre.tp pfet_03v3 ad=1.248p pd=5.32u as=1.248p ps=5.32u w=4.8u l=0.4u
X1045 xl2.xpre.tp xl2.gp xl2.xpre.fa xl2.xpre.tp pfet_03v3 ad=1.248p pd=5.32u as=1.248p ps=5.32u w=4.8u l=0.4u
X1046 VDD VDD VDD VDD pfet_03v3 ad=0.962p pd=4.22u as=0 ps=0 w=3.7u l=0.28u
C0 vbn EN 0.42114f
C1 xl0.xout.i2 xl0.xout.i1 0.28557f
C2 vbn xbias.vf 1.54524f
C3 xl0.d2b xl0.d2a 2.76659f
C4 xl1.xout.i2 EN 0.31277f
C5 vbn xl0.gn 0.11482f
C6 EN xl1.d2a 0.17357f
C7 xl1.xpre.tn xl1.gp 1.20627f
C8 vbn xl0.xpre.fa 2.39287f
C9 xbias.enb xbias.nrb 0.83214f
C10 xbias.rb_m2 xbias.vf 0.08519f
C11 xl0.xhyst.ts xl0.xhyst.sa 0.03853f
C12 xl1.xout.nm xl1.xout.d3 0.01765f
C13 vbn xl1.oa 0.33374f
C14 vbn xl0.gp 0.14191f
C15 vref xl0.gn 2.33633f
C16 xl2.ob VDD 1.92789f
C17 xbias.nrb VDD 5.10108f
C18 vbn xl0.oa 0.33374f
C19 xl1.xout.nm xl1.xout.nd 0.2193f
C20 xl0.d2b xl0.rla_m1 0.00423f
C21 vref xl0.xpre.fa 2.64932f
C22 vbp xl1.xpre.tp 3.37779f
C23 xl1.xout.i2 xl1.xout.i1 0.28557f
C24 xl2.xpre.tn VDD 0.19528f
C25 xl1.xpre.tn xl1.gn 0.99696f
C26 vref xl1.oa 2.14744f
C27 xl1.gp VDD 4.5498f
C28 vref xl0.gp 1.91483f
C29 xl1.oa xl1.d2a 0.16422f
C30 vref xl0.oa 2.14744f
C31 RX0_O VDD 3.99882f
C32 xl1.xhyst.ts xl1.xhyst.sa 0.03853f
C33 xl2.d2b xl2.xhyst.sa 0.20995f
C34 xl0.rlb_m1 xl0.rla_m1 0.39394f
C35 xl2.xhyst.ts VDD 0.93712f
C36 xbias.nrb EN 0.24322f
C37 xbias.vf xbias.nrb 0.76263f
C38 xl1.xout.i2 RX1_O 0.50509f
C39 vb2 xl1.xpre.tp 0.05309f
C40 xl2.gp vbp 0.26446f
C41 xl1.gn VDD 4.52025f
C42 RX2_N VDD 2.56543f
C43 EN RX0_O 1.94682f
C44 xl0.xhyst.ts VDD 0.93712f
C45 xl1.ob vb2 0.57476f
C46 vbp xl2.gn 0.26446f
C47 xl2.d2b xl2.rla_m1 0.00423f
C48 vbp RX0_N 0.03712f
C49 xbias.rdb_m2 xbias.rdt_m2 0.37f
C50 xl0.d2b xl0.ob 0.16374f
C51 xl0.gn xl0.xpre.fb 2.59553f
C52 xl0.xhyst.sa VDD 0.00366f
C53 xl0.xpre.fa xl0.xpre.fb 0.80129f
C54 vb2 xl2.gp 0.05601f
C55 xl2.xout.i1 VDD 2.62232f
C56 xl2.gp xl2.xpre.tp 12.8757f
C57 vbp RX0_P 0.03875f
C58 xl1.oa xl1.gp 1.23135f
C59 xl1.xpre.fa xl1.xpre.tp 25.3704f
C60 xl0.gp xl0.xpre.fb 0.86843f
C61 xbias.rdt_m2 xbias.nmid 0.00432f
C62 vb2 xl2.gn 0.05558f
C63 xl2.xpre.tp xl2.gn 13.4594f
C64 xl1.ob xl1.xpre.fa 0
C65 xl1.xpre.tn VDD 0.19528f
C66 xl0.xhyst.ts xl0.gn 0.01921f
C67 xl2.ob xl2.xhyst.sb 0.20964f
C68 xl0.d2b xl0.xout.n3a 0.16863f
C69 xl2.xout.i1 EN 0.26447f
C70 xl0.xout.nd xl0.xout.nm 0.2193f
C71 xl1.oa xl1.gn 0.30476f
C72 xl2.d2a VDD 12.6668f
C73 xl0.xout.d3 xl0.d2a 2.37176f
C74 vbp xbias.nmid 0.03404f
C75 EN xl0.xout.nm 0.02238f
C76 xbias.enb VDD 6.1787f
C77 xl2.gp xl2.xpre.fa 2.44274f
C78 xl1.xpre.fb vb2 2.14447f
C79 xl1.xhyst.ts xl1.ob 0.21086f
C80 xl2.xhyst.ts xl2.xhyst.sb 0.06367f
C81 vb2 xl0.ob 0.57476f
C82 xl2.gn xl2.xpre.fa 0.67123f
C83 xl1.ob xl1.xhyst.sa 0.00738f
C84 xl2.d2a EN 0.17357f
C85 xl2.gp RX2_P 0.14621f
C86 vref xbias.rdt_m2 0.00234f
C87 xbias.enb EN 4.04436f
C88 vbn vbp 7.61409f
C89 xl0.oa xl0.xhyst.sa 0.14911f
C90 vb2 xbias.nmid 0.91956f
C91 xbias.enb xbias.vf 1.18587f
C92 RX1_P vbp 0.03967f
C93 xl0.xout.nd VDD 2.72485f
C94 xl2.xpre.fb vb2 2.14447f
C95 xbias.rdb_m3 xbias.rdt_m1 0.41833f
C96 xl2.xpre.fb xl2.xpre.tp 25.7437f
C97 EN VDD 63.4972f
C98 xbias.rdt_m3 xbias.rdt_m1 0.08167f
C99 xl1.xpre.fb xl1.xpre.fa 0.80129f
C100 vref vbp 0.0747f
C101 xbias.vf VDD 0.00294f
C102 xl1.oa xl1.xpre.tn 9.87797f
C103 xl1.d2b xl1.xhyst.sa 0.20995f
C104 xbias.rdb_m1 xbias.rdt_m3 0.22342f
C105 xl0.xhyst.sb xl0.ob 0.20964f
C106 vbn vb2 0.63813f
C107 EN xl0.xout.nd 0.90578f
C108 xl0.gn VDD 4.52025f
C109 xl2.xhyst.sa xl2.oa 0.14911f
C110 xbias.vf EN 0.02265f
C111 xl1.xout.i1 VDD 2.62232f
C112 xl2.xpre.fb xl2.xpre.fa 0.80129f
C113 xl1.oa VDD 1.56447f
C114 vref vb2 24.5935f
C115 xl0.gp VDD 4.5498f
C116 vref xl2.xpre.tp 14.925f
C117 xl0.oa VDD 1.56447f
C118 vb2 xl2.oa 0.57905f
C119 xl2.xout.d3 xl2.xout.nd 0.22426f
C120 xbias.nrb vbp 0.36246f
C121 xl1.xout.i1 EN 0.26447f
C122 RX1_O VDD 4.00061f
C123 vbn xl2.xpre.fa 2.39287f
C124 xl2.xout.i2 RX2_O 0.50509f
C125 xl0.xout.i2 RX0_O 0.50501f
C126 vbn xl1.xpre.fa 2.39287f
C127 xl2.ob xl2.xhyst.sa 0.00738f
C128 xl1.gp vbp 0.26446f
C129 xl0.xpre.fa xl0.gn 0.67123f
C130 xl0.rla_m1 xl0.d2a 0
C131 vref xl1.xpre.fa 2.64932f
C132 vref xl2.xpre.fa 2.64932f
C133 xl0.xout.d3 xl0.xout.n3a 0.80741f
C134 xl2.xout.nm xl2.xout.nd 0.2193f
C135 xl2.d2b xl2.xout.n3a 0.16863f
C136 EN RX1_O 0.00492f
C137 xl2.oa xl2.xpre.fa 2.90441f
C138 xl0.gn xl0.gp 2.07546f
C139 xl1.xhyst.ts vbn 0.99312f
C140 xl2.ob vb2 0.57476f
C141 xbias.nrb vb2 0.03936f
C142 xl0.oa xl0.gn 0.30476f
C143 xl2.xhyst.ts xl2.xhyst.sa 0.03853f
C144 xl0.d2b xl0.xhyst.sa 0.20995f
C145 xl0.xpre.fa xl0.gp 2.44274f
C146 vbp xl1.gn 0.26446f
C147 xl0.xpre.fa xl0.oa 2.90441f
C148 RX2_N vbp 0.03712f
C149 vb2 xl1.gp 0.05601f
C150 xl1.ob xl1.d2b 0.16374f
C151 vb2 xl0.xpre.fb 2.14447f
C152 vref xl1.xhyst.ts 0.07669f
C153 vref xl0.xpre.tp 14.925f
C154 xl0.oa xl0.gp 1.23135f
C155 xl0.rlb_m1 xl0.xhyst.sa 0
C156 xl1.xout.n3a xl1.d2b 0.16863f
C157 xl1.xout.i1 RX1_O 0
C158 xl1.xhyst.sa xl1.rla_m1 0.30587f
C159 xl1.d2a xl1.xhyst.sa 1.67001f
C160 xl1.xpre.fb xl1.xpre.tp 25.7437f
C161 xl2.gp xl2.gn 2.07546f
C162 vb2 xl1.gn 0.05558f
C163 xl1.xout.nm EN 0.02238f
C164 xl2.ob xl2.xpre.fa 0
C165 xl1.xpre.fb xl1.ob 2.81909f
C166 xl1.xout.n3a xl1.xout.d3 0.80741f
C167 RX1_N xl1.gn 0.14621f
C168 xl1.xpre.fa xl1.gp 2.44274f
C169 xl0.d2b VDD 11.7806f
C170 xl2.d2b xl2.xout.d3 0.34009f
C171 xl1.xout.d3 xl1.d2b 0.34009f
C172 xbias.rdt_m2 VDD 0.00209f
C173 xl0.xout.i2 VDD 4.2831f
C174 xbias.enb vbp 1.1468f
C175 xl2.d2a xl2.xhyst.sa 1.67001f
C176 xl1.xpre.fa xl1.gn 0.67123f
C177 xbias.rf_m1 xbias.rb_m3 0.04347f
C178 xl0.xout.n3a xl0.d2a 0.24692f
C179 xl0.xpre.fb xl0.xpre.tp 25.7437f
C180 xl2.xout.n3a xl2.xout.d3 0.80741f
C181 EN xl0.d2b 0.44208f
C182 vbp VDD 0.11404p
C183 xl0.xhyst.ts xl0.xhyst.sb 0.06367f
C184 xl1.xout.nd xl1.xout.d3 0.22426f
C185 xl2.xpre.fb xl2.gp 0.86843f
C186 xl2.xhyst.sa VDD 0.00366f
C187 xl0.xout.i2 EN 0.31277f
C188 vbn xl1.ob 0.19136f
C189 xl0.xpre.tn xl0.ob 9.55392f
C190 xl1.xhyst.ts xl1.gn 0.01921f
C191 xl2.d2a xl2.rla_m1 0
C192 xbias.enb vb2 2.12636f
C193 vref xl1.xpre.tp 14.925f
C194 xl2.rlb_m1 xl2.xhyst.sa 0
C195 xl1.rlb_m1 xl1.xhyst.sa 0
C196 xl0.xhyst.sb xl0.xhyst.sa 0.7765f
C197 xl2.xpre.fb xl2.gn 2.59553f
C198 vbp EN 0.30684f
C199 vref xl1.ob 2.70252f
C200 xbias.vf vbp 0.3587f
C201 vb2 VDD 6.61063f
C202 vbn xl2.gp 0.14191f
C203 xl2.xpre.tp VDD 11.3411f
C204 xbias.rdb_m2 xbias.nmid 0.04228f
C205 RX1_N VDD 2.56543f
C206 xl1.xout.n3a xl1.d2a 0.24692f
C207 vbp xl0.gn 0.26446f
C208 vbn xl2.gn 0.11482f
C209 xl2.rlb_m1 xl2.rla_m1 0.39394f
C210 xl2.xout.i1 xl2.xout.nd 0.21598f
C211 xl2.xout.i2 xl2.xout.i1 0.28557f
C212 vref xl2.gp 1.91483f
C213 xl0.xout.d3 xl0.xout.nm 0.01765f
C214 RX0_O xl0.xout.i1 0
C215 vb2 EN 2.2084f
C216 xl2.gp xl2.oa 1.23135f
C217 vbn xl0.xpre.tn 0.82513f
C218 xbias.enb xbias.rb_m1 0
C219 xl1.d2b xl1.rla_m1 0.00423f
C220 xbias.vf vb2 0.92899f
C221 vref xl2.gn 2.33633f
C222 vbp xl0.gp 0.26446f
C223 xl1.d2b xl1.d2a 2.76659f
C224 xl1.xhyst.ts xl1.xpre.tn 0
C225 xl2.gn xl2.oa 0.30476f
C226 xl2.ob xl2.d2b 0.16374f
C227 vbn xl1.xpre.fb 1.48704f
C228 vref xl0.xpre.tn 1.62411f
C229 vb2 xl0.gn 0.05558f
C230 xl1.gp xl1.xpre.tp 12.8757f
C231 vbn xl0.ob 0.19136f
C232 xl0.xpre.fa vb2 1.75715f
C233 xl1.xout.d3 xl1.d2a 2.37176f
C234 vref xbias.rdb_m2 0.09091f
C235 RX2_P VDD 2.27847f
C236 xl2.xout.d3 xl2.xout.nm 0.01765f
C237 vref xl1.xpre.fb 2.88984f
C238 xl1.ob xl1.gp 0.3633f
C239 xl1.oa vb2 0.57905f
C240 vb2 xl0.gp 0.05601f
C241 xl0.xout.d3 VDD 4.47773f
C242 vbn xbias.nmid 0.11617f
C243 xl1.xhyst.ts VDD 0.93712f
C244 xl0.xpre.tp VDD 11.3411f
C245 vb2 xl0.oa 0.57905f
C246 xl2.xout.nd VDD 2.72485f
C247 xl2.ob xl2.gp 0.3633f
C248 xl2.xout.i2 VDD 4.2831f
C249 xbias.rb_m1 EN 0.00476f
C250 vref xl0.ob 2.70252f
C251 xl2.xhyst.sa xl2.xhyst.sb 0.7765f
C252 xl1.xpre.tp xl1.gn 13.4594f
C253 vbn xl2.xpre.fb 1.48704f
C254 xl1.xhyst.sa VDD 0.00366f
C255 xl2.xpre.tn xl2.gp 1.20627f
C256 xl2.ob xl2.gn 1.03804f
C257 vref xbias.nmid 0
C258 xl1.ob xl1.gn 1.03804f
C259 xl0.xout.d3 xl0.xout.nd 0.22426f
C260 xl2.xpre.tn xl2.gn 0.99696f
C261 xl0.xout.d3 EN 0.46698f
C262 EN xl2.xout.nd 0.90578f
C263 vref xl2.xpre.fb 2.88984f
C264 xl2.xout.i2 EN 0.31277f
C265 xl0.xhyst.sa xl0.d2a 1.67001f
C266 xl1.oa xl1.xpre.fa 2.90441f
C267 xl2.xhyst.ts xl2.gn 0.01921f
C268 xl0.gn xl0.xpre.tp 13.4594f
C269 vref vbn 2.95645f
C270 xl0.xpre.fa xl0.xpre.tp 25.3704f
C271 RX2_N xl2.gn 0.14621f
C272 vbn xl2.oa 0.33374f
C273 xl1.xpre.fb xl1.gp 0.86843f
C274 xl1.xhyst.ts xl1.xhyst.sb 0.06367f
C275 vbn xbias.rb_m2 0.03954f
C276 VDD xl0.xout.i1 2.62232f
C277 xl0.gp xl0.xpre.tp 12.8757f
C278 xl0.xhyst.sa xl0.rla_m1 0.30587f
C279 xl1.xhyst.sb xl1.xhyst.sa 0.7765f
C280 xl0.xpre.fb xl0.ob 2.81909f
C281 xl1.oa xl1.xhyst.sa 0.14911f
C282 xl1.ob xl1.xpre.tn 9.55392f
C283 xl1.d2a xl1.rla_m1 0
C284 vref xl2.oa 2.14744f
C285 xl0.xhyst.ts xl0.xpre.tn 0
C286 xl2.ob xl2.xpre.fb 2.81909f
C287 xl2.d2a xl2.d2b 2.76659f
C288 xl0.xout.nd xl0.xout.i1 0.21598f
C289 xl1.xpre.fb xl1.gn 2.59553f
C290 EN xl0.xout.i1 0.26447f
C291 xl0.d2a VDD 12.6668f
C292 xl1.xpre.tp VDD 11.3411f
C293 xl2.d2a xl2.xout.n3a 0.24692f
C294 vbn xl2.ob 0.19136f
C295 xl2.d2b VDD 11.7806f
C296 xl0.xhyst.ts xl0.ob 0.21086f
C297 vbn xbias.nrb 0.04436f
C298 xl1.ob VDD 1.92789f
C299 vbn xl2.xpre.tn 0.82513f
C300 vbn xl1.gp 0.14191f
C301 vbn xl0.xpre.fb 1.48704f
C302 xl1.xout.n3a VDD 4.08941f
C303 EN xl0.d2a 0.17357f
C304 RX1_P xl1.gp 0.14621f
C305 vref xl2.ob 2.70252f
C306 xl0.xhyst.sa xl0.ob 0.00738f
C307 xl2.xout.n3a VDD 4.08941f
C308 xl2.gp VDD 4.5498f
C309 xl2.ob xl2.oa 0.59251f
C310 xl2.d2b EN 0.44208f
C311 vbn xl2.xhyst.ts 0.99312f
C312 vref xl2.xpre.tn 1.62411f
C313 xbias.rb_m2 xbias.nrb 0.03837f
C314 vref xl1.gp 1.91483f
C315 xl2.xpre.tn xl2.oa 9.87797f
C316 vref xl0.xpre.fb 2.88984f
C317 xl1.d2b VDD 11.7806f
C318 vb2 vbp 5.46578f
C319 xl2.gn VDD 4.52025f
C320 vbn xl1.gn 0.11482f
C321 vbp xl2.xpre.tp 3.37779f
C322 xl1.xout.n3a EN 0.00585f
C323 RX0_N VDD 2.56543f
C324 vref xl2.xhyst.ts 0.07669f
C325 xl2.xout.i1 RX2_O 0
C326 vbn xl0.xhyst.ts 0.99312f
C327 vbp RX1_N 0.03712f
C328 EN xl2.xout.n3a 0.00585f
C329 xl0.xhyst.sb xl0.d2b 0.68313f
C330 xl0.xpre.tn VDD 0.19528f
C331 xbias.enb xbias.rdt_m1 0.0052f
C332 xl2.xhyst.sa xl2.rla_m1 0.30587f
C333 xl1.rlb_m1 xl1.rla_m1 0.39394f
C334 xl1.xout.d3 VDD 4.47773f
C335 vref xl1.gn 2.33633f
C336 xl0.oa xl0.d2a 0.16422f
C337 xl1.d2b EN 0.44208f
C338 xl1.ob xl1.xhyst.sb 0.20964f
C339 RX0_P VDD 2.27023f
C340 xbias.rdb_m2 VDD 0.00594f
C341 xl2.d2a xl2.xout.d3 2.37176f
C342 xl1.xout.nd VDD 2.72485f
C343 vref xl0.xhyst.ts 0.07669f
C344 xl1.ob xl1.oa 0.59251f
C345 xl0.xout.d3 xl0.d2b 0.34009f
C346 vb2 xl2.xpre.tp 0.05309f
C347 xl2.ob xl2.xpre.tn 9.55392f
C348 xl0.ob VDD 1.92789f
C349 xbias.enb xbias.nmid 0.71708f
C350 xbias.rb_m1 vbp 0.0038f
C351 xl1.xout.d3 EN 0.46698f
C352 xl2.xout.d3 VDD 4.47773f
C353 xl0.gn RX0_N 0.14621f
C354 xbias.nmid VDD 0.89656f
C355 xl1.xout.nd EN 0.90578f
C356 vbn xl1.xpre.tn 0.82513f
C357 xl1.d2b xl1.xhyst.sb 0.68313f
C358 xl2.ob xl2.xhyst.ts 0.21086f
C359 xl2.d2b xl2.xhyst.sb 0.68313f
C360 RX2_O VDD 4.00067f
C361 vbp RX2_P 0.03967f
C362 xl0.gn xl0.xpre.tn 0.99696f
C363 xl2.xhyst.ts xl2.xpre.tn 0
C364 vbp xl0.xpre.tp 3.37779f
C365 vbn xbias.enb 0.2848f
C366 xl1.xpre.fa vb2 1.75715f
C367 vb2 xl2.xpre.fa 1.75715f
C368 vref xl1.xpre.tn 1.62411f
C369 xl2.xpre.tp xl2.xpre.fa 25.3704f
C370 EN xl2.xout.d3 0.46698f
C371 xl0.xout.n3a VDD 4.08941f
C372 xl0.gp xl0.xpre.tn 1.20627f
C373 xbias.nmid EN 0.59891f
C374 xl1.gp xl1.gn 2.07546f
C375 xl0.oa xl0.xpre.tn 9.87797f
C376 EN RX2_O 0.005f
C377 vbn VDD 3.79959f
C378 xl0.gn xl0.ob 1.03804f
C379 xl1.xout.i1 xl1.xout.nd 0.21598f
C380 xl2.d2a xl2.oa 0.16422f
C381 vref xbias.enb 0.14548f
C382 RX1_P VDD 2.27847f
C383 RX0_P xl0.gp 0.14621f
C384 xl0.xpre.fa xl0.ob 0
C385 xbias.rb_m3 xbias.rb_m1 0.06955f
C386 vb2 xl0.xpre.tp 0.05309f
C387 xl0.gp xl0.ob 0.3633f
C388 xl1.xout.i2 VDD 4.2831f
C389 EN xl0.xout.n3a 0.00585f
C390 vref VDD 2.13357f
C391 xl0.oa xl0.ob 0.59251f
C392 xl1.d2a VDD 12.6668f
C393 EN xl2.xout.nm 0.02238f
C394 xl2.oa VDD 1.56447f
C395 RX2_O VSS 18.8961f
C396 RX1_O VSS 11.8271f
C397 RX0_O VSS 11.1616f
C398 EN VSS 37.6717f
C399 RX2_N VSS 3.34389f
C400 RX2_P VSS 3.63059f
C401 RX1_N VSS 3.34389f
C402 RX1_P VSS 3.63059f
C403 RX0_N VSS 3.34389f
C404 RX0_P VSS 3.63059f
C405 VDD VSS 0.73438p
C406 xbias.rb_m3 VSS 1.32997f
C407 xbias.rb_m2 VSS 1.18198f
C408 xbias.rb_m1 VSS 1.29868f
C409 xbias.rf_m1 VSS 1.40226f
C410 xbias.vf VSS 3.02831f
C411 xbias.nrb VSS 1.98311f
C412 xl2.xout.i2 VSS 4.2469f
C413 xl2.xout.i1 VSS 3.72118f
C414 xl2.xout.nm VSS 0.31567f
C415 xl2.xout.nd VSS 3.35161f
C416 xl1.xout.i2 VSS 4.2469f
C417 xl1.xout.i1 VSS 3.72118f
C418 xl1.xout.nm VSS 0.31567f
C419 xl1.xout.nd VSS 3.35161f
C420 xl0.xout.i2 VSS 4.2469f
C421 xl0.xout.i1 VSS 3.72118f
C422 xl0.xout.nm VSS 0.31567f
C423 xl0.xout.nd VSS 3.35161f
C424 xl2.xout.d3 VSS 4.9259f
C425 xl2.xout.n3a VSS 3.56595f
C426 xl1.xout.d3 VSS 4.9259f
C427 xl1.xout.n3a VSS 3.56595f
C428 xl0.xout.d3 VSS 4.9259f
C429 xl0.xout.n3a VSS 3.56595f
C430 xbias.rdb_m1 VSS 1.12023f
C431 xbias.rdt_m3 VSS 1.81265f
C432 xbias.rdb_m2 VSS 1.89154f
C433 xbias.rdb_m3 VSS 1.13703f
C434 xbias.rdt_m1 VSS 1.66241f
C435 xbias.rdt_m2 VSS 1.18196f
C436 xbias.nmid VSS 4.29306f
C437 xl2.xhyst.sb VSS 2.33901f
C438 xl2.d2b VSS 5.02018f
C439 xl2.rlb_m1 VSS 1.11225f
C440 xl2.rla_m1 VSS 1.48222f
C441 xl2.xhyst.sa VSS 4.30772f
C442 xl2.d2a VSS 3.35523f
C443 xl1.xhyst.sb VSS 2.33901f
C444 xl1.d2b VSS 5.02018f
C445 xl1.rlb_m1 VSS 1.11225f
C446 xl1.rla_m1 VSS 1.48222f
C447 xl1.xhyst.sa VSS 4.30772f
C448 xl1.d2a VSS 3.35523f
C449 xl0.xhyst.sb VSS 2.33901f
C450 xl0.d2b VSS 5.02018f
C451 xl0.rlb_m1 VSS 1.11225f
C452 xl0.rla_m1 VSS 1.48222f
C453 xl0.xhyst.sa VSS 4.30772f
C454 xl0.d2a VSS 3.35523f
C455 xl2.xhyst.ts VSS 7.37304f
C456 xl2.xpre.tn VSS 4.38031f
C457 xl1.xhyst.ts VSS 7.37304f
C458 xl1.xpre.tn VSS 4.38031f
C459 xl0.xhyst.ts VSS 7.37304f
C460 xl0.xpre.tn VSS 4.38031f
C461 xbias.enb VSS 8.34564f
C462 xl2.ob VSS 6.80006f
C463 xl2.oa VSS 7.22376f
C464 xl1.ob VSS 6.80006f
C465 xl1.oa VSS 7.22376f
C466 xl0.ob VSS 6.80006f
C467 vbn VSS 0.1762p
C468 xl0.oa VSS 7.22376f
C469 xl2.xpre.fa VSS 9.0556f
C470 xl2.xpre.fb VSS 7.93573f
C471 xl1.xpre.fa VSS 9.0556f
C472 xl1.xpre.fb VSS 7.93573f
C473 xl0.xpre.fa VSS 9.0556f
C474 xl0.xpre.fb VSS 7.93573f
C475 vref VSS 59.6279f
C476 vb2 VSS 40.2263f
C477 xl2.gn VSS 13.8994f
C478 xl2.gp VSS 14.1023f
C479 xl1.gn VSS 13.8994f
C480 xl1.gp VSS 14.1023f
C481 xl0.gn VSS 13.8994f
C482 vbp VSS 20.6887f
C483 xl0.gp VSS 14.1023f
C484 xl2.xpre.tp VSS 0.1029p
C485 xl1.xpre.tp VSS 0.1029p
C486 xl0.xpre.tp VSS 0.1029p
.ends lvds_rx_x3
