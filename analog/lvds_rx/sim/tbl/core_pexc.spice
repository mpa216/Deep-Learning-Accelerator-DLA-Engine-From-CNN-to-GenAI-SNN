* core_pexc.spice -- GENERATED by sim/tbl/make_cores.py (T11); do not edit.
* = netlist/lvds_rx_core.spice (sha256 ca22c0077896c1c83352aac4db29565814a5e849bb95e50bf86d1c9090600d5e) without lvds_rx_x3
*   + results/layout/lvds_rx_x3.pex_c.spice (sha256 264fe7e552e1f6c838ac346c1953505a74638d58a2c353d2501add261fdf6a23) with its nodes renamed to the pre-layout paths.
* lvds_rx_core.spice -- LVDS receiver macro lvds_rx_x3 (3 lanes + shared bias), gf180mcuD 3.3 V devices.
* GENERATED by netlist/gen_core.py from netlist/lvds_circuit.py -- do not edit by hand.
* Every W/L/nf and poly size comes from the parameters of sizing/sizes.spice: the deck must  .include  sizes.spice BEFORE this file
* and the PDK sections (header of sim/harness).  Matched devices are one device with nf fingers (never m).
* Build flags (parameters of sizes.spice, redefine AFTER the include to switch): flag_nmos_pair flag_dump_devices (implemented);
*   flag_extra_gain_stage flag_bias_constgm flag_failsafe flag_on_die_term (NOT implemented in v0: setting one aborts the parse).
* Instance names are hierarchical, e.g. xl0.xpre.xmp1a; the BSIM device inside is  @m.<path>.m0[...] .

.subckt lvds_bias VDD VSS EN VBN VBP VB2 VREF
Xmen_p enb EN VDD VDD pfet_03v3 L={l_men_p} W={w_men_p} nf={nf_men_p} ad='int((nf+1)/2) * W/nf * 0.18u' as='int((nf+2)/2) * W/nf * 0.18u' pd='2*int((nf+1)/2) * (W/nf + 0.18u)' ps='2*int((nf+2)/2) * (W/nf + 0.18u)' nrd='0.18u / W' nrs='0.18u / W' sa=0 sb=0 sd=0
Xmen_n enb EN VSS VSS nfet_03v3 L={l_men_n} W={w_men_n} nf={nf_men_n} ad='int((nf+1)/2) * W/nf * 0.18u' as='int((nf+2)/2) * W/nf * 0.18u' pd='2*int((nf+1)/2) * (W/nf + 0.18u)' ps='2*int((nf+2)/2) * (W/nf + 0.18u)' nrd='0.18u / W' nrs='0.18u / W' sa=0 sb=0 sd=0
Xmsw nrb enb VDD VDD pfet_03v3 L={l_msw} W={w_msw} nf={nf_msw} ad='int((nf+1)/2) * W/nf * 0.18u' as='int((nf+2)/2) * W/nf * 0.18u' pd='2*int((nf+1)/2) * (W/nf + 0.18u)' ps='2*int((nf+2)/2) * (W/nf + 0.18u)' nrd='0.18u / W' nrs='0.18u / W' sa=0 sb=0 sd=0
Xrrb nrb VBN VSS ppolyf_u_1k r_width={rw_rb} r_length={rl_rb}
Xmbn VBN VBN VSS VSS nfet_03v3 L={l_mbn} W={w_mbn} nf={nf_mbn} ad='int((nf+1)/2) * W/nf * 0.18u' as='int((nf+2)/2) * W/nf * 0.18u' pd='2*int((nf+1)/2) * (W/nf + 0.18u)' ps='2*int((nf+2)/2) * (W/nf + 0.18u)' nrd='0.18u / W' nrs='0.18u / W' sa=0 sb=0 sd=0
Xmpd_n VBN enb VSS VSS nfet_03v3 L={l_mpd_n} W={w_mpd_n} nf={nf_mpd_n} ad='int((nf+1)/2) * W/nf * 0.18u' as='int((nf+2)/2) * W/nf * 0.18u' pd='2*int((nf+1)/2) * (W/nf + 0.18u)' ps='2*int((nf+2)/2) * (W/nf + 0.18u)' nrd='0.18u / W' nrs='0.18u / W' sa=0 sb=0 sd=0
Xmbs VBP VBN VSS VSS nfet_03v3 L={l_mbs} W={w_mbs} nf={nf_mbs} ad='int((nf+1)/2) * W/nf * 0.18u' as='int((nf+2)/2) * W/nf * 0.18u' pd='2*int((nf+1)/2) * (W/nf + 0.18u)' ps='2*int((nf+2)/2) * (W/nf + 0.18u)' nrd='0.18u / W' nrs='0.18u / W' sa=0 sb=0 sd=0
Xmbp VBP VBP VDD VDD pfet_03v3 L={l_mbp} W={w_mbp} nf={nf_mbp} ad='int((nf+1)/2) * W/nf * 0.18u' as='int((nf+2)/2) * W/nf * 0.18u' pd='2*int((nf+1)/2) * (W/nf + 0.18u)' ps='2*int((nf+2)/2) * (W/nf + 0.18u)' nrd='0.18u / W' nrs='0.18u / W' sa=0 sb=0 sd=0
Xmpu_p VBP EN VDD VDD pfet_03v3 L={l_mpu_p} W={w_mpu_p} nf={nf_mpu_p} ad='int((nf+1)/2) * W/nf * 0.18u' as='int((nf+2)/2) * W/nf * 0.18u' pd='2*int((nf+1)/2) * (W/nf + 0.18u)' ps='2*int((nf+2)/2) * (W/nf + 0.18u)' nrd='0.18u / W' nrs='0.18u / W' sa=0 sb=0 sd=0
Xmb2p VB2 VBP VDD VDD pfet_03v3 L={l_mb2p} W={w_mb2p} nf={nf_mb2p} ad='int((nf+1)/2) * W/nf * 0.18u' as='int((nf+2)/2) * W/nf * 0.18u' pd='2*int((nf+1)/2) * (W/nf + 0.18u)' ps='2*int((nf+2)/2) * (W/nf + 0.18u)' nrd='0.18u / W' nrs='0.18u / W' sa=0 sb=0 sd=0
Xmb2 VB2 VB2 vf VSS nfet_03v3 L={l_mb2} W={w_mb2} nf={nf_mb2} ad='int((nf+1)/2) * W/nf * 0.18u' as='int((nf+2)/2) * W/nf * 0.18u' pd='2*int((nf+1)/2) * (W/nf + 0.18u)' ps='2*int((nf+2)/2) * (W/nf + 0.18u)' nrd='0.18u / W' nrs='0.18u / W' sa=0 sb=0 sd=0
Xrrf vf VSS VSS ppolyf_u_1k r_width={rw_rf} r_length={rl_rf}
Xmpd_2 VB2 enb VSS VSS nfet_03v3 L={l_mpd_2} W={w_mpd_2} nf={nf_mpd_2} ad='int((nf+1)/2) * W/nf * 0.18u' as='int((nf+2)/2) * W/nf * 0.18u' pd='2*int((nf+1)/2) * (W/nf + 0.18u)' ps='2*int((nf+2)/2) * (W/nf + 0.18u)' nrd='0.18u / W' nrs='0.18u / W' sa=0 sb=0 sd=0
Xrrdt VDD VREF VSS ppolyf_u_1k r_width={rw_rdt} r_length={rl_rdt}
Xrrdb VREF nmid VSS ppolyf_u_1k r_width={rw_rdb} r_length={rl_rdb}
Xmvs nmid EN VSS VSS nfet_03v3 L={l_mvs} W={w_mvs} nf={nf_mvs} ad='int((nf+1)/2) * W/nf * 0.18u' as='int((nf+2)/2) * W/nf * 0.18u' pd='2*int((nf+1)/2) * (W/nf + 0.18u)' ps='2*int((nf+2)/2) * (W/nf + 0.18u)' nrd='0.18u / W' nrs='0.18u / W' sa=0 sb=0 sd=0
Xcvref VREF VSS cap_nmos_03v3 c_length={cap_vref_l} c_width={cap_vref_w}
.ends lvds_bias

.subckt lvds_esd2 A B VDD VSS
Xresd A B VDD ppolyf_u r_width={rw_esd} r_length={rl_esd}
Ddesd_h B VDD diode_pd2nw_03v3 area={dw_esd*dl_esd} pj={2*(dw_esd+dl_esd)}
Ddesd_l VSS B diode_nd2ps_03v3 area={dw_esd*dl_esd} pj={2*(dw_esd+dl_esd)}
.ends lvds_esd2

.subckt lvds_pre VDD VSS INP INN VBN VBP VB2 VREF OA OB
Xrla VDD OA VSS ppolyf_u_1k r_width={rw_rl} r_length={rl_rl}
Xrlb VDD OB VSS ppolyf_u_1k r_width={rw_rl} r_length={rl_rl}
Xmpt tp VBP VDD VDD pfet_03v3 L={l_mpt} W={w_mpt} nf={nf_mpt} ad='int((nf+1)/2) * W/nf * 0.18u' as='int((nf+2)/2) * W/nf * 0.18u' pd='2*int((nf+1)/2) * (W/nf + 0.18u)' ps='2*int((nf+2)/2) * (W/nf + 0.18u)' nrd='0.18u / W' nrs='0.18u / W' sa=0 sb=0 sd=0
Xmp1a fa INP tp tp pfet_03v3 L={l_mp1} W={w_mp1} nf={nf_mp1} ad='int((nf+1)/2) * W/nf * 0.18u' as='int((nf+2)/2) * W/nf * 0.18u' pd='2*int((nf+1)/2) * (W/nf + 0.18u)' ps='2*int((nf+2)/2) * (W/nf + 0.18u)' nrd='0.18u / W' nrs='0.18u / W' sa=0 sb=0 sd=0
Xmp1b fb INN tp tp pfet_03v3 L={l_mp1} W={w_mp1} nf={nf_mp1} ad='int((nf+1)/2) * W/nf * 0.18u' as='int((nf+2)/2) * W/nf * 0.18u' pd='2*int((nf+1)/2) * (W/nf + 0.18u)' ps='2*int((nf+2)/2) * (W/nf + 0.18u)' nrd='0.18u / W' nrs='0.18u / W' sa=0 sb=0 sd=0
.if ((flag_dump_devices == 1))
Xmpda fa VREF tp tp pfet_03v3 L={l_mpd} W={w_mpd} nf={nf_mpd} ad='int((nf+1)/2) * W/nf * 0.18u' as='int((nf+2)/2) * W/nf * 0.18u' pd='2*int((nf+1)/2) * (W/nf + 0.18u)' ps='2*int((nf+2)/2) * (W/nf + 0.18u)' nrd='0.18u / W' nrs='0.18u / W' sa=0 sb=0 sd=0
Xmpdb fb VREF tp tp pfet_03v3 L={l_mpd} W={w_mpd} nf={nf_mpd} ad='int((nf+1)/2) * W/nf * 0.18u' as='int((nf+2)/2) * W/nf * 0.18u' pd='2*int((nf+1)/2) * (W/nf + 0.18u)' ps='2*int((nf+2)/2) * (W/nf + 0.18u)' nrd='0.18u / W' nrs='0.18u / W' sa=0 sb=0 sd=0
.endif
.if ((flag_nmos_pair == 1))
Xm3a fa VBN VSS VSS nfet_03v3 L={l_m3} W={w_m3} nf={nf_m3} ad='int((nf+1)/2) * W/nf * 0.18u' as='int((nf+2)/2) * W/nf * 0.18u' pd='2*int((nf+1)/2) * (W/nf + 0.18u)' ps='2*int((nf+2)/2) * (W/nf + 0.18u)' nrd='0.18u / W' nrs='0.18u / W' sa=0 sb=0 sd=0
Xm3b fb VBN VSS VSS nfet_03v3 L={l_m3} W={w_m3} nf={nf_m3} ad='int((nf+1)/2) * W/nf * 0.18u' as='int((nf+2)/2) * W/nf * 0.18u' pd='2*int((nf+1)/2) * (W/nf + 0.18u)' ps='2*int((nf+2)/2) * (W/nf + 0.18u)' nrd='0.18u / W' nrs='0.18u / W' sa=0 sb=0 sd=0
.endif
.if ((flag_nmos_pair != 1))
Xm3a fa VBN VSS VSS nfet_03v3 L={l_m3a} W={w_m3a} nf={nf_m3a} ad='int((nf+1)/2) * W/nf * 0.18u' as='int((nf+2)/2) * W/nf * 0.18u' pd='2*int((nf+1)/2) * (W/nf + 0.18u)' ps='2*int((nf+2)/2) * (W/nf + 0.18u)' nrd='0.18u / W' nrs='0.18u / W' sa=0 sb=0 sd=0
Xm3b fb VBN VSS VSS nfet_03v3 L={l_m3a} W={w_m3a} nf={nf_m3a} ad='int((nf+1)/2) * W/nf * 0.18u' as='int((nf+2)/2) * W/nf * 0.18u' pd='2*int((nf+1)/2) * (W/nf + 0.18u)' ps='2*int((nf+2)/2) * (W/nf + 0.18u)' nrd='0.18u / W' nrs='0.18u / W' sa=0 sb=0 sd=0
.endif
Xm5a OA VB2 fa VSS nfet_03v3 L={l_m5} W={w_m5} nf={nf_m5} ad='int((nf+1)/2) * W/nf * 0.18u' as='int((nf+2)/2) * W/nf * 0.18u' pd='2*int((nf+1)/2) * (W/nf + 0.18u)' ps='2*int((nf+2)/2) * (W/nf + 0.18u)' nrd='0.18u / W' nrs='0.18u / W' sa=0 sb=0 sd=0
Xm5b OB VB2 fb VSS nfet_03v3 L={l_m5} W={w_m5} nf={nf_m5} ad='int((nf+1)/2) * W/nf * 0.18u' as='int((nf+2)/2) * W/nf * 0.18u' pd='2*int((nf+1)/2) * (W/nf + 0.18u)' ps='2*int((nf+2)/2) * (W/nf + 0.18u)' nrd='0.18u / W' nrs='0.18u / W' sa=0 sb=0 sd=0
.if ((flag_nmos_pair == 1))
Xmnt tn VBN VSS VSS nfet_03v3 L={l_mnt} W={w_mnt} nf={nf_mnt} ad='int((nf+1)/2) * W/nf * 0.18u' as='int((nf+2)/2) * W/nf * 0.18u' pd='2*int((nf+1)/2) * (W/nf + 0.18u)' ps='2*int((nf+2)/2) * (W/nf + 0.18u)' nrd='0.18u / W' nrs='0.18u / W' sa=0 sb=0 sd=0
Xmn1a OA INP tn VSS nfet_03v3 L={l_mn1} W={w_mn1} nf={nf_mn1} ad='int((nf+1)/2) * W/nf * 0.18u' as='int((nf+2)/2) * W/nf * 0.18u' pd='2*int((nf+1)/2) * (W/nf + 0.18u)' ps='2*int((nf+2)/2) * (W/nf + 0.18u)' nrd='0.18u / W' nrs='0.18u / W' sa=0 sb=0 sd=0
Xmn1b OB INN tn VSS nfet_03v3 L={l_mn1} W={w_mn1} nf={nf_mn1} ad='int((nf+1)/2) * W/nf * 0.18u' as='int((nf+2)/2) * W/nf * 0.18u' pd='2*int((nf+1)/2) * (W/nf + 0.18u)' ps='2*int((nf+2)/2) * (W/nf + 0.18u)' nrd='0.18u / W' nrs='0.18u / W' sa=0 sb=0 sd=0
.endif
.if ((flag_nmos_pair == 1) && (flag_dump_devices == 1))
Xmnda OA VREF tn VSS nfet_03v3 L={l_mnd} W={w_mnd} nf={nf_mnd} ad='int((nf+1)/2) * W/nf * 0.18u' as='int((nf+2)/2) * W/nf * 0.18u' pd='2*int((nf+1)/2) * (W/nf + 0.18u)' ps='2*int((nf+2)/2) * (W/nf + 0.18u)' nrd='0.18u / W' nrs='0.18u / W' sa=0 sb=0 sd=0
Xmndb OB VREF tn VSS nfet_03v3 L={l_mnd} W={w_mnd} nf={nf_mnd} ad='int((nf+1)/2) * W/nf * 0.18u' as='int((nf+2)/2) * W/nf * 0.18u' pd='2*int((nf+1)/2) * (W/nf + 0.18u)' ps='2*int((nf+2)/2) * (W/nf + 0.18u)' nrd='0.18u / W' nrs='0.18u / W' sa=0 sb=0 sd=0
.endif
.ends lvds_pre

.subckt lvds_hyst VDD VSS OA OB VBN EN D2A D2B
Xmt2 ts VBN VSS VSS nfet_03v3 L={l_mt2} W={w_mt2} nf={nf_mt2} ad='int((nf+1)/2) * W/nf * 0.18u' as='int((nf+2)/2) * W/nf * 0.18u' pd='2*int((nf+1)/2) * (W/nf + 0.18u)' ps='2*int((nf+2)/2) * (W/nf + 0.18u)' nrd='0.18u / W' nrs='0.18u / W' sa=0 sb=0 sd=0
Xms1 D2A OA sa VSS nfet_03v3 L={l_ms} W={w_ms} nf={nf_ms} ad='int((nf+1)/2) * W/nf * 0.18u' as='int((nf+2)/2) * W/nf * 0.18u' pd='2*int((nf+1)/2) * (W/nf + 0.18u)' ps='2*int((nf+2)/2) * (W/nf + 0.18u)' nrd='0.18u / W' nrs='0.18u / W' sa=0 sb=0 sd=0
Xms2 D2B OB sb VSS nfet_03v3 L={l_ms} W={w_ms} nf={nf_ms} ad='int((nf+1)/2) * W/nf * 0.18u' as='int((nf+2)/2) * W/nf * 0.18u' pd='2*int((nf+1)/2) * (W/nf + 0.18u)' ps='2*int((nf+2)/2) * (W/nf + 0.18u)' nrd='0.18u / W' nrs='0.18u / W' sa=0 sb=0 sd=0
Xrs1 sa ts VSS ppolyf_u_1k r_width={rw_rs} r_length={rl_rs}
Xrs2 sb ts VSS ppolyf_u_1k r_width={rw_rs} r_length={rl_rs}
Xmld1 D2A D2A VDD VDD pfet_03v3 L={l_mld} W={w_mld} nf={nf_mld} ad='int((nf+1)/2) * W/nf * 0.18u' as='int((nf+2)/2) * W/nf * 0.18u' pd='2*int((nf+1)/2) * (W/nf + 0.18u)' ps='2*int((nf+2)/2) * (W/nf + 0.18u)' nrd='0.18u / W' nrs='0.18u / W' sa=0 sb=0 sd=0
Xmld2 D2B D2B VDD VDD pfet_03v3 L={l_mld} W={w_mld} nf={nf_mld} ad='int((nf+1)/2) * W/nf * 0.18u' as='int((nf+2)/2) * W/nf * 0.18u' pd='2*int((nf+1)/2) * (W/nf + 0.18u)' ps='2*int((nf+2)/2) * (W/nf + 0.18u)' nrd='0.18u / W' nrs='0.18u / W' sa=0 sb=0 sd=0
Xmlc1 D2A D2B VDD VDD pfet_03v3 L={l_mlc} W={w_mlc} nf={nf_mlc} ad='int((nf+1)/2) * W/nf * 0.18u' as='int((nf+2)/2) * W/nf * 0.18u' pd='2*int((nf+1)/2) * (W/nf + 0.18u)' ps='2*int((nf+2)/2) * (W/nf + 0.18u)' nrd='0.18u / W' nrs='0.18u / W' sa=0 sb=0 sd=0
Xmlc2 D2B D2A VDD VDD pfet_03v3 L={l_mlc} W={w_mlc} nf={nf_mlc} ad='int((nf+1)/2) * W/nf * 0.18u' as='int((nf+2)/2) * W/nf * 0.18u' pd='2*int((nf+1)/2) * (W/nf + 0.18u)' ps='2*int((nf+2)/2) * (W/nf + 0.18u)' nrd='0.18u / W' nrs='0.18u / W' sa=0 sb=0 sd=0
Xmpu1 D2A EN VDD VDD pfet_03v3 L={l_mpu2} W={w_mpu2} nf={nf_mpu2} ad='int((nf+1)/2) * W/nf * 0.18u' as='int((nf+2)/2) * W/nf * 0.18u' pd='2*int((nf+1)/2) * (W/nf + 0.18u)' ps='2*int((nf+2)/2) * (W/nf + 0.18u)' nrd='0.18u / W' nrs='0.18u / W' sa=0 sb=0 sd=0
Xmpu2 D2B EN VDD VDD pfet_03v3 L={l_mpu2} W={w_mpu2} nf={nf_mpu2} ad='int((nf+1)/2) * W/nf * 0.18u' as='int((nf+2)/2) * W/nf * 0.18u' pd='2*int((nf+1)/2) * (W/nf + 0.18u)' ps='2*int((nf+2)/2) * (W/nf + 0.18u)' nrd='0.18u / W' nrs='0.18u / W' sa=0 sb=0 sd=0
.ends lvds_hyst

.subckt lvds_out VDD VSS D2A D2B EN OUT
Xmp3a n3a D2A VDD VDD pfet_03v3 L={l_mp3} W={w_mp3} nf={nf_mp3} ad='int((nf+1)/2) * W/nf * 0.18u' as='int((nf+2)/2) * W/nf * 0.18u' pd='2*int((nf+1)/2) * (W/nf + 0.18u)' ps='2*int((nf+2)/2) * (W/nf + 0.18u)' nrd='0.18u / W' nrs='0.18u / W' sa=0 sb=0 sd=0
Xmp3b d3 D2B VDD VDD pfet_03v3 L={l_mp3} W={w_mp3} nf={nf_mp3} ad='int((nf+1)/2) * W/nf * 0.18u' as='int((nf+2)/2) * W/nf * 0.18u' pd='2*int((nf+1)/2) * (W/nf + 0.18u)' ps='2*int((nf+2)/2) * (W/nf + 0.18u)' nrd='0.18u / W' nrs='0.18u / W' sa=0 sb=0 sd=0
Xmn3a n3a n3a VSS VSS nfet_03v3 L={l_mn3} W={w_mn3} nf={nf_mn3} ad='int((nf+1)/2) * W/nf * 0.18u' as='int((nf+2)/2) * W/nf * 0.18u' pd='2*int((nf+1)/2) * (W/nf + 0.18u)' ps='2*int((nf+2)/2) * (W/nf + 0.18u)' nrd='0.18u / W' nrs='0.18u / W' sa=0 sb=0 sd=0
Xmn3b d3 n3a VSS VSS nfet_03v3 L={l_mn3} W={w_mn3} nf={nf_mn3} ad='int((nf+1)/2) * W/nf * 0.18u' as='int((nf+2)/2) * W/nf * 0.18u' pd='2*int((nf+1)/2) * (W/nf + 0.18u)' ps='2*int((nf+2)/2) * (W/nf + 0.18u)' nrd='0.18u / W' nrs='0.18u / W' sa=0 sb=0 sd=0
Xmnandp1 nd d3 VDD VDD pfet_03v3 L={l_nand_p} W={w_nand_p} nf={nf_nand_p} ad='int((nf+1)/2) * W/nf * 0.18u' as='int((nf+2)/2) * W/nf * 0.18u' pd='2*int((nf+1)/2) * (W/nf + 0.18u)' ps='2*int((nf+2)/2) * (W/nf + 0.18u)' nrd='0.18u / W' nrs='0.18u / W' sa=0 sb=0 sd=0
Xmnandp2 nd EN VDD VDD pfet_03v3 L={l_nand_p} W={w_nand_p} nf={nf_nand_p} ad='int((nf+1)/2) * W/nf * 0.18u' as='int((nf+2)/2) * W/nf * 0.18u' pd='2*int((nf+1)/2) * (W/nf + 0.18u)' ps='2*int((nf+2)/2) * (W/nf + 0.18u)' nrd='0.18u / W' nrs='0.18u / W' sa=0 sb=0 sd=0
Xmnandn1 nd d3 nm VSS nfet_03v3 L={l_nand_n} W={w_nand_n} nf={nf_nand_n} ad='int((nf+1)/2) * W/nf * 0.18u' as='int((nf+2)/2) * W/nf * 0.18u' pd='2*int((nf+1)/2) * (W/nf + 0.18u)' ps='2*int((nf+2)/2) * (W/nf + 0.18u)' nrd='0.18u / W' nrs='0.18u / W' sa=0 sb=0 sd=0
Xmnandn2 nm EN VSS VSS nfet_03v3 L={l_nand_n} W={w_nand_n} nf={nf_nand_n} ad='int((nf+1)/2) * W/nf * 0.18u' as='int((nf+2)/2) * W/nf * 0.18u' pd='2*int((nf+1)/2) * (W/nf + 0.18u)' ps='2*int((nf+2)/2) * (W/nf + 0.18u)' nrd='0.18u / W' nrs='0.18u / W' sa=0 sb=0 sd=0
Xminv1p i1 nd VDD VDD pfet_03v3 L={l_inv1_p} W={w_inv1_p} nf={nf_inv1_p} ad='int((nf+1)/2) * W/nf * 0.18u' as='int((nf+2)/2) * W/nf * 0.18u' pd='2*int((nf+1)/2) * (W/nf + 0.18u)' ps='2*int((nf+2)/2) * (W/nf + 0.18u)' nrd='0.18u / W' nrs='0.18u / W' sa=0 sb=0 sd=0
Xminv1n i1 nd VSS VSS nfet_03v3 L={l_inv1_n} W={w_inv1_n} nf={nf_inv1_n} ad='int((nf+1)/2) * W/nf * 0.18u' as='int((nf+2)/2) * W/nf * 0.18u' pd='2*int((nf+1)/2) * (W/nf + 0.18u)' ps='2*int((nf+2)/2) * (W/nf + 0.18u)' nrd='0.18u / W' nrs='0.18u / W' sa=0 sb=0 sd=0
Xminv2p i2 i1 VDD VDD pfet_03v3 L={l_inv2_p} W={w_inv2_p} nf={nf_inv2_p} ad='int((nf+1)/2) * W/nf * 0.18u' as='int((nf+2)/2) * W/nf * 0.18u' pd='2*int((nf+1)/2) * (W/nf + 0.18u)' ps='2*int((nf+2)/2) * (W/nf + 0.18u)' nrd='0.18u / W' nrs='0.18u / W' sa=0 sb=0 sd=0
Xminv2n i2 i1 VSS VSS nfet_03v3 L={l_inv2_n} W={w_inv2_n} nf={nf_inv2_n} ad='int((nf+1)/2) * W/nf * 0.18u' as='int((nf+2)/2) * W/nf * 0.18u' pd='2*int((nf+1)/2) * (W/nf + 0.18u)' ps='2*int((nf+2)/2) * (W/nf + 0.18u)' nrd='0.18u / W' nrs='0.18u / W' sa=0 sb=0 sd=0
Xminv3p OUT i2 VDD VDD pfet_03v3 L={l_inv3_p} W={w_inv3_p} nf={nf_inv3_p} ad='int((nf+1)/2) * W/nf * 0.18u' as='int((nf+2)/2) * W/nf * 0.18u' pd='2*int((nf+1)/2) * (W/nf + 0.18u)' ps='2*int((nf+2)/2) * (W/nf + 0.18u)' nrd='0.18u / W' nrs='0.18u / W' sa=0 sb=0 sd=0
Xminv3n OUT i2 VSS VSS nfet_03v3 L={l_inv3_n} W={w_inv3_n} nf={nf_inv3_n} ad='int((nf+1)/2) * W/nf * 0.18u' as='int((nf+2)/2) * W/nf * 0.18u' pd='2*int((nf+1)/2) * (W/nf + 0.18u)' ps='2*int((nf+2)/2) * (W/nf + 0.18u)' nrd='0.18u / W' nrs='0.18u / W' sa=0 sb=0 sd=0
.ends lvds_out

.subckt lvds_lane VDD VSS INP INN EN VBN VBP VB2 VREF OUT
xesdp INP gp VDD VSS lvds_esd2
xesdn INN gn VDD VSS lvds_esd2
xpre VDD VSS gp gn VBN VBP VB2 VREF oa ob lvds_pre
xhyst VDD VSS oa ob VBN EN d2a d2b lvds_hyst
xout VDD VSS d2a d2b EN OUT lvds_out
.ends lvds_lane

* (subckt lvds_rx_x3 removed: the extracted one follows)

.subckt lvds_rx_x3 VDD VSS RX0_P RX0_N RX1_P RX1_N RX2_P RX2_N EN RX0_O RX1_O RX2_O
X0 VDD xl2.d2b xl2.d2b VDD pfet_03v3 ad=0.52p pd=2.52u as=0.52p ps=2.52u w=2u l=0.4u
X1 VSS VSS xl2.xpre.fa VSS nfet_03v3 ad=1.1p pd=5.88u as=0.65p ps=3.02u w=2.5u l=1u
X2 xl2.xout.n3a xl2.d2a VDD VDD pfet_03v3 ad=0.52p pd=2.52u as=0.52p ps=2.52u w=2u l=0.4u
X3 VSS VSS RX1_O VSS nfet_03v3 ad=1.76p pd=8.88u as=1.04p ps=4.52u w=4u l=0.28u
X4 xl0.xpre.tp xl0.gn xl0.xpre.fb xl0.xpre.tp pfet_03v3 ad=1.248p pd=5.32u as=1.248p ps=5.32u w=4.8u l=0.4u
X5 xl0.xpre.fb vref xl0.xpre.tp xl0.xpre.tp pfet_03v3 ad=1.248p pd=5.32u as=1.248p ps=5.32u w=4.8u l=0.4u
X6 VDD vbp xl2.xpre.tp VDD pfet_03v3 ad=1.3p pd=5.52u as=1.3p ps=5.52u w=5u l=1u
X7 xl1.xpre.tp xl1.gn xl1.xpre.fb xl1.xpre.tp pfet_03v3 ad=1.248p pd=5.32u as=1.248p ps=5.32u w=4.8u l=0.4u
X8 xl1.xpre.fb vbn VSS VSS nfet_03v3 ad=0.65p pd=3.02u as=0.65p ps=3.02u w=2.5u l=1u
X9 vbp vbp VDD VDD pfet_03v3 ad=1.3p pd=5.52u as=1.3p ps=5.52u w=5u l=1u
X10 xl2.xpre.fa vref xl2.xpre.tp xl2.xpre.tp pfet_03v3 ad=1.248p pd=5.32u as=1.248p ps=5.32u w=4.8u l=0.4u
X11 VSS vbn xl0.xpre.fb VSS nfet_03v3 ad=0.65p pd=3.02u as=0.65p ps=3.02u w=2.5u l=1u
X12 xl2.xout.n3a xl2.d2a VDD VDD pfet_03v3 ad=0.52p pd=2.52u as=0.52p ps=2.52u w=2u l=0.4u
X13 xl1.xpre.tp vbp VDD VDD pfet_03v3 ad=1.3p pd=5.52u as=1.3p ps=5.52u w=5u l=1u
X14 VSS VSS xl2.xpre.fa VSS nfet_03v3 ad=1.9888p pd=9.92u as=1.1752p ps=5.04u w=4.52u l=0.5u
X15 xl1.xpre.tn xl1.gp xl1.oa VSS nfet_03v3 ad=1.235p pd=5.27u as=1.235p ps=5.27u w=4.75u l=0.5u
X16 xl1.xpre.fb xl1.gn xl1.xpre.tp xl1.xpre.tp pfet_03v3 ad=1.248p pd=5.32u as=1.248p ps=5.32u w=4.8u l=0.4u
X17 xl2.xpre.tp vref xl2.xpre.fb xl2.xpre.tp pfet_03v3 ad=1.248p pd=5.32u as=1.248p ps=5.32u w=4.8u l=0.4u
X18 VSS vbn xl1.xpre.fb VSS nfet_03v3 ad=0.65p pd=3.02u as=0.65p ps=3.02u w=2.5u l=1u
X19 xl2.xpre.tn vref xl2.ob VSS nfet_03v3 ad=1.235p pd=5.27u as=1.235p ps=5.27u w=4.75u l=0.5u
X20 xl2.oa vb2 xl2.xpre.fa VSS nfet_03v3 ad=1.1752p pd=5.04u as=1.1752p ps=5.04u w=4.52u l=0.5u
X21 xl0.xpre.tp xl0.gp xl0.xpre.fa xl0.xpre.tp pfet_03v3 ad=1.248p pd=5.32u as=1.248p ps=5.32u w=4.8u l=0.4u
X22 xl0.oa vref xl0.xpre.tn VSS nfet_03v3 ad=1.235p pd=5.27u as=1.235p ps=5.27u w=4.75u l=0.5u
X23 xl1.xpre.fb vref xl1.xpre.tp xl1.xpre.tp pfet_03v3 ad=1.248p pd=5.32u as=1.248p ps=5.32u w=4.8u l=0.4u
X24 xl2.xpre.fb vb2 xl2.ob VSS nfet_03v3 ad=1.1752p pd=5.04u as=1.1752p ps=5.04u w=4.52u l=0.5u
X25 VSS vref VSS VSS nfet_03v3 ad=8.8p pd=40.88u as=0.24333n ps=1.1905m w=20u l=25.13u
X26 xl1.xpre.tn xl1.gp xl1.oa VSS nfet_03v3 ad=1.235p pd=5.27u as=1.235p ps=5.27u w=4.75u l=0.5u
X27 xl2.xout.d3 xl2.d2b VDD VDD pfet_03v3 ad=0.52p pd=2.52u as=0.52p ps=2.52u w=2u l=0.4u
X28 xl1.xout.d3 xl1.d2b VDD VDD pfet_03v3 ad=0.52p pd=2.52u as=0.52p ps=2.52u w=2u l=0.4u
D0 xl0.gp VDD diode_pd2nw_03v3 pj=26u area=40p
X29 xl2.xpre.tp xl2.gp xl2.xpre.fa xl2.xpre.tp pfet_03v3 ad=1.248p pd=5.32u as=1.248p ps=5.32u w=4.8u l=0.4u
X30 xl0.ob vb2 xl0.xpre.fb VSS nfet_03v3 ad=1.1752p pd=5.04u as=1.1752p ps=5.04u w=4.52u l=0.5u
X31 xl0.xout.nm xl0.xout.d3 xl0.xout.nd VSS nfet_03v3 ad=0.52p pd=2.52u as=0.52p ps=2.52u w=2u l=0.28u
X32 xl1.d2a VDD VDD VDD pfet_03v3 ad=0.52p pd=2.52u as=0.88p ps=4.88u w=2u l=0.4u
X33 xl0.ob vref xl0.xpre.tn VSS nfet_03v3 ad=1.235p pd=5.27u as=1.235p ps=5.27u w=4.75u l=0.5u
X34 xl1.xpre.tn xl1.gn xl1.ob VSS nfet_03v3 ad=1.235p pd=5.27u as=1.235p ps=5.27u w=4.75u l=0.5u
X35 RX0_O xl0.xout.i2 VSS VSS nfet_03v3 ad=1.04p pd=4.52u as=1.04p ps=4.52u w=4u l=0.28u
X36 VSS vbn vbp VSS nfet_03v3 ad=0.65p pd=3.02u as=0.65p ps=3.02u w=2.5u l=1u
X37 VSS VSS VSS ppolyf_u_1k r_width=2u r_length=8.86u
X38 xl0.xpre.fa vref xl0.xpre.tp xl0.xpre.tp pfet_03v3 ad=1.248p pd=5.32u as=1.248p ps=5.32u w=4.8u l=0.4u
X39 xl1.xpre.fb xl1.gn xl1.xpre.tp xl1.xpre.tp pfet_03v3 ad=1.248p pd=5.32u as=1.248p ps=5.32u w=4.8u l=0.4u
X40 xl0.xpre.fa vbn VSS VSS nfet_03v3 ad=0.65p pd=3.02u as=0.65p ps=3.02u w=2.5u l=1u
X41 xl0.xpre.tn xl0.gp xl0.oa VSS nfet_03v3 ad=1.235p pd=5.27u as=1.235p ps=5.27u w=4.75u l=0.5u
X42 xl2.xpre.fb vref xl2.xpre.tp xl2.xpre.tp pfet_03v3 ad=1.248p pd=5.32u as=1.248p ps=5.32u w=4.8u l=0.4u
X43 xl0.xpre.fa vref xl0.xpre.tp xl0.xpre.tp pfet_03v3 ad=1.248p pd=5.32u as=1.248p ps=5.32u w=4.8u l=0.4u
X44 xl1.xpre.tp vref xl1.xpre.fa xl1.xpre.tp pfet_03v3 ad=1.248p pd=5.32u as=1.248p ps=5.32u w=4.8u l=0.4u
X45 xl0.xpre.tn vbn VSS VSS nfet_03v3 ad=0.65p pd=3.02u as=0.65p ps=3.02u w=2.5u l=1u
X46 xl2.oa xl2.gp xl2.xpre.tn VSS nfet_03v3 ad=1.235p pd=5.27u as=1.235p ps=5.27u w=4.75u l=0.5u
X47 RX2_O xl2.xout.i2 VSS VSS nfet_03v3 ad=1.04p pd=4.52u as=1.04p ps=4.52u w=4u l=0.28u
X48 VSS VSS xl2.xhyst.ts VSS nfet_03v3 ad=1.1p pd=5.88u as=0.65p ps=3.02u w=2.5u l=1u
X49 VDD xl0.xout.i2 RX0_O VDD pfet_03v3 ad=1.3p pd=5.52u as=1.3p ps=5.52u w=5u l=0.28u
X50 VSS xbias.enb vb2 VSS nfet_03v3 ad=0.52p pd=2.52u as=0.52p ps=2.52u w=2u l=0.5u
X51 VDD xl2.xout.d3 xl2.xout.nd VDD pfet_03v3 ad=0.78p pd=3.52u as=0.78p ps=3.52u w=3u l=0.28u
X52 xl0.d2b xl0.d2b VDD VDD pfet_03v3 ad=0.52p pd=2.52u as=0.52p ps=2.52u w=2u l=0.4u
X53 xl0.xout.d3 xl0.d2b VDD VDD pfet_03v3 ad=0.52p pd=2.52u as=0.52p ps=2.52u w=2u l=0.4u
X54 xl1.xpre.tp vref xl1.xpre.fa xl1.xpre.tp pfet_03v3 ad=1.248p pd=5.32u as=1.248p ps=5.32u w=4.8u l=0.4u
X55 VSS vbn xl0.xhyst.ts VSS nfet_03v3 ad=0.65p pd=3.02u as=0.65p ps=3.02u w=2.5u l=1u
X56 xl2.ob vref xl2.xpre.tn VSS nfet_03v3 ad=1.235p pd=5.27u as=1.235p ps=5.27u w=4.75u l=0.5u
X57 VDD VDD xl0.xout.i2 VDD pfet_03v3 ad=1.65p pd=8.38u as=0.975p ps=4.27u w=3.75u l=0.28u
X58 VDD VDD xl2.d2b VDD pfet_03v3 ad=0.88p pd=4.88u as=0.52p ps=2.52u w=2u l=0.4u
X59 xl0.xout.d3 xl0.xout.n3a VSS VSS nfet_03v3 ad=0.6734p pd=3.11u as=0.6734p ps=3.11u w=2.59u l=0.28u
X60 xl0.xpre.tp xl0.gn xl0.xpre.fb xl0.xpre.tp pfet_03v3 ad=1.248p pd=5.32u as=1.248p ps=5.32u w=4.8u l=0.4u
X61 xl0.xpre.fa vref xl0.xpre.tp xl0.xpre.tp pfet_03v3 ad=1.248p pd=5.32u as=1.248p ps=5.32u w=4.8u l=0.4u
X62 xl1.xpre.fa vref xl1.xpre.tp xl1.xpre.tp pfet_03v3 ad=1.248p pd=5.32u as=1.248p ps=5.32u w=4.8u l=0.4u
X63 xl2.xpre.tp xl2.gp xl2.xpre.fa xl2.xpre.tp pfet_03v3 ad=1.248p pd=5.32u as=1.248p ps=5.32u w=4.8u l=0.4u
X64 xl2.xout.n3a VDD VDD VDD pfet_03v3 ad=0.52p pd=2.52u as=0.88p ps=4.88u w=2u l=0.4u
X65 xl0.xpre.tp vref xl0.xpre.fb xl0.xpre.tp pfet_03v3 ad=1.248p pd=5.32u as=1.248p ps=5.32u w=4.8u l=0.4u
X66 xl1.xpre.tp xl1.gn xl1.xpre.fb xl1.xpre.tp pfet_03v3 ad=1.248p pd=5.32u as=1.248p ps=5.32u w=4.8u l=0.4u
X67 VDD xl2.xout.i2 RX2_O VDD pfet_03v3 ad=1.3p pd=5.52u as=1.3p ps=5.52u w=5u l=0.28u
X68 xl2.xpre.fa xl2.gp xl2.xpre.tp xl2.xpre.tp pfet_03v3 ad=1.248p pd=5.32u as=1.248p ps=5.32u w=4.8u l=0.4u
X69 xl1.d2a xl1.oa xl1.xhyst.sa VSS nfet_03v3 ad=1.0036p pd=4.38u as=1.0036p ps=4.38u w=3.86u l=0.5u
X70 VSS VSS VSS ppolyf_u_1k r_width=2u r_length=9.11u
X71 VDD vbp xl0.xpre.tp VDD pfet_03v3 ad=1.3p pd=5.52u as=1.3p ps=5.52u w=5u l=1u
X72 xl1.xpre.fa xl1.gp xl1.xpre.tp xl1.xpre.tp pfet_03v3 ad=1.248p pd=5.32u as=1.248p ps=5.32u w=4.8u l=0.4u
X73 xl1.ob vref xl1.xpre.tn VSS nfet_03v3 ad=2.09p pd=10.38u as=1.235p ps=5.27u w=4.75u l=0.5u
X74 xl0.xpre.tp vref xl0.xpre.fa xl0.xpre.tp pfet_03v3 ad=1.248p pd=5.32u as=1.248p ps=5.32u w=4.8u l=0.4u
X75 VSS VSS RX0_O VSS nfet_03v3 ad=1.76p pd=8.88u as=1.04p ps=4.52u w=4u l=0.28u
X76 xl0.xpre.fb xl0.gn xl0.xpre.tp xl0.xpre.tp pfet_03v3 ad=1.248p pd=5.32u as=1.248p ps=5.32u w=4.8u l=0.4u
X77 xl2.xpre.tp vref xl2.xpre.fb xl2.xpre.tp pfet_03v3 ad=1.248p pd=5.32u as=1.248p ps=5.32u w=4.8u l=0.4u
X78 VSS vbn xl1.xpre.fb VSS nfet_03v3 ad=0.65p pd=3.02u as=0.65p ps=3.02u w=2.5u l=1u
X79 VDD vbp xl1.xpre.tp VDD pfet_03v3 ad=1.3p pd=5.52u as=1.3p ps=5.52u w=5u l=1u
X80 xl1.oa vb2 xl1.xpre.fa VSS nfet_03v3 ad=1.1752p pd=5.04u as=1.1752p ps=5.04u w=4.52u l=0.5u
X81 VSS VSS xl1.xpre.fb VSS nfet_03v3 ad=1.9888p pd=9.92u as=1.1752p ps=5.04u w=4.52u l=0.5u
X82 xl0.xpre.tn VSS VSS VSS nfet_03v3 ad=0.65p pd=3.02u as=1.1p ps=5.88u w=2.5u l=1u
X83 VDD vbp xl1.xpre.tp VDD pfet_03v3 ad=1.3p pd=5.52u as=1.3p ps=5.52u w=5u l=1u
X84 xl0.oa vref xl0.xpre.tn VSS nfet_03v3 ad=1.235p pd=5.27u as=1.235p ps=5.27u w=4.75u l=0.5u
X85 xl0.xout.n3a xl0.d2a VDD VDD pfet_03v3 ad=0.52p pd=2.52u as=0.52p ps=2.52u w=2u l=0.4u
X86 xl2.xout.i2 xl2.xout.i1 VDD VDD pfet_03v3 ad=0.975p pd=4.27u as=0.975p ps=4.27u w=3.75u l=0.28u
X87 VDD VDD VDD VDD pfet_03v3 ad=0.52p pd=2.52u as=0.29839n ps=1.38742m w=2u l=0.5u
X88 VDD EN xl1.d2a VDD pfet_03v3 ad=0.52p pd=2.52u as=0.52p ps=2.52u w=2u l=0.5u
X89 xl1.oa VSS VSS VSS nfet_03v3 ad=1.1752p pd=5.04u as=1.9888p ps=9.92u w=4.52u l=0.5u
X90 xl2.xpre.tp vref xl2.xpre.fb xl2.xpre.tp pfet_03v3 ad=1.248p pd=5.32u as=1.248p ps=5.32u w=4.8u l=0.4u
X91 xl1.xhyst.ts vbn VSS VSS nfet_03v3 ad=0.65p pd=3.02u as=0.65p ps=3.02u w=2.5u l=1u
X92 xl1.xpre.tp xl1.gn xl1.xpre.fb xl1.xpre.tp pfet_03v3 ad=1.248p pd=5.32u as=1.248p ps=5.32u w=4.8u l=0.4u
X93 xl0.ob vref xl0.xpre.tn VSS nfet_03v3 ad=1.235p pd=5.27u as=1.235p ps=5.27u w=4.75u l=0.5u
X94 VSS VSS RX2_O VSS nfet_03v3 ad=1.76p pd=8.88u as=1.04p ps=4.52u w=4u l=0.28u
X95 xl0.xpre.tp vref xl0.xpre.fa xl0.xpre.tp pfet_03v3 ad=1.248p pd=5.32u as=1.248p ps=5.32u w=4.8u l=0.4u
X96 xl2.xpre.fb vref xl2.xpre.tp xl2.xpre.tp pfet_03v3 ad=1.248p pd=5.32u as=1.248p ps=5.32u w=4.8u l=0.4u
X97 xl1.oa xl1.gp xl1.xpre.tn VSS nfet_03v3 ad=1.235p pd=5.27u as=1.235p ps=5.27u w=4.75u l=0.5u
X98 xl2.xpre.tn vref xl2.oa VSS nfet_03v3 ad=1.235p pd=5.27u as=1.235p ps=5.27u w=4.75u l=0.5u
X99 xl0.oa vref xl0.xpre.tn VSS nfet_03v3 ad=1.235p pd=5.27u as=1.235p ps=5.27u w=4.75u l=0.5u
X100 VDD xl1.d2a xl1.xout.n3a VDD pfet_03v3 ad=0.52p pd=2.52u as=0.52p ps=2.52u w=2u l=0.4u
X101 xl0.xpre.tp vbp VDD VDD pfet_03v3 ad=1.3p pd=5.52u as=1.3p ps=5.52u w=5u l=1u
X102 VSS VSS VSS ppolyf_u_1k r_width=2u r_length=23.07u
X103 xl0.xpre.fa xl0.gp xl0.xpre.tp xl0.xpre.tp pfet_03v3 ad=1.248p pd=5.32u as=1.248p ps=5.32u w=4.8u l=0.4u
X104 xl1.xpre.fa xl1.gp xl1.xpre.tp xl1.xpre.tp pfet_03v3 ad=1.248p pd=5.32u as=1.248p ps=5.32u w=4.8u l=0.4u
X105 xl1.ob xl1.gn xl1.xpre.tn VSS nfet_03v3 ad=1.235p pd=5.27u as=1.235p ps=5.27u w=4.75u l=0.5u
X106 xl1.xpre.tp vbp VDD VDD pfet_03v3 ad=1.3p pd=5.52u as=1.3p ps=5.52u w=5u l=1u
X107 xl2.xpre.tp vref xl2.xpre.fa xl2.xpre.tp pfet_03v3 ad=1.248p pd=5.32u as=1.248p ps=5.32u w=4.8u l=0.4u
X108 VDD VDD xl2.xout.n3a VDD pfet_03v3 ad=0.88p pd=4.88u as=0.52p ps=2.52u w=2u l=0.4u
X109 xl2.gp RX2_P VDD ppolyf_u r_width=5u r_length=1.8u
X110 xl0.xpre.tp xl0.gp xl0.xpre.fa xl0.xpre.tp pfet_03v3 ad=1.248p pd=5.32u as=1.248p ps=5.32u w=4.8u l=0.4u
X111 xl1.ob vref xl1.xpre.tn VSS nfet_03v3 ad=1.235p pd=5.27u as=1.235p ps=5.27u w=4.75u l=0.5u
X112 VSS vbn xl0.xpre.tn VSS nfet_03v3 ad=0.65p pd=3.02u as=0.65p ps=3.02u w=2.5u l=1u
X113 xl0.xpre.tp xl0.gn xl0.xpre.fb xl0.xpre.tp pfet_03v3 ad=1.248p pd=5.32u as=1.248p ps=5.32u w=4.8u l=0.4u
X114 xl0.xpre.tp xl0.gn xl0.xpre.fb xl0.xpre.tp pfet_03v3 ad=1.248p pd=5.32u as=1.248p ps=5.32u w=4.8u l=0.4u
X115 VSS vbn xl1.xpre.fa VSS nfet_03v3 ad=0.65p pd=3.02u as=0.65p ps=3.02u w=2.5u l=1u
X116 xl2.xhyst.ts vbn VSS VSS nfet_03v3 ad=0.65p pd=3.02u as=0.65p ps=3.02u w=2.5u l=1u
X117 xl1.xpre.fa vref xl1.xpre.tp xl1.xpre.tp pfet_03v3 ad=1.248p pd=5.32u as=1.248p ps=5.32u w=4.8u l=0.4u
X118 xl2.xpre.fa vref xl2.xpre.tp xl2.xpre.tp pfet_03v3 ad=1.248p pd=5.32u as=1.248p ps=5.32u w=4.8u l=0.4u
X119 xbias.nmid EN VSS VSS nfet_03v3 ad=1.3p pd=5.52u as=1.3p ps=5.52u w=5u l=0.5u
X120 VDD VDD VDD VDD pfet_03v3 ad=1.3p pd=5.52u as=0 ps=0 w=5u l=1u
X121 xl0.xpre.fa vbn VSS VSS nfet_03v3 ad=0.65p pd=3.02u as=0.65p ps=3.02u w=2.5u l=1u
X122 VSS vbn xl1.xpre.tn VSS nfet_03v3 ad=0.65p pd=3.02u as=0.65p ps=3.02u w=2.5u l=1u
X123 VSS vbn vbn VSS nfet_03v3 ad=0.65p pd=3.02u as=0.65p ps=3.02u w=2.5u l=1u
X124 xl2.d2b xl2.ob xl2.xhyst.sb VSS nfet_03v3 ad=1.0036p pd=4.38u as=1.0036p ps=4.38u w=3.86u l=0.5u
X125 vb2 vbp VDD VDD pfet_03v3 ad=1.3p pd=5.52u as=1.3p ps=5.52u w=5u l=1u
X126 xl0.xpre.fb xl0.gn xl0.xpre.tp xl0.xpre.tp pfet_03v3 ad=1.248p pd=5.32u as=1.248p ps=5.32u w=4.8u l=0.4u
X127 xl2.xpre.tp vref xl2.xpre.fa xl2.xpre.tp pfet_03v3 ad=1.248p pd=5.32u as=1.248p ps=5.32u w=4.8u l=0.4u
X128 VDD xbias.rdt_m1 VSS ppolyf_u_1k r_width=2u r_length=21.01u
X129 xl2.xpre.tn vref xl2.oa VSS nfet_03v3 ad=1.235p pd=5.27u as=1.235p ps=5.27u w=4.75u l=0.5u
X130 xl2.d2b xl2.d2b VDD VDD pfet_03v3 ad=0.52p pd=2.52u as=0.52p ps=2.52u w=2u l=0.4u
X131 xbias.nmid VSS VSS VSS nfet_03v3 ad=1.3p pd=5.52u as=2.2p ps=10.88u w=5u l=0.5u
X132 xl0.xhyst.sb xl0.ob xl0.d2b VSS nfet_03v3 ad=1.0036p pd=4.38u as=1.0036p ps=4.38u w=3.86u l=0.5u
X133 VSS VSS xl0.xhyst.sa VSS nfet_03v3 ad=1.6984p pd=8.6u as=1.0036p ps=4.38u w=3.86u l=0.5u
X134 xl2.xpre.fa vref xl2.xpre.tp xl2.xpre.tp pfet_03v3 ad=1.248p pd=5.32u as=1.248p ps=5.32u w=4.8u l=0.4u
X135 xl1.xpre.tn xl1.gn xl1.ob VSS nfet_03v3 ad=1.235p pd=5.27u as=1.235p ps=5.27u w=4.75u l=0.5u
X136 VDD EN xbias.enb VDD pfet_03v3 ad=0.65p pd=3.02u as=0.65p ps=3.02u w=2.5u l=0.28u
X137 VDD xl2.d2b xl2.xout.d3 VDD pfet_03v3 ad=0.52p pd=2.52u as=0.52p ps=2.52u w=2u l=0.4u
X138 xl2.xpre.fb vb2 xl2.ob VSS nfet_03v3 ad=1.1752p pd=5.04u as=1.1752p ps=5.04u w=4.52u l=0.5u
X139 xl2.xpre.tn vref xl2.ob VSS nfet_03v3 ad=1.235p pd=5.27u as=1.235p ps=5.27u w=4.75u l=0.5u
X140 xl2.xpre.fa vref xl2.xpre.tp xl2.xpre.tp pfet_03v3 ad=1.248p pd=5.32u as=1.248p ps=5.32u w=4.8u l=0.4u
X141 xl2.oa vb2 xl2.xpre.fa VSS nfet_03v3 ad=1.1752p pd=5.04u as=1.1752p ps=5.04u w=4.52u l=0.5u
X142 VDD EN xl2.d2b VDD pfet_03v3 ad=0.52p pd=2.52u as=0.52p ps=2.52u w=2u l=0.5u
X143 xl0.xpre.fb xl0.gn xl0.xpre.tp xl0.xpre.tp pfet_03v3 ad=1.248p pd=5.32u as=1.248p ps=5.32u w=4.8u l=0.4u
X144 xl1.xpre.fb xl1.gn xl1.xpre.tp xl1.xpre.tp pfet_03v3 ad=1.248p pd=5.32u as=1.248p ps=5.32u w=4.8u l=0.4u
X145 VSS vbn xl2.xpre.fa VSS nfet_03v3 ad=0.65p pd=3.02u as=0.65p ps=3.02u w=2.5u l=1u
X146 xl2.xpre.fb vb2 xl2.ob VSS nfet_03v3 ad=1.1752p pd=5.04u as=1.1752p ps=5.04u w=4.52u l=0.5u
X147 xl1.xpre.tn xl1.gp xl1.oa VSS nfet_03v3 ad=1.235p pd=5.27u as=1.235p ps=5.27u w=4.75u l=0.5u
X148 xl1.xhyst.ts vbn VSS VSS nfet_03v3 ad=0.65p pd=3.02u as=0.65p ps=3.02u w=2.5u l=1u
X149 VDD vbp xl1.xpre.tp VDD pfet_03v3 ad=1.3p pd=5.52u as=1.3p ps=5.52u w=5u l=1u
X150 VSS VSS VSS ppolyf_u_1k r_width=2u r_length=21.01u
X151 xbias.rdb_m2 xbias.rdb_m3 VSS ppolyf_u_1k r_width=2u r_length=19.26u
D1 xl1.gn VDD diode_pd2nw_03v3 pj=26u area=40p
X152 VDD vbp xl2.xpre.tp VDD pfet_03v3 ad=1.3p pd=5.52u as=1.3p ps=5.52u w=5u l=1u
X153 VDD vbp vb2 VDD pfet_03v3 ad=1.3p pd=5.52u as=1.3p ps=5.52u w=5u l=1u
X154 xl2.xpre.tp vref xl2.xpre.fb xl2.xpre.tp pfet_03v3 ad=1.248p pd=5.32u as=1.248p ps=5.32u w=4.8u l=0.4u
X155 VSS vbn xl0.xpre.fa VSS nfet_03v3 ad=0.65p pd=3.02u as=0.65p ps=3.02u w=2.5u l=1u
X156 xl0.ob vb2 xl0.xpre.fb VSS nfet_03v3 ad=1.1752p pd=5.04u as=1.1752p ps=5.04u w=4.52u l=0.5u
X157 xl1.xpre.fb vref xl1.xpre.tp xl1.xpre.tp pfet_03v3 ad=2.112p pd=10.48u as=1.248p ps=5.32u w=4.8u l=0.4u
X158 xl0.oa vref xl0.xpre.tn VSS nfet_03v3 ad=1.235p pd=5.27u as=1.235p ps=5.27u w=4.75u l=0.5u
X159 xl2.ob xl2.rlb_m1 VSS ppolyf_u_1k r_width=2u r_length=9.11u
X160 xl2.gn RX2_N VDD ppolyf_u r_width=5u r_length=1.8u
X161 xl0.xpre.tp xl0.gn xl0.xpre.fb xl0.xpre.tp pfet_03v3 ad=1.248p pd=5.32u as=1.248p ps=5.32u w=4.8u l=0.4u
X162 VSS VSS xbias.vf VSS nfet_03v3 ad=3.4804p pd=16.7u as=2.0566p ps=8.43u w=7.91u l=0.5u
X163 xl2.d2b xl2.d2a VDD VDD pfet_03v3 ad=0.52p pd=2.52u as=0.52p ps=2.52u w=2u l=0.4u
X164 xl2.xout.d3 xl2.d2b VDD VDD pfet_03v3 ad=0.52p pd=2.52u as=0.52p ps=2.52u w=2u l=0.4u
X165 xl0.ob vb2 xl0.xpre.fb VSS nfet_03v3 ad=1.1752p pd=5.04u as=1.1752p ps=5.04u w=4.52u l=0.5u
X166 xl1.xpre.fb vbn VSS VSS nfet_03v3 ad=0.65p pd=3.02u as=0.65p ps=3.02u w=2.5u l=1u
X167 xl2.ob xl2.gn xl2.xpre.tn VSS nfet_03v3 ad=1.235p pd=5.27u as=1.235p ps=5.27u w=4.75u l=0.5u
X168 xl1.xpre.fb vref xl1.xpre.tp xl1.xpre.tp pfet_03v3 ad=1.248p pd=5.32u as=1.248p ps=5.32u w=4.8u l=0.4u
X169 xl1.xpre.tn vbn VSS VSS nfet_03v3 ad=0.65p pd=3.02u as=0.65p ps=3.02u w=2.5u l=1u
X170 VDD xl2.xout.nd xl2.xout.i1 VDD pfet_03v3 ad=0.962p pd=4.22u as=0.962p ps=4.22u w=3.7u l=0.28u
X171 xl1.xpre.tp vbp VDD VDD pfet_03v3 ad=1.3p pd=5.52u as=1.3p ps=5.52u w=5u l=1u
X172 xl2.xpre.fa vbn VSS VSS nfet_03v3 ad=0.65p pd=3.02u as=0.65p ps=3.02u w=2.5u l=1u
X173 xl1.xhyst.sb xl1.ob xl1.d2b VSS nfet_03v3 ad=1.0036p pd=4.38u as=1.0036p ps=4.38u w=3.86u l=0.5u
X174 xl0.xpre.fa xl0.gp xl0.xpre.tp xl0.xpre.tp pfet_03v3 ad=1.248p pd=5.32u as=1.248p ps=5.32u w=4.8u l=0.4u
X175 xl0.xpre.tp vref xl0.xpre.fa xl0.xpre.tp pfet_03v3 ad=1.248p pd=5.32u as=1.248p ps=5.32u w=4.8u l=0.4u
X176 xl1.xpre.fb xl1.gn xl1.xpre.tp xl1.xpre.tp pfet_03v3 ad=1.248p pd=5.32u as=1.248p ps=5.32u w=4.8u l=0.4u
X177 xl0.ob VSS VSS VSS nfet_03v3 ad=1.1752p pd=5.04u as=1.9888p ps=9.92u w=4.52u l=0.5u
X178 VSS vbn xl1.xpre.fb VSS nfet_03v3 ad=0.65p pd=3.02u as=0.65p ps=3.02u w=2.5u l=1u
X179 xl2.xpre.tn vbn VSS VSS nfet_03v3 ad=0.65p pd=3.02u as=0.65p ps=3.02u w=2.5u l=1u
X180 VDD xl1.d2a xl1.d2a VDD pfet_03v3 ad=0.52p pd=2.52u as=0.52p ps=2.52u w=2u l=0.4u
X181 xl2.xpre.tp vbp VDD VDD pfet_03v3 ad=1.3p pd=5.52u as=1.3p ps=5.52u w=5u l=1u
X182 VDD xl1.d2a xl1.xout.n3a VDD pfet_03v3 ad=0.52p pd=2.52u as=0.52p ps=2.52u w=2u l=0.4u
D2 VSS xl1.gn diode_nd2ps_03v3 pj=26u area=40p
X183 xl2.xpre.fb vref xl2.xpre.tp xl2.xpre.tp pfet_03v3 ad=1.248p pd=5.32u as=1.248p ps=5.32u w=4.8u l=0.4u
X184 VSS vbn xl1.xhyst.ts VSS nfet_03v3 ad=0.65p pd=3.02u as=0.65p ps=3.02u w=2.5u l=1u
X185 xl2.xhyst.ts xl2.xhyst.sa VSS ppolyf_u_1k r_width=2u r_length=8.86u
X186 xl2.xhyst.sa xl2.oa xl2.d2a VSS nfet_03v3 ad=1.0036p pd=4.38u as=1.0036p ps=4.38u w=3.86u l=0.5u
X187 xl2.xpre.tp vbp VDD VDD pfet_03v3 ad=1.3p pd=5.52u as=1.3p ps=5.52u w=5u l=1u
X188 xl2.oa vref xl2.xpre.tn VSS nfet_03v3 ad=1.235p pd=5.27u as=1.235p ps=5.27u w=4.75u l=0.5u
X189 xl1.xout.i2 VDD VDD VDD pfet_03v3 ad=0.975p pd=4.27u as=1.65p ps=8.38u w=3.75u l=0.28u
X190 vb2 VSS VSS VSS nfet_03v3 ad=2.0566p pd=8.43u as=3.4804p ps=16.7u w=7.91u l=0.5u
X191 xl1.xout.n3a xl1.d2a VDD VDD pfet_03v3 ad=0.52p pd=2.52u as=0.52p ps=2.52u w=2u l=0.4u
X192 VSS VSS VSS ppolyf_u_1k r_width=2u r_length=9.11u
X193 xl1.xpre.fb vref xl1.xpre.tp xl1.xpre.tp pfet_03v3 ad=1.248p pd=5.32u as=1.248p ps=5.32u w=4.8u l=0.4u
X194 xl0.xpre.tp xl0.gn xl0.xpre.fb xl0.xpre.tp pfet_03v3 ad=1.248p pd=5.32u as=1.248p ps=5.32u w=4.8u l=0.4u
X195 xl2.xpre.fb xl2.gn xl2.xpre.tp xl2.xpre.tp pfet_03v3 ad=1.248p pd=5.32u as=1.248p ps=5.32u w=4.8u l=0.4u
X196 xl0.xpre.fb vbn VSS VSS nfet_03v3 ad=0.65p pd=3.02u as=0.65p ps=3.02u w=2.5u l=1u
X197 xl2.ob xl2.gn xl2.xpre.tn VSS nfet_03v3 ad=1.235p pd=5.27u as=1.235p ps=5.27u w=4.75u l=0.5u
X198 VDD vbp xl1.xpre.tp VDD pfet_03v3 ad=1.3p pd=5.52u as=1.3p ps=5.52u w=5u l=1u
X199 xl1.xpre.fa vref xl1.xpre.tp xl1.xpre.tp pfet_03v3 ad=1.248p pd=5.32u as=1.248p ps=5.32u w=4.8u l=0.4u
X200 xl2.xpre.tp xl2.gp xl2.xpre.fa xl2.xpre.tp pfet_03v3 ad=1.248p pd=5.32u as=1.248p ps=5.32u w=4.8u l=0.4u
X201 xl1.xout.n3a xl1.d2a VDD VDD pfet_03v3 ad=0.52p pd=2.52u as=0.52p ps=2.52u w=2u l=0.4u
X202 xl0.xpre.tp vbp VDD VDD pfet_03v3 ad=1.3p pd=5.52u as=1.3p ps=5.52u w=5u l=1u
X203 vbp VDD VDD VDD pfet_03v3 ad=1.3p pd=5.52u as=2.2p ps=10.88u w=5u l=1u
X204 xl2.oa xl2.gp xl2.xpre.tn VSS nfet_03v3 ad=1.235p pd=5.27u as=1.235p ps=5.27u w=4.75u l=0.5u
X205 VSS VSS xl1.xpre.fa VSS nfet_03v3 ad=1.9888p pd=9.92u as=1.1752p ps=5.04u w=4.52u l=0.5u
X206 VSS vbn xl2.xpre.fa VSS nfet_03v3 ad=0.65p pd=3.02u as=0.65p ps=3.02u w=2.5u l=1u
X207 xl0.xpre.tn xl0.gp xl0.oa VSS nfet_03v3 ad=1.235p pd=5.27u as=1.235p ps=5.27u w=4.75u l=0.5u
X208 VDD vbp vbp VDD pfet_03v3 ad=1.3p pd=5.52u as=1.3p ps=5.52u w=5u l=1u
X209 xl0.xpre.fb xl0.gn xl0.xpre.tp xl0.xpre.tp pfet_03v3 ad=1.248p pd=5.32u as=1.248p ps=5.32u w=4.8u l=0.4u
X210 xl1.xpre.tp vref xl1.xpre.fb xl1.xpre.tp pfet_03v3 ad=1.248p pd=5.32u as=1.248p ps=5.32u w=4.8u l=0.4u
X211 VSS vbn xl0.xpre.fb VSS nfet_03v3 ad=0.65p pd=3.02u as=0.65p ps=3.02u w=2.5u l=1u
X212 VSS VSS VSS ppolyf_u_1k r_width=2u r_length=8.86u
X213 VDD vbp xl2.xpre.tp VDD pfet_03v3 ad=1.3p pd=5.52u as=1.3p ps=5.52u w=5u l=1u
X214 xl1.xpre.fa xl1.gp xl1.xpre.tp xl1.xpre.tp pfet_03v3 ad=1.248p pd=5.32u as=1.248p ps=5.32u w=4.8u l=0.4u
X215 xl1.oa vb2 xl1.xpre.fa VSS nfet_03v3 ad=1.1752p pd=5.04u as=1.1752p ps=5.04u w=4.52u l=0.5u
X216 VSS VSS xl2.xpre.tn VSS nfet_03v3 ad=1.1p pd=5.88u as=0.65p ps=3.02u w=2.5u l=1u
X217 VSS vbn xl1.xpre.fa VSS nfet_03v3 ad=0.65p pd=3.02u as=0.65p ps=3.02u w=2.5u l=1u
X218 VSS VSS VSS ppolyf_u_1k r_width=2u r_length=22.27u
X219 xl0.xpre.fb vref xl0.xpre.tp xl0.xpre.tp pfet_03v3 ad=1.248p pd=5.32u as=1.248p ps=5.32u w=4.8u l=0.4u
X220 xl0.xpre.tn xl0.gp xl0.oa VSS nfet_03v3 ad=1.235p pd=5.27u as=1.235p ps=5.27u w=4.75u l=0.5u
X221 xl2.xout.n3a VSS VSS VSS nfet_03v3 ad=0.6734p pd=3.11u as=1.1396p ps=6.06u w=2.59u l=0.28u
X222 VDD vbp xl2.xpre.tp VDD pfet_03v3 ad=1.3p pd=5.52u as=1.3p ps=5.52u w=5u l=1u
X223 xl2.xpre.tp xl2.gn xl2.xpre.fb xl2.xpre.tp pfet_03v3 ad=1.248p pd=5.32u as=1.248p ps=5.32u w=4.8u l=0.4u
X224 xl1.d2b VDD VDD VDD pfet_03v3 ad=0.52p pd=2.52u as=0.88p ps=4.88u w=2u l=0.5u
X225 xl1.xout.d3 xl1.d2b VDD VDD pfet_03v3 ad=0.52p pd=2.52u as=0.52p ps=2.52u w=2u l=0.4u
X226 xl0.xout.d3 xl0.d2b VDD VDD pfet_03v3 ad=0.52p pd=2.52u as=0.52p ps=2.52u w=2u l=0.4u
X227 xl1.xpre.tp xl1.gp xl1.xpre.fa xl1.xpre.tp pfet_03v3 ad=1.248p pd=5.32u as=1.248p ps=5.32u w=4.8u l=0.4u
X228 xl0.d2a VDD VDD VDD pfet_03v3 ad=0.52p pd=2.52u as=0.88p ps=4.88u w=2u l=0.4u
X229 xl0.xpre.tn xl0.gn xl0.ob VSS nfet_03v3 ad=1.235p pd=5.27u as=1.235p ps=5.27u w=4.75u l=0.5u
X230 xbias.nrb VDD VDD VDD pfet_03v3 ad=1.3p pd=5.52u as=2.2p ps=10.88u w=5u l=0.5u
X231 VSS VSS VSS ppolyf_u_1k r_width=2u r_length=8.86u
X232 xl2.xpre.fa vbn VSS VSS nfet_03v3 ad=0.65p pd=3.02u as=0.65p ps=3.02u w=2.5u l=1u
X233 VSS VSS vbp VSS nfet_03v3 ad=1.1p pd=5.88u as=0.65p ps=3.02u w=2.5u l=1u
X234 xl2.xpre.tn vref xl2.ob VSS nfet_03v3 ad=1.235p pd=5.27u as=2.09p ps=10.38u w=4.75u l=0.5u
X235 xl2.xpre.tn vref xl2.oa VSS nfet_03v3 ad=1.235p pd=5.27u as=1.235p ps=5.27u w=4.75u l=0.5u
X236 xl2.xpre.tp vbp VDD VDD pfet_03v3 ad=1.3p pd=5.52u as=1.3p ps=5.52u w=5u l=1u
X237 xl0.xpre.fb xl0.gn xl0.xpre.tp xl0.xpre.tp pfet_03v3 ad=1.248p pd=5.32u as=1.248p ps=5.32u w=4.8u l=0.4u
X238 VSS VSS VSS VSS nfet_03v3 ad=0.52p pd=2.52u as=0 ps=0 w=2u l=0.5u
X239 xbias.rb_m1 xbias.nrb VSS ppolyf_u_1k r_width=2u r_length=22.27u
X240 xl0.xpre.tp vref xl0.xpre.fa xl0.xpre.tp pfet_03v3 ad=1.248p pd=5.32u as=1.248p ps=5.32u w=4.8u l=0.4u
X241 VSS xl1.xout.i1 xl1.xout.i2 VSS nfet_03v3 ad=0.78p pd=3.52u as=0.78p ps=3.52u w=3u l=0.28u
X242 VSS xl1.xout.i2 RX1_O VSS nfet_03v3 ad=1.04p pd=4.52u as=1.04p ps=4.52u w=4u l=0.28u
X243 xl2.xpre.fb xl2.gn xl2.xpre.tp xl2.xpre.tp pfet_03v3 ad=1.248p pd=5.32u as=1.248p ps=5.32u w=4.8u l=0.4u
X244 xl1.oa xl1.gp xl1.xpre.tn VSS nfet_03v3 ad=1.235p pd=5.27u as=1.235p ps=5.27u w=4.75u l=0.5u
X245 VDD VDD xl1.xpre.tp VDD pfet_03v3 ad=2.2p pd=10.88u as=1.3p ps=5.52u w=5u l=1u
X246 xl2.xpre.fb vref xl2.xpre.tp xl2.xpre.tp pfet_03v3 ad=1.248p pd=5.32u as=1.248p ps=5.32u w=4.8u l=0.4u
X247 vbn VSS VSS VSS nfet_03v3 ad=0.52p pd=2.52u as=0.88p ps=4.88u w=2u l=0.5u
X248 VDD xl1.xout.d3 xl1.xout.nd VDD pfet_03v3 ad=0.78p pd=3.52u as=0.78p ps=3.52u w=3u l=0.28u
X249 xl0.xpre.tp vref xl0.xpre.fa xl0.xpre.tp pfet_03v3 ad=1.248p pd=5.32u as=1.248p ps=5.32u w=4.8u l=0.4u
X250 VSS VSS xl2.xout.d3 VSS nfet_03v3 ad=1.1396p pd=6.06u as=0.6734p ps=3.11u w=2.59u l=0.28u
X251 xl1.xpre.fb xl1.gn xl1.xpre.tp xl1.xpre.tp pfet_03v3 ad=1.248p pd=5.32u as=1.248p ps=5.32u w=4.8u l=0.4u
X252 xl1.ob vref xl1.xpre.tn VSS nfet_03v3 ad=1.235p pd=5.27u as=1.235p ps=5.27u w=4.75u l=0.5u
X253 xl1.xpre.fb vbn VSS VSS nfet_03v3 ad=0.65p pd=3.02u as=0.65p ps=3.02u w=2.5u l=1u
X254 VSS vbn xl2.xpre.tn VSS nfet_03v3 ad=0.65p pd=3.02u as=0.65p ps=3.02u w=2.5u l=1u
X255 xl0.xpre.fa vref xl0.xpre.tp xl0.xpre.tp pfet_03v3 ad=1.248p pd=5.32u as=1.248p ps=5.32u w=4.8u l=0.4u
X256 xl1.xpre.tp xl1.gp xl1.xpre.fa xl1.xpre.tp pfet_03v3 ad=1.248p pd=5.32u as=1.248p ps=5.32u w=4.8u l=0.4u
X257 xl1.xpre.tp xl1.gp xl1.xpre.fa xl1.xpre.tp pfet_03v3 ad=1.248p pd=5.32u as=1.248p ps=5.32u w=4.8u l=0.4u
X258 xl2.xpre.tp vref xl2.xpre.fa xl2.xpre.tp pfet_03v3 ad=1.248p pd=5.32u as=1.248p ps=5.32u w=4.8u l=0.4u
X259 RX1_O xl1.xout.i2 VDD VDD pfet_03v3 ad=1.3p pd=5.52u as=1.3p ps=5.52u w=5u l=0.28u
X260 xl1.xout.n3a VDD VDD VDD pfet_03v3 ad=0.52p pd=2.52u as=0.88p ps=4.88u w=2u l=0.4u
X261 xl2.d2b VSS VSS VSS nfet_03v3 ad=1.0036p pd=4.38u as=1.6984p ps=8.6u w=3.86u l=0.5u
X262 xl0.xpre.tp xl0.gn xl0.xpre.fb xl0.xpre.tp pfet_03v3 ad=1.248p pd=5.32u as=1.248p ps=5.32u w=4.8u l=0.4u
X263 xl1.xpre.fa xl1.gp xl1.xpre.tp xl1.xpre.tp pfet_03v3 ad=1.248p pd=5.32u as=1.248p ps=5.32u w=4.8u l=0.4u
X264 xbias.nmid xbias.rdb_m3 VSS ppolyf_u_1k r_width=2u r_length=19.26u
X265 xl0.d2a xl0.oa xl0.xhyst.sa VSS nfet_03v3 ad=1.0036p pd=4.38u as=1.0036p ps=4.38u w=3.86u l=0.5u
X266 xl2.d2a xl2.d2b VDD VDD pfet_03v3 ad=0.52p pd=2.52u as=0.52p ps=2.52u w=2u l=0.4u
X267 xl2.xpre.tn vref xl2.oa VSS nfet_03v3 ad=1.235p pd=5.27u as=1.235p ps=5.27u w=4.75u l=0.5u
X268 xl2.xout.nd VDD VDD VDD pfet_03v3 ad=0.78p pd=3.52u as=1.32p ps=6.88u w=3u l=0.28u
X269 VDD xl2.d2b xl2.xout.d3 VDD pfet_03v3 ad=0.52p pd=2.52u as=0.52p ps=2.52u w=2u l=0.4u
X270 xl0.xpre.fa xl0.gp xl0.xpre.tp xl0.xpre.tp pfet_03v3 ad=1.248p pd=5.32u as=1.248p ps=5.32u w=4.8u l=0.4u
X271 VDD xl2.d2a xl2.d2b VDD pfet_03v3 ad=0.52p pd=2.52u as=0.52p ps=2.52u w=2u l=0.4u
X272 VSS xl0.xout.n3a xl0.xout.n3a VSS nfet_03v3 ad=0.6734p pd=3.11u as=0.6734p ps=3.11u w=2.59u l=0.28u
X273 xl2.xpre.fb vb2 xl2.ob VSS nfet_03v3 ad=1.1752p pd=5.04u as=1.1752p ps=5.04u w=4.52u l=0.5u
X274 xl0.ob vref xl0.xpre.tn VSS nfet_03v3 ad=2.09p pd=10.38u as=1.235p ps=5.27u w=4.75u l=0.5u
X275 xl1.xpre.tn xl1.gn xl1.ob VSS nfet_03v3 ad=1.235p pd=5.27u as=1.235p ps=5.27u w=4.75u l=0.5u
X276 xl1.xout.i2 VSS VSS VSS nfet_03v3 ad=0.78p pd=3.52u as=1.32p ps=6.88u w=3u l=0.28u
X277 VDD vbp xl0.xpre.tp VDD pfet_03v3 ad=1.3p pd=5.52u as=1.3p ps=5.52u w=5u l=1u
X278 xl1.xpre.tp vref xl1.xpre.fb xl1.xpre.tp pfet_03v3 ad=1.248p pd=5.32u as=1.248p ps=5.32u w=4.8u l=0.4u
X279 xl2.xpre.fa xl2.gp xl2.xpre.tp xl2.xpre.tp pfet_03v3 ad=1.248p pd=5.32u as=1.248p ps=5.32u w=4.8u l=0.4u
X280 xl0.oa vb2 xl0.xpre.fa VSS nfet_03v3 ad=1.1752p pd=5.04u as=1.1752p ps=5.04u w=4.52u l=0.5u
X281 VSS vbn xl0.xpre.fb VSS nfet_03v3 ad=0.65p pd=3.02u as=0.65p ps=3.02u w=2.5u l=1u
X282 RX1_O VSS VSS VSS nfet_03v3 ad=1.04p pd=4.52u as=1.76p ps=8.88u w=4u l=0.28u
X283 VSS VSS xl0.xpre.fb VSS nfet_03v3 ad=1.9888p pd=9.92u as=1.1752p ps=5.04u w=4.52u l=0.5u
X284 VSS VSS VSS VSS nfet_03v3 ad=0.39p pd=2.02u as=0 ps=0 w=1.5u l=0.28u
X285 VDD vbp xl1.xpre.tp VDD pfet_03v3 ad=1.3p pd=5.52u as=1.3p ps=5.52u w=5u l=1u
X286 xbias.rb_m1 xbias.rb_m2 VSS ppolyf_u_1k r_width=2u r_length=22.27u
X287 VDD EN vbp VDD pfet_03v3 ad=0.52p pd=2.52u as=0.52p ps=2.52u w=2u l=0.5u
X288 VDD VDD VDD VDD pfet_03v3 ad=0.52p pd=2.52u as=0 ps=0 w=2u l=0.5u
X289 xl2.oa xl2.rla_m1 VSS ppolyf_u_1k r_width=2u r_length=9.11u
X290 VDD vbp xl0.xpre.tp VDD pfet_03v3 ad=1.3p pd=5.52u as=1.3p ps=5.52u w=5u l=1u
X291 xl2.xpre.tp vref xl2.xpre.fa xl2.xpre.tp pfet_03v3 ad=1.248p pd=5.32u as=1.248p ps=5.32u w=4.8u l=0.4u
X292 xl1.d2b xl1.d2a VDD VDD pfet_03v3 ad=0.52p pd=2.52u as=0.52p ps=2.52u w=2u l=0.4u
X293 VDD VDD VDD VDD pfet_03v3 ad=0.52p pd=2.52u as=0 ps=0 w=2u l=0.5u
X294 VDD EN xl0.d2a VDD pfet_03v3 ad=0.52p pd=2.52u as=0.52p ps=2.52u w=2u l=0.5u
X295 xl0.oa VSS VSS VSS nfet_03v3 ad=1.1752p pd=5.04u as=1.9888p ps=9.92u w=4.52u l=0.5u
X296 xl2.xpre.tp vref xl2.xpre.fb xl2.xpre.tp pfet_03v3 ad=1.248p pd=5.32u as=1.248p ps=5.32u w=4.8u l=0.4u
X297 VSS VSS VSS VSS nfet_03v3 ad=0.78p pd=3.52u as=0 ps=0 w=3u l=0.28u
X298 VSS vbn vbp VSS nfet_03v3 ad=0.65p pd=3.02u as=0.65p ps=3.02u w=2.5u l=1u
X299 xl0.xhyst.ts vbn VSS VSS nfet_03v3 ad=0.65p pd=3.02u as=0.65p ps=3.02u w=2.5u l=1u
X300 xl2.d2a VDD VDD VDD pfet_03v3 ad=0.52p pd=2.52u as=0.88p ps=4.88u w=2u l=0.5u
X301 xl0.xpre.tp xl0.gn xl0.xpre.fb xl0.xpre.tp pfet_03v3 ad=1.248p pd=5.32u as=1.248p ps=5.32u w=4.8u l=0.4u
X302 xl2.xpre.fa vref xl2.xpre.tp xl2.xpre.tp pfet_03v3 ad=1.248p pd=5.32u as=1.248p ps=5.32u w=4.8u l=0.4u
X303 VDD xl1.xout.i2 RX1_O VDD pfet_03v3 ad=1.3p pd=5.52u as=1.3p ps=5.52u w=5u l=0.28u
X304 xl1.xpre.fb vref xl1.xpre.tp xl1.xpre.tp pfet_03v3 ad=1.248p pd=5.32u as=1.248p ps=5.32u w=4.8u l=0.4u
X305 xl0.oa xl0.gp xl0.xpre.tn VSS nfet_03v3 ad=1.235p pd=5.27u as=1.235p ps=5.27u w=4.75u l=0.5u
X306 xl1.xpre.tn vref xl1.oa VSS nfet_03v3 ad=1.235p pd=5.27u as=1.235p ps=5.27u w=4.75u l=0.5u
X307 VDD xl0.d2a xl0.xout.n3a VDD pfet_03v3 ad=0.52p pd=2.52u as=0.52p ps=2.52u w=2u l=0.4u
X308 xl1.xpre.tp vref xl1.xpre.fb xl1.xpre.tp pfet_03v3 ad=1.248p pd=5.32u as=1.248p ps=5.32u w=4.8u l=0.4u
X309 VDD VDD xl2.xout.nd VDD pfet_03v3 ad=1.32p pd=6.88u as=0.78p ps=3.52u w=3u l=0.28u
X310 xl2.d2b xl2.d2a VDD VDD pfet_03v3 ad=0.52p pd=2.52u as=0.52p ps=2.52u w=2u l=0.4u
X311 xl0.xpre.fa xl0.gp xl0.xpre.tp xl0.xpre.tp pfet_03v3 ad=1.248p pd=5.32u as=1.248p ps=5.32u w=4.8u l=0.4u
X312 xl2.xpre.tp xl2.gn xl2.xpre.fb xl2.xpre.tp pfet_03v3 ad=1.248p pd=5.32u as=1.248p ps=5.32u w=4.8u l=0.4u
X313 xl0.ob xl0.gn xl0.xpre.tn VSS nfet_03v3 ad=1.235p pd=5.27u as=1.235p ps=5.27u w=4.75u l=0.5u
X314 xl0.xpre.tp vbp VDD VDD pfet_03v3 ad=1.3p pd=5.52u as=1.3p ps=5.52u w=5u l=1u
X315 VDD xl2.d2a xl2.xout.n3a VDD pfet_03v3 ad=0.52p pd=2.52u as=0.52p ps=2.52u w=2u l=0.4u
X316 VDD VDD xl1.xout.n3a VDD pfet_03v3 ad=0.88p pd=4.88u as=0.52p ps=2.52u w=2u l=0.4u
X317 VDD xl2.xout.i1 xl2.xout.i2 VDD pfet_03v3 ad=0.975p pd=4.27u as=0.975p ps=4.27u w=3.75u l=0.28u
X318 xl1.gp RX1_P VDD ppolyf_u r_width=5u r_length=1.8u
X319 xl0.ob vref xl0.xpre.tn VSS nfet_03v3 ad=1.235p pd=5.27u as=1.235p ps=5.27u w=4.75u l=0.5u
X320 VSS vbn xl0.xpre.fa VSS nfet_03v3 ad=0.65p pd=3.02u as=0.65p ps=3.02u w=2.5u l=1u
X321 xl2.ob xl2.gn xl2.xpre.tn VSS nfet_03v3 ad=1.235p pd=5.27u as=1.235p ps=5.27u w=4.75u l=0.5u
X322 xl1.xpre.tp vbp VDD VDD pfet_03v3 ad=1.3p pd=5.52u as=1.3p ps=5.52u w=5u l=1u
X323 xl0.xpre.fa vref xl0.xpre.tp xl0.xpre.tp pfet_03v3 ad=1.248p pd=5.32u as=1.248p ps=5.32u w=4.8u l=0.4u
X324 xl1.xpre.fa vref xl1.xpre.tp xl1.xpre.tp pfet_03v3 ad=1.248p pd=5.32u as=1.248p ps=5.32u w=4.8u l=0.4u
X325 xl1.d2a xl1.d2a VDD VDD pfet_03v3 ad=0.52p pd=2.52u as=0.52p ps=2.52u w=2u l=0.4u
X326 xl1.xpre.tp xl1.gp xl1.xpre.fa xl1.xpre.tp pfet_03v3 ad=1.248p pd=5.32u as=1.248p ps=5.32u w=4.8u l=0.4u
X327 VSS vbn xl0.xpre.tn VSS nfet_03v3 ad=0.65p pd=3.02u as=0.65p ps=3.02u w=2.5u l=1u
X328 xl2.xhyst.ts VSS VSS VSS nfet_03v3 ad=0.65p pd=3.02u as=1.1p ps=5.88u w=2.5u l=1u
X329 VSS VSS xl1.xpre.fa VSS nfet_03v3 ad=1.1p pd=5.88u as=0.65p ps=3.02u w=2.5u l=1u
X330 VDD xl1.d2b xl1.d2b VDD pfet_03v3 ad=0.52p pd=2.52u as=0.52p ps=2.52u w=2u l=0.4u
X331 xl2.ob xl2.gn xl2.xpre.tn VSS nfet_03v3 ad=1.235p pd=5.27u as=1.235p ps=5.27u w=4.75u l=0.5u
X332 VSS xl0.xout.i2 RX0_O VSS nfet_03v3 ad=1.04p pd=4.52u as=1.04p ps=4.52u w=4u l=0.28u
X333 VSS xl0.xout.i1 xl0.xout.i2 VSS nfet_03v3 ad=0.78p pd=3.52u as=0.78p ps=3.52u w=3u l=0.28u
X334 VDD xl1.d2b xl1.xout.d3 VDD pfet_03v3 ad=0.52p pd=2.52u as=0.52p ps=2.52u w=2u l=0.4u
X335 xl0.xpre.tn xl0.gn xl0.ob VSS nfet_03v3 ad=1.235p pd=5.27u as=1.235p ps=5.27u w=4.75u l=0.5u
X336 xbias.nrb xbias.enb VDD VDD pfet_03v3 ad=1.3p pd=5.52u as=1.3p ps=5.52u w=5u l=0.5u
X337 xl2.oa xl2.gp xl2.xpre.tn VSS nfet_03v3 ad=1.235p pd=5.27u as=1.235p ps=5.27u w=4.75u l=0.5u
X338 xl1.xpre.fa vref xl1.xpre.tp xl1.xpre.tp pfet_03v3 ad=1.248p pd=5.32u as=1.248p ps=5.32u w=4.8u l=0.4u
X339 xl1.oa vb2 xl1.xpre.fa VSS nfet_03v3 ad=1.1752p pd=5.04u as=1.1752p ps=5.04u w=4.52u l=0.5u
X340 xl0.xpre.fb xl0.gn xl0.xpre.tp xl0.xpre.tp pfet_03v3 ad=1.248p pd=5.32u as=1.248p ps=5.32u w=4.8u l=0.4u
X341 xl0.xpre.tn xl0.gp xl0.oa VSS nfet_03v3 ad=1.235p pd=5.27u as=1.235p ps=5.27u w=4.75u l=0.5u
X342 xl2.xpre.tp xl2.gp xl2.xpre.fa xl2.xpre.tp pfet_03v3 ad=1.248p pd=5.32u as=1.248p ps=5.32u w=4.8u l=0.4u
X343 xbias.nrb xbias.enb VDD VDD pfet_03v3 ad=1.3p pd=5.52u as=1.3p ps=5.52u w=5u l=0.5u
X344 xl1.xpre.fa vref xl1.xpre.tp xl1.xpre.tp pfet_03v3 ad=1.248p pd=5.32u as=1.248p ps=5.32u w=4.8u l=0.4u
X345 xl2.xpre.fa xl2.gp xl2.xpre.tp xl2.xpre.tp pfet_03v3 ad=1.248p pd=5.32u as=1.248p ps=5.32u w=4.8u l=0.4u
X346 xl0.xhyst.ts vbn VSS VSS nfet_03v3 ad=0.65p pd=3.02u as=0.65p ps=3.02u w=2.5u l=1u
X347 VDD vbp xl0.xpre.tp VDD pfet_03v3 ad=1.3p pd=5.52u as=1.3p ps=5.52u w=5u l=1u
D3 xl0.gn VDD diode_pd2nw_03v3 pj=26u area=40p
X348 VSS xl2.xout.i1 xl2.xout.i2 VSS nfet_03v3 ad=0.78p pd=3.52u as=0.78p ps=3.52u w=3u l=0.28u
X349 VSS xl2.xout.i2 RX2_O VSS nfet_03v3 ad=1.04p pd=4.52u as=1.04p ps=4.52u w=4u l=0.28u
X350 xl0.xpre.fb vref xl0.xpre.tp xl0.xpre.tp pfet_03v3 ad=2.112p pd=10.48u as=1.248p ps=5.32u w=4.8u l=0.4u
X351 xl2.xpre.fa xl2.gp xl2.xpre.tp xl2.xpre.tp pfet_03v3 ad=1.248p pd=5.32u as=1.248p ps=5.32u w=4.8u l=0.4u
X352 xl2.xpre.tp xl2.gn xl2.xpre.fb xl2.xpre.tp pfet_03v3 ad=1.248p pd=5.32u as=1.248p ps=5.32u w=4.8u l=0.4u
X353 xbias.nrb xbias.enb VDD VDD pfet_03v3 ad=1.3p pd=5.52u as=1.3p ps=5.52u w=5u l=0.5u
X354 RX0_O xl0.xout.i2 VDD VDD pfet_03v3 ad=1.3p pd=5.52u as=1.3p ps=5.52u w=5u l=0.28u
X355 xl1.xout.d3 xl1.d2b VDD VDD pfet_03v3 ad=0.52p pd=2.52u as=0.52p ps=2.52u w=2u l=0.4u
X356 xl1.xpre.tn vref xl1.ob VSS nfet_03v3 ad=1.235p pd=5.27u as=1.235p ps=5.27u w=4.75u l=0.5u
X357 xl1.d2b xl1.d2a VDD VDD pfet_03v3 ad=0.52p pd=2.52u as=0.52p ps=2.52u w=2u l=0.4u
X358 xl0.xpre.fb vbn VSS VSS nfet_03v3 ad=0.65p pd=3.02u as=0.65p ps=3.02u w=2.5u l=1u
X359 xl1.ob xl1.gn xl1.xpre.tn VSS nfet_03v3 ad=1.235p pd=5.27u as=1.235p ps=5.27u w=4.75u l=0.5u
X360 xl2.xpre.tn vref xl2.ob VSS nfet_03v3 ad=1.235p pd=5.27u as=1.235p ps=5.27u w=4.75u l=0.5u
X361 xl0.xpre.fb vref xl0.xpre.tp xl0.xpre.tp pfet_03v3 ad=1.248p pd=5.32u as=1.248p ps=5.32u w=4.8u l=0.4u
X362 xl1.xpre.fa vbn VSS VSS nfet_03v3 ad=0.65p pd=3.02u as=0.65p ps=3.02u w=2.5u l=1u
X363 xl0.xpre.tn vbn VSS VSS nfet_03v3 ad=0.65p pd=3.02u as=0.65p ps=3.02u w=2.5u l=1u
X364 VDD xl1.xout.nd xl1.xout.i1 VDD pfet_03v3 ad=0.962p pd=4.22u as=0.962p ps=4.22u w=3.7u l=0.28u
X365 VSS vbn xl2.xhyst.ts VSS nfet_03v3 ad=0.65p pd=3.02u as=0.65p ps=3.02u w=2.5u l=1u
X366 xl0.xpre.tp vbp VDD VDD pfet_03v3 ad=1.3p pd=5.52u as=1.3p ps=5.52u w=5u l=1u
X367 xl1.xpre.fb vb2 xl1.ob VSS nfet_03v3 ad=1.1752p pd=5.04u as=1.1752p ps=5.04u w=4.52u l=0.5u
X368 xl0.xhyst.sb xl0.ob xl0.d2b VSS nfet_03v3 ad=1.0036p pd=4.38u as=1.0036p ps=4.38u w=3.86u l=0.5u
X369 xl2.xpre.fa xl2.gp xl2.xpre.tp xl2.xpre.tp pfet_03v3 ad=1.248p pd=5.32u as=1.248p ps=5.32u w=4.8u l=0.4u
X370 VSS vbn xl0.xpre.fb VSS nfet_03v3 ad=0.65p pd=3.02u as=0.65p ps=3.02u w=2.5u l=1u
X371 xl1.xpre.tn vbn VSS VSS nfet_03v3 ad=0.65p pd=3.02u as=0.65p ps=3.02u w=2.5u l=1u
X372 VDD xl0.d2a xl0.d2a VDD pfet_03v3 ad=0.52p pd=2.52u as=0.52p ps=2.52u w=2u l=0.4u
X373 xl1.xpre.tp vbp VDD VDD pfet_03v3 ad=1.3p pd=5.52u as=1.3p ps=5.52u w=5u l=1u
X374 xl0.xpre.fb xl0.gn xl0.xpre.tp xl0.xpre.tp pfet_03v3 ad=1.248p pd=5.32u as=1.248p ps=5.32u w=4.8u l=0.4u
X375 RX2_O xl2.xout.i2 VDD VDD pfet_03v3 ad=1.3p pd=5.52u as=1.3p ps=5.52u w=5u l=0.28u
X376 VDD vbp vbp VDD pfet_03v3 ad=1.3p pd=5.52u as=1.3p ps=5.52u w=5u l=1u
X377 VSS vbn xl0.xhyst.ts VSS nfet_03v3 ad=0.65p pd=3.02u as=0.65p ps=3.02u w=2.5u l=1u
X378 xl0.xout.i2 VSS VSS VSS nfet_03v3 ad=0.78p pd=3.52u as=1.32p ps=6.88u w=3u l=0.28u
X379 VDD xl0.d2a xl0.xout.n3a VDD pfet_03v3 ad=0.52p pd=2.52u as=0.52p ps=2.52u w=2u l=0.4u
X380 xl1.xhyst.sa xl1.oa xl1.d2a VSS nfet_03v3 ad=1.0036p pd=4.38u as=1.0036p ps=4.38u w=3.86u l=0.5u
D4 VSS xl0.gn diode_nd2ps_03v3 pj=26u area=40p
X381 RX0_O VSS VSS VSS nfet_03v3 ad=1.04p pd=4.52u as=1.76p ps=8.88u w=4u l=0.28u
X382 VSS VSS VSS VSS nfet_03v3 ad=0.39p pd=2.02u as=0 ps=0 w=1.5u l=0.28u
X383 xl0.xout.n3a xl0.d2a VDD VDD pfet_03v3 ad=0.52p pd=2.52u as=0.52p ps=2.52u w=2u l=0.4u
X384 xl1.oa vref xl1.xpre.tn VSS nfet_03v3 ad=1.235p pd=5.27u as=1.235p ps=5.27u w=4.75u l=0.5u
X385 xl0.xout.i2 VDD VDD VDD pfet_03v3 ad=0.975p pd=4.27u as=1.65p ps=8.38u w=3.75u l=0.28u
X386 VDD xl2.d2b xl2.d2a VDD pfet_03v3 ad=0.52p pd=2.52u as=0.52p ps=2.52u w=2u l=0.4u
X387 xl2.xpre.fb vbn VSS VSS nfet_03v3 ad=0.65p pd=3.02u as=0.65p ps=3.02u w=2.5u l=1u
X388 VSS VSS VSS VSS nfet_03v3 ad=0.78p pd=3.52u as=0 ps=0 w=3u l=0.28u
X389 VSS VSS VSS ppolyf_u_1k r_width=2u r_length=9.11u
X390 xl0.xpre.fb vref xl0.xpre.tp xl0.xpre.tp pfet_03v3 ad=1.248p pd=5.32u as=1.248p ps=5.32u w=4.8u l=0.4u
X391 xl1.xpre.fb vref xl1.xpre.tp xl1.xpre.tp pfet_03v3 ad=1.248p pd=5.32u as=1.248p ps=5.32u w=4.8u l=0.4u
X392 xl2.xpre.fa vbn VSS VSS nfet_03v3 ad=0.65p pd=3.02u as=0.65p ps=3.02u w=2.5u l=1u
X393 xl2.xout.i1 VDD VDD VDD pfet_03v3 ad=0.962p pd=4.22u as=1.628p ps=8.28u w=3.7u l=0.28u
X394 VDD vbp xl0.xpre.tp VDD pfet_03v3 ad=1.3p pd=5.52u as=1.3p ps=5.52u w=5u l=1u
X395 xl0.xpre.fa vref xl0.xpre.tp xl0.xpre.tp pfet_03v3 ad=1.248p pd=5.32u as=1.248p ps=5.32u w=4.8u l=0.4u
X396 VSS VSS xl1.xhyst.ts VSS nfet_03v3 ad=1.1p pd=5.88u as=0.65p ps=3.02u w=2.5u l=1u
X397 xl2.xout.i2 VSS VSS VSS nfet_03v3 ad=0.78p pd=3.52u as=1.32p ps=6.88u w=3u l=0.28u
X398 RX2_O VSS VSS VSS nfet_03v3 ad=1.04p pd=4.52u as=1.76p ps=8.88u w=4u l=0.28u
X399 vbp vbn VSS VSS nfet_03v3 ad=0.65p pd=3.02u as=0.65p ps=3.02u w=2.5u l=1u
X400 xl2.xpre.tp vbp VDD VDD pfet_03v3 ad=1.3p pd=5.52u as=1.3p ps=5.52u w=5u l=1u
X401 xl1.xpre.tp xl1.gp xl1.xpre.fa xl1.xpre.tp pfet_03v3 ad=1.248p pd=5.32u as=1.248p ps=5.32u w=4.8u l=0.4u
X402 xl2.xpre.tp xl2.gp xl2.xpre.fa xl2.xpre.tp pfet_03v3 ad=1.248p pd=5.32u as=1.248p ps=5.32u w=4.8u l=0.4u
X403 VDD xl0.xout.i2 RX0_O VDD pfet_03v3 ad=1.3p pd=5.52u as=1.3p ps=5.52u w=5u l=0.28u
X404 xl0.xout.n3a xl0.d2a VDD VDD pfet_03v3 ad=0.52p pd=2.52u as=0.52p ps=2.52u w=2u l=0.4u
X405 VSS VSS xl0.xpre.fa VSS nfet_03v3 ad=1.9888p pd=9.92u as=1.1752p ps=5.04u w=4.52u l=0.5u
X406 VDD VDD xl1.d2b VDD pfet_03v3 ad=0.88p pd=4.88u as=0.52p ps=2.52u w=2u l=0.4u
X407 VSS vbn xl1.xpre.fa VSS nfet_03v3 ad=0.65p pd=3.02u as=0.65p ps=3.02u w=2.5u l=1u
X408 VSS VSS VSS VSS nfet_03v3 ad=0.78p pd=3.52u as=0 ps=0 w=3u l=0.28u
X409 xbias.rdt_m2 xbias.rdt_m1 VSS ppolyf_u_1k r_width=2u r_length=21.01u
X410 xl0.xpre.tp vref xl0.xpre.fb xl0.xpre.tp pfet_03v3 ad=1.248p pd=5.32u as=1.248p ps=5.32u w=4.8u l=0.4u
X411 xl2.xpre.fa vb2 xl2.oa VSS nfet_03v3 ad=1.1752p pd=5.04u as=1.1752p ps=5.04u w=4.52u l=0.5u
X412 VDD xl2.d2b xl2.d2a VDD pfet_03v3 ad=0.52p pd=2.52u as=0.52p ps=2.52u w=2u l=0.4u
X413 VSS VSS VSS ppolyf_u_1k r_width=2u r_length=8.86u
X414 xl0.xpre.fa xl0.gp xl0.xpre.tp xl0.xpre.tp pfet_03v3 ad=1.248p pd=5.32u as=1.248p ps=5.32u w=4.8u l=0.4u
X415 xl0.oa vb2 xl0.xpre.fa VSS nfet_03v3 ad=1.1752p pd=5.04u as=1.1752p ps=5.04u w=4.52u l=0.5u
X416 VSS vbn xl2.xpre.fb VSS nfet_03v3 ad=0.65p pd=3.02u as=0.65p ps=3.02u w=2.5u l=1u
X417 VSS VSS xl1.xpre.tn VSS nfet_03v3 ad=1.1p pd=5.88u as=0.65p ps=3.02u w=2.5u l=1u
X418 VDD xl2.rla_m1 VSS ppolyf_u_1k r_width=2u r_length=9.11u
X419 VDD vbp xl1.xpre.tp VDD pfet_03v3 ad=1.3p pd=5.52u as=1.3p ps=5.52u w=5u l=1u
X420 xl2.xpre.tp vref xl2.xpre.fa xl2.xpre.tp pfet_03v3 ad=1.248p pd=5.32u as=1.248p ps=5.32u w=4.8u l=0.4u
X421 VSS vbn xl0.xpre.fa VSS nfet_03v3 ad=0.65p pd=3.02u as=0.65p ps=3.02u w=2.5u l=1u
X422 VDD xl2.xout.i2 RX2_O VDD pfet_03v3 ad=1.3p pd=5.52u as=1.3p ps=5.52u w=5u l=0.28u
X423 xl1.xout.n3a VSS VSS VSS nfet_03v3 ad=0.6734p pd=3.11u as=1.1396p ps=6.06u w=2.59u l=0.28u
X424 xl1.xpre.tp xl1.gn xl1.xpre.fb xl1.xpre.tp pfet_03v3 ad=1.248p pd=5.32u as=1.248p ps=5.32u w=4.8u l=0.4u
X425 xl0.d2b VDD VDD VDD pfet_03v3 ad=0.52p pd=2.52u as=0.88p ps=4.88u w=2u l=0.5u
X426 xl2.xpre.fa vb2 xl2.oa VSS nfet_03v3 ad=1.1752p pd=5.04u as=1.1752p ps=5.04u w=4.52u l=0.5u
X427 xl0.xout.d3 xl0.d2b VDD VDD pfet_03v3 ad=0.52p pd=2.52u as=0.52p ps=2.52u w=2u l=0.4u
X428 VDD xl2.d2a xl2.d2b VDD pfet_03v3 ad=0.52p pd=2.52u as=0.52p ps=2.52u w=2u l=0.4u
X429 VDD xl2.rlb_m1 VSS ppolyf_u_1k r_width=2u r_length=9.11u
X430 xl0.xpre.tp xl0.gp xl0.xpre.fa xl0.xpre.tp pfet_03v3 ad=1.248p pd=5.32u as=1.248p ps=5.32u w=4.8u l=0.4u
X431 xl2.xpre.fa xl2.gp xl2.xpre.tp xl2.xpre.tp pfet_03v3 ad=1.248p pd=5.32u as=1.248p ps=5.32u w=4.8u l=0.4u
X432 xl2.xpre.fa VSS VSS VSS nfet_03v3 ad=0.65p pd=3.02u as=1.1p ps=5.88u w=2.5u l=1u
X433 xbias.rb_m3 xbias.rb_m2 VSS ppolyf_u_1k r_width=2u r_length=22.27u
X434 xl2.xpre.fb vbn VSS VSS nfet_03v3 ad=0.65p pd=3.02u as=0.65p ps=3.02u w=2.5u l=1u
X435 xl1.xpre.tn vref xl1.ob VSS nfet_03v3 ad=1.235p pd=5.27u as=2.09p ps=10.38u w=4.75u l=0.5u
X436 xl1.xpre.tn vref xl1.oa VSS nfet_03v3 ad=1.235p pd=5.27u as=1.235p ps=5.27u w=4.75u l=0.5u
X437 xl2.xhyst.ts xl2.xhyst.sb VSS ppolyf_u_1k r_width=2u r_length=8.86u
X438 xl2.xpre.tp vbp VDD VDD pfet_03v3 ad=1.3p pd=5.52u as=1.3p ps=5.52u w=5u l=1u
X439 xl1.xpre.fb xl1.gn xl1.xpre.tp xl1.xpre.tp pfet_03v3 ad=1.248p pd=5.32u as=1.248p ps=5.32u w=4.8u l=0.4u
X440 xl0.oa xl0.gp xl0.xpre.tn VSS nfet_03v3 ad=1.235p pd=5.27u as=1.235p ps=5.27u w=4.75u l=0.5u
X441 xl1.xout.i2 xl1.xout.i1 VDD VDD pfet_03v3 ad=0.975p pd=4.27u as=0.975p ps=4.27u w=3.75u l=0.28u
X442 VDD VDD xl0.xpre.tp VDD pfet_03v3 ad=2.2p pd=10.88u as=1.3p ps=5.52u w=5u l=1u
X443 xl1.xpre.tp vref xl1.xpre.fb xl1.xpre.tp pfet_03v3 ad=1.248p pd=5.32u as=1.248p ps=5.32u w=4.8u l=0.4u
D5 xl2.gp VDD diode_pd2nw_03v3 pj=26u area=40p
X444 xl2.xpre.tp vref xl2.xpre.fb xl2.xpre.tp pfet_03v3 ad=1.248p pd=5.32u as=1.248p ps=5.32u w=4.8u l=0.4u
X445 VDD xl0.xout.d3 xl0.xout.nd VDD pfet_03v3 ad=0.78p pd=3.52u as=0.78p ps=3.52u w=3u l=0.28u
X446 VDD xl2.d2b xl2.xout.d3 VDD pfet_03v3 ad=0.52p pd=2.52u as=0.52p ps=2.52u w=2u l=0.4u
X447 xl2.xpre.tn xl2.gn xl2.ob VSS nfet_03v3 ad=1.235p pd=5.27u as=1.235p ps=5.27u w=4.75u l=0.5u
X448 VDD xl2.d2b xl2.d2b VDD pfet_03v3 ad=0.52p pd=2.52u as=0.52p ps=2.52u w=2u l=0.4u
X449 VSS VSS xl1.xout.d3 VSS nfet_03v3 ad=1.1396p pd=6.06u as=0.6734p ps=3.11u w=2.59u l=0.28u
X450 xl0.xpre.fb xl0.gn xl0.xpre.tp xl0.xpre.tp pfet_03v3 ad=1.248p pd=5.32u as=1.248p ps=5.32u w=4.8u l=0.4u
X451 xl2.xpre.fa vbn VSS VSS nfet_03v3 ad=0.65p pd=3.02u as=0.65p ps=3.02u w=2.5u l=1u
X452 xl0.ob vref xl0.xpre.tn VSS nfet_03v3 ad=1.235p pd=5.27u as=1.235p ps=5.27u w=4.75u l=0.5u
X453 vbp vbp VDD VDD pfet_03v3 ad=1.3p pd=5.52u as=1.3p ps=5.52u w=5u l=1u
X454 xl0.xpre.fb vbn VSS VSS nfet_03v3 ad=0.65p pd=3.02u as=0.65p ps=3.02u w=2.5u l=1u
X455 VSS vbn xl1.xpre.tn VSS nfet_03v3 ad=0.65p pd=3.02u as=0.65p ps=3.02u w=2.5u l=1u
X456 xl2.oa xl2.gp xl2.xpre.tn VSS nfet_03v3 ad=1.235p pd=5.27u as=1.235p ps=5.27u w=4.75u l=0.5u
X457 xl2.xpre.tp vbp VDD VDD pfet_03v3 ad=1.3p pd=5.52u as=1.3p ps=5.52u w=5u l=1u
X458 xl0.xpre.tp xl0.gp xl0.xpre.fa xl0.xpre.tp pfet_03v3 ad=1.248p pd=5.32u as=1.248p ps=5.32u w=4.8u l=0.4u
X459 xl0.xpre.tp xl0.gp xl0.xpre.fa xl0.xpre.tp pfet_03v3 ad=1.248p pd=5.32u as=1.248p ps=5.32u w=4.8u l=0.4u
X460 xl1.xpre.tp vref xl1.xpre.fa xl1.xpre.tp pfet_03v3 ad=1.248p pd=5.32u as=1.248p ps=5.32u w=4.8u l=0.4u
X461 xl2.xpre.tn vref xl2.oa VSS nfet_03v3 ad=1.235p pd=5.27u as=1.235p ps=5.27u w=4.75u l=0.5u
X462 xl0.xout.n3a VDD VDD VDD pfet_03v3 ad=0.52p pd=2.52u as=0.88p ps=4.88u w=2u l=0.4u
X463 xl0.xpre.fa xl0.gp xl0.xpre.tp xl0.xpre.tp pfet_03v3 ad=1.248p pd=5.32u as=1.248p ps=5.32u w=4.8u l=0.4u
X464 xl1.xpre.tp vref xl1.xpre.fa xl1.xpre.tp pfet_03v3 ad=1.248p pd=5.32u as=1.248p ps=5.32u w=4.8u l=0.4u
X465 VSS vbn xl2.xpre.fa VSS nfet_03v3 ad=0.65p pd=3.02u as=0.65p ps=3.02u w=2.5u l=1u
X466 VSS vbn vbn VSS nfet_03v3 ad=0.65p pd=3.02u as=0.65p ps=3.02u w=2.5u l=1u
X467 VSS vbn xl2.xpre.fb VSS nfet_03v3 ad=0.65p pd=3.02u as=0.65p ps=3.02u w=2.5u l=1u
X468 VSS vbn xl2.xpre.tn VSS nfet_03v3 ad=0.65p pd=3.02u as=0.65p ps=3.02u w=2.5u l=1u
X469 xl1.xout.nd VDD VDD VDD pfet_03v3 ad=0.78p pd=3.52u as=1.32p ps=6.88u w=3u l=0.28u
X470 xl2.xout.d3 xl2.xout.n3a VSS VSS nfet_03v3 ad=0.6734p pd=3.11u as=0.6734p ps=3.11u w=2.59u l=0.28u
X471 VDD xl1.d2b xl1.xout.d3 VDD pfet_03v3 ad=0.52p pd=2.52u as=0.52p ps=2.52u w=2u l=0.4u
X472 xl0.xpre.tn xl0.gn xl0.ob VSS nfet_03v3 ad=1.235p pd=5.27u as=1.235p ps=5.27u w=4.75u l=0.5u
X473 xl1.xhyst.ts vbn VSS VSS nfet_03v3 ad=0.65p pd=3.02u as=0.65p ps=3.02u w=2.5u l=1u
X474 VSS VSS VSS VSS nfet_03v3 ad=0.39p pd=2.02u as=0 ps=0 w=1.5u l=0.28u
X475 VDD xl1.d2a xl1.d2b VDD pfet_03v3 ad=0.52p pd=2.52u as=0.52p ps=2.52u w=2u l=0.4u
X476 VDD vbp xl2.xpre.tp VDD pfet_03v3 ad=1.3p pd=5.52u as=1.3p ps=5.52u w=5u l=1u
X477 xl0.xpre.tp vref xl0.xpre.fb xl0.xpre.tp pfet_03v3 ad=1.248p pd=5.32u as=1.248p ps=5.32u w=4.8u l=0.4u
X478 xl1.xpre.fa xl1.gp xl1.xpre.tp xl1.xpre.tp pfet_03v3 ad=1.248p pd=5.32u as=1.248p ps=5.32u w=4.8u l=0.4u
X479 xl1.d2b xl1.ob xl1.xhyst.sb VSS nfet_03v3 ad=1.0036p pd=4.38u as=1.0036p ps=4.38u w=3.86u l=0.5u
X480 xl1.xpre.tp vref xl1.xpre.fa xl1.xpre.tp pfet_03v3 ad=1.248p pd=5.32u as=1.248p ps=5.32u w=4.8u l=0.4u
X481 xl1.xpre.tn vref xl1.oa VSS nfet_03v3 ad=1.235p pd=5.27u as=1.235p ps=5.27u w=4.75u l=0.5u
X482 VDD vbp xl0.xpre.tp VDD pfet_03v3 ad=1.3p pd=5.52u as=1.3p ps=5.52u w=5u l=1u
X483 VDD VDD VDD VDD pfet_03v3 ad=0.52p pd=2.52u as=0 ps=0 w=2u l=0.5u
X484 VSS VSS xl2.xhyst.sb VSS nfet_03v3 ad=1.6984p pd=8.6u as=1.0036p ps=4.38u w=3.86u l=0.5u
X485 xl1.oa xl1.rla_m1 VSS ppolyf_u_1k r_width=2u r_length=9.11u
X486 xl2.xpre.tp xl2.gp xl2.xpre.fa xl2.xpre.tp pfet_03v3 ad=1.248p pd=5.32u as=1.248p ps=5.32u w=4.8u l=0.4u
X487 xbias.nrb xbias.enb VDD VDD pfet_03v3 ad=1.3p pd=5.52u as=1.3p ps=5.52u w=5u l=0.5u
X488 xl1.d2b xl1.d2b VDD VDD pfet_03v3 ad=0.52p pd=2.52u as=0.52p ps=2.52u w=2u l=0.4u
X489 xl0.d2b xl0.d2a VDD VDD pfet_03v3 ad=0.52p pd=2.52u as=0.52p ps=2.52u w=2u l=0.4u
X490 xl1.xpre.fa vref xl1.xpre.tp xl1.xpre.tp pfet_03v3 ad=1.248p pd=5.32u as=1.248p ps=5.32u w=4.8u l=0.4u
X491 xl1.xpre.fb vb2 xl1.ob VSS nfet_03v3 ad=1.1752p pd=5.04u as=1.1752p ps=5.04u w=4.52u l=0.5u
X492 xl2.xpre.fb vbn VSS VSS nfet_03v3 ad=0.65p pd=3.02u as=0.65p ps=3.02u w=2.5u l=1u
X493 xl1.xpre.tn vref xl1.ob VSS nfet_03v3 ad=1.235p pd=5.27u as=1.235p ps=5.27u w=4.75u l=0.5u
X494 xl2.d2a xl2.d2a VDD VDD pfet_03v3 ad=0.52p pd=2.52u as=0.52p ps=2.52u w=2u l=0.4u
X495 xl1.d2a VDD VDD VDD pfet_03v3 ad=0.52p pd=2.52u as=0.88p ps=4.88u w=2u l=0.5u
X496 VDD EN xl1.d2b VDD pfet_03v3 ad=0.52p pd=2.52u as=0.52p ps=2.52u w=2u l=0.5u
X497 xl1.xpre.fa vref xl1.xpre.tp xl1.xpre.tp pfet_03v3 ad=1.248p pd=5.32u as=1.248p ps=5.32u w=4.8u l=0.4u
X498 VSS vbn xl1.xpre.fa VSS nfet_03v3 ad=0.65p pd=3.02u as=0.65p ps=3.02u w=2.5u l=1u
X499 xl2.xpre.tn vbn VSS VSS nfet_03v3 ad=0.65p pd=3.02u as=0.65p ps=3.02u w=2.5u l=1u
X500 xl2.xpre.tp VDD VDD VDD pfet_03v3 ad=1.3p pd=5.52u as=2.2p ps=10.88u w=5u l=1u
X501 xl1.xpre.fb vb2 xl1.ob VSS nfet_03v3 ad=1.1752p pd=5.04u as=1.1752p ps=5.04u w=4.52u l=0.5u
X502 VDD vbp vbp VDD pfet_03v3 ad=1.3p pd=5.52u as=1.3p ps=5.52u w=5u l=1u
X503 xl0.xpre.tn vref xl0.oa VSS nfet_03v3 ad=1.235p pd=5.27u as=1.235p ps=5.27u w=4.75u l=0.5u
X504 VDD vbp xl1.xpre.tp VDD pfet_03v3 ad=1.3p pd=5.52u as=1.3p ps=5.52u w=5u l=1u
X505 xl0.xpre.fb vref xl0.xpre.tp xl0.xpre.tp pfet_03v3 ad=1.248p pd=5.32u as=1.248p ps=5.32u w=4.8u l=0.4u
X506 xl0.xpre.tp vref xl0.xpre.fb xl0.xpre.tp pfet_03v3 ad=1.248p pd=5.32u as=1.248p ps=5.32u w=4.8u l=0.4u
X507 xl1.xpre.tp vref xl1.xpre.fb xl1.xpre.tp pfet_03v3 ad=1.248p pd=5.32u as=1.248p ps=5.32u w=4.8u l=0.4u
X508 xl1.ob xl1.rlb_m1 VSS ppolyf_u_1k r_width=2u r_length=9.11u
X509 xl2.xpre.tp xl2.gn xl2.xpre.fb xl2.xpre.tp pfet_03v3 ad=1.248p pd=5.32u as=1.248p ps=5.32u w=4.8u l=0.4u
X510 VDD VDD xl1.xout.nd VDD pfet_03v3 ad=1.32p pd=6.88u as=0.78p ps=3.52u w=3u l=0.28u
X511 xl1.gn RX1_N VDD ppolyf_u r_width=5u r_length=1.8u
X512 xl2.xpre.tp vref xl2.xpre.fb xl2.xpre.tp pfet_03v3 ad=1.248p pd=5.32u as=1.248p ps=5.32u w=4.8u l=0.4u
X513 VDD xl1.d2a xl1.xout.n3a VDD pfet_03v3 ad=0.52p pd=2.52u as=0.52p ps=2.52u w=2u l=0.4u
X514 VDD VDD xl0.xout.n3a VDD pfet_03v3 ad=0.88p pd=4.88u as=0.52p ps=2.52u w=2u l=0.4u
X515 xl0.xpre.tp vbp VDD VDD pfet_03v3 ad=1.3p pd=5.52u as=1.3p ps=5.52u w=5u l=1u
X516 xl0.xpre.fa vref xl0.xpre.tp xl0.xpre.tp pfet_03v3 ad=1.248p pd=5.32u as=1.248p ps=5.32u w=4.8u l=0.4u
X517 VSS VSS xbias.nmid VSS nfet_03v3 ad=2.2p pd=10.88u as=1.3p ps=5.52u w=5u l=0.5u
X518 xl0.xpre.tp xl0.gp xl0.xpre.fa xl0.xpre.tp pfet_03v3 ad=1.248p pd=5.32u as=1.248p ps=5.32u w=4.8u l=0.4u
X519 xl0.d2a xl0.d2a VDD VDD pfet_03v3 ad=0.52p pd=2.52u as=0.52p ps=2.52u w=2u l=0.4u
X520 xl1.xhyst.ts xl1.xhyst.sa VSS ppolyf_u_1k r_width=2u r_length=8.86u
X521 xl1.xpre.fb vref xl1.xpre.tp xl1.xpre.tp pfet_03v3 ad=1.248p pd=5.32u as=1.248p ps=5.32u w=4.8u l=0.4u
X522 xl2.xpre.fb vref xl2.xpre.tp xl2.xpre.tp pfet_03v3 ad=1.248p pd=5.32u as=1.248p ps=5.32u w=4.8u l=0.4u
X523 xl1.xpre.tp vbp VDD VDD pfet_03v3 ad=1.3p pd=5.52u as=1.3p ps=5.52u w=5u l=1u
X524 VSS VSS xl0.xpre.fa VSS nfet_03v3 ad=1.1p pd=5.88u as=0.65p ps=3.02u w=2.5u l=1u
X525 VDD xl0.d2b xl0.d2b VDD pfet_03v3 ad=0.52p pd=2.52u as=0.52p ps=2.52u w=2u l=0.4u
X526 xl2.xhyst.sa xl2.oa xl2.d2a VSS nfet_03v3 ad=1.0036p pd=4.38u as=1.0036p ps=4.38u w=3.86u l=0.5u
X527 xl2.xout.nd EN VDD VDD pfet_03v3 ad=0.78p pd=3.52u as=0.78p ps=3.52u w=3u l=0.28u
X528 VSS EN xbias.nmid VSS nfet_03v3 ad=1.3p pd=5.52u as=1.3p ps=5.52u w=5u l=0.5u
X529 VDD vbp vbp VDD pfet_03v3 ad=1.3p pd=5.52u as=1.3p ps=5.52u w=5u l=1u
X530 xl2.xpre.tp xl2.gp xl2.xpre.fa xl2.xpre.tp pfet_03v3 ad=1.248p pd=5.32u as=1.248p ps=5.32u w=4.8u l=0.4u
X531 VDD xl0.d2b xl0.xout.d3 VDD pfet_03v3 ad=0.52p pd=2.52u as=0.52p ps=2.52u w=2u l=0.4u
X532 VSS vbn xl2.xpre.tn VSS nfet_03v3 ad=0.65p pd=3.02u as=0.65p ps=3.02u w=2.5u l=1u
X533 xl2.oa vref xl2.xpre.tn VSS nfet_03v3 ad=1.235p pd=5.27u as=1.235p ps=5.27u w=4.75u l=0.5u
X534 VDD vbp xl2.xpre.tp VDD pfet_03v3 ad=1.3p pd=5.52u as=1.3p ps=5.52u w=5u l=1u
X535 xl0.xpre.fa vref xl0.xpre.tp xl0.xpre.tp pfet_03v3 ad=1.248p pd=5.32u as=1.248p ps=5.32u w=4.8u l=0.4u
X536 xl0.oa vb2 xl0.xpre.fa VSS nfet_03v3 ad=1.1752p pd=5.04u as=1.1752p ps=5.04u w=4.52u l=0.5u
X537 xl2.xout.i1 VSS VSS VSS nfet_03v3 ad=0.39p pd=2.02u as=0.66p ps=3.88u w=1.5u l=0.28u
X538 xl1.ob xl1.gn xl1.xpre.tn VSS nfet_03v3 ad=1.235p pd=5.27u as=1.235p ps=5.27u w=4.75u l=0.5u
X539 xl1.xpre.fb xl1.gn xl1.xpre.tp xl1.xpre.tp pfet_03v3 ad=1.248p pd=5.32u as=1.248p ps=5.32u w=4.8u l=0.4u
X540 xl2.ob vb2 xl2.xpre.fb VSS nfet_03v3 ad=1.1752p pd=5.04u as=1.1752p ps=5.04u w=4.52u l=0.5u
X541 xl2.ob vref xl2.xpre.tn VSS nfet_03v3 ad=1.235p pd=5.27u as=1.235p ps=5.27u w=4.75u l=0.5u
X542 xl0.xpre.fa vref xl0.xpre.tp xl0.xpre.tp pfet_03v3 ad=1.248p pd=5.32u as=1.248p ps=5.32u w=4.8u l=0.4u
X543 xl1.xpre.fa xl1.gp xl1.xpre.tp xl1.xpre.tp pfet_03v3 ad=1.248p pd=5.32u as=1.248p ps=5.32u w=4.8u l=0.4u
X544 xl2.xpre.fa vb2 xl2.oa VSS nfet_03v3 ad=1.1752p pd=5.04u as=1.1752p ps=5.04u w=4.52u l=0.5u
X545 xl2.xpre.tp vref xl2.xpre.fa xl2.xpre.tp pfet_03v3 ad=1.248p pd=5.32u as=1.248p ps=5.32u w=4.8u l=0.4u
D6 VSS xl2.gp diode_nd2ps_03v3 pj=26u area=40p
X546 xl1.oa xl1.gp xl1.xpre.tn VSS nfet_03v3 ad=1.235p pd=5.27u as=1.235p ps=5.27u w=4.75u l=0.5u
X547 xl2.xpre.tn vbn VSS VSS nfet_03v3 ad=0.65p pd=3.02u as=0.65p ps=3.02u w=2.5u l=1u
X548 VSS VSS VSS VSS nfet_03v3 ad=0.52p pd=2.52u as=0 ps=0 w=2u l=0.28u
X549 xl1.xpre.tp xl1.gn xl1.xpre.fb xl1.xpre.tp pfet_03v3 ad=1.248p pd=5.32u as=1.248p ps=5.32u w=4.8u l=0.4u
X550 xl2.xpre.fa vb2 xl2.oa VSS nfet_03v3 ad=1.1752p pd=5.04u as=1.1752p ps=5.04u w=4.52u l=0.5u
X551 xl0.xout.d3 xl0.d2b VDD VDD pfet_03v3 ad=0.52p pd=2.52u as=0.52p ps=2.52u w=2u l=0.4u
X552 xl0.d2b xl0.d2a VDD VDD pfet_03v3 ad=0.52p pd=2.52u as=0.52p ps=2.52u w=2u l=0.4u
X553 xl2.xpre.fa vref xl2.xpre.tp xl2.xpre.tp pfet_03v3 ad=1.248p pd=5.32u as=1.248p ps=5.32u w=4.8u l=0.4u
X554 xl0.ob xl0.gn xl0.xpre.tn VSS nfet_03v3 ad=1.235p pd=5.27u as=1.235p ps=5.27u w=4.75u l=0.5u
X555 xl0.xpre.tn vref xl0.ob VSS nfet_03v3 ad=1.235p pd=5.27u as=1.235p ps=5.27u w=4.75u l=0.5u
X556 xl1.xpre.tn vref xl1.ob VSS nfet_03v3 ad=1.235p pd=5.27u as=1.235p ps=5.27u w=4.75u l=0.5u
X557 xl2.xout.n3a xl2.d2a VDD VDD pfet_03v3 ad=0.52p pd=2.52u as=0.52p ps=2.52u w=2u l=0.4u
X558 xl2.d2a xl2.d2b VDD VDD pfet_03v3 ad=0.52p pd=2.52u as=0.52p ps=2.52u w=2u l=0.4u
X559 xl0.xpre.fa vbn VSS VSS nfet_03v3 ad=0.65p pd=3.02u as=0.65p ps=3.02u w=2.5u l=1u
X560 VDD xl0.xout.nd xl0.xout.i1 VDD pfet_03v3 ad=0.962p pd=4.22u as=0.962p ps=4.22u w=3.7u l=0.28u
X561 VDD vbp xl1.xpre.tp VDD pfet_03v3 ad=1.3p pd=5.52u as=1.3p ps=5.52u w=5u l=1u
X562 xl0.xpre.fb vb2 xl0.ob VSS nfet_03v3 ad=1.1752p pd=5.04u as=1.1752p ps=5.04u w=4.52u l=0.5u
X563 xl0.xpre.tn vbn VSS VSS nfet_03v3 ad=0.65p pd=3.02u as=0.65p ps=3.02u w=2.5u l=1u
X564 xl2.xpre.tn xl2.gp xl2.oa VSS nfet_03v3 ad=1.235p pd=5.27u as=1.235p ps=5.27u w=4.75u l=0.5u
X565 xl0.xpre.tp vbp VDD VDD pfet_03v3 ad=1.3p pd=5.52u as=1.3p ps=5.52u w=5u l=1u
X566 VDD VDD xl2.xout.i2 VDD pfet_03v3 ad=1.65p pd=8.38u as=0.975p ps=4.27u w=3.75u l=0.28u
X567 VSS vbn xl2.xhyst.ts VSS nfet_03v3 ad=0.65p pd=3.02u as=0.65p ps=3.02u w=2.5u l=1u
X568 xl2.xpre.tp vref xl2.xpre.fb xl2.xpre.tp pfet_03v3 ad=1.248p pd=5.32u as=2.112p ps=10.48u w=4.8u l=0.4u
X569 xl0.xhyst.sa xl0.oa xl0.d2a VSS nfet_03v3 ad=1.0036p pd=4.38u as=1.0036p ps=4.38u w=3.86u l=0.5u
X570 xl2.xpre.fa vref xl2.xpre.tp xl2.xpre.tp pfet_03v3 ad=1.248p pd=5.32u as=1.248p ps=5.32u w=4.8u l=0.4u
X571 xl1.xpre.fa vbn VSS VSS nfet_03v3 ad=0.65p pd=3.02u as=0.65p ps=3.02u w=2.5u l=1u
X572 xl2.xpre.tn xl2.gn xl2.ob VSS nfet_03v3 ad=1.235p pd=5.27u as=1.235p ps=5.27u w=4.75u l=0.5u
X573 xl0.oa vref xl0.xpre.tn VSS nfet_03v3 ad=1.235p pd=5.27u as=1.235p ps=5.27u w=4.75u l=0.5u
X574 xl2.xout.nd VSS VSS VSS nfet_03v3 ad=0.52p pd=2.52u as=0.88p ps=4.88u w=2u l=0.28u
X575 VSS VSS VSS ppolyf_u_1k r_width=2u r_length=21.01u
X576 xl2.d2a VSS VSS VSS nfet_03v3 ad=1.0036p pd=4.38u as=1.6984p ps=8.6u w=3.86u l=0.5u
X577 xl1.xpre.tp vbp VDD VDD pfet_03v3 ad=1.3p pd=5.52u as=1.3p ps=5.52u w=5u l=1u
X578 xl2.xpre.tp vref xl2.xpre.fb xl2.xpre.tp pfet_03v3 ad=1.248p pd=5.32u as=1.248p ps=5.32u w=4.8u l=0.4u
X579 xl1.xpre.fb vbn VSS VSS nfet_03v3 ad=0.65p pd=3.02u as=0.65p ps=3.02u w=2.5u l=1u
X580 xl2.xpre.tn vref xl2.ob VSS nfet_03v3 ad=1.235p pd=5.27u as=1.235p ps=5.27u w=4.75u l=0.5u
X581 xl0.xpre.fb vref xl0.xpre.tp xl0.xpre.tp pfet_03v3 ad=1.248p pd=5.32u as=1.248p ps=5.32u w=4.8u l=0.4u
X582 vref xbias.rdb_m1 VSS ppolyf_u_1k r_width=2u r_length=19.26u
X583 xl2.xpre.tp vref xl2.xpre.fb xl2.xpre.tp pfet_03v3 ad=1.248p pd=5.32u as=1.248p ps=5.32u w=4.8u l=0.4u
X584 xl1.xout.i1 VDD VDD VDD pfet_03v3 ad=0.962p pd=4.22u as=1.628p ps=8.28u w=3.7u l=0.28u
X585 VSS VSS xl0.xhyst.ts VSS nfet_03v3 ad=1.1p pd=5.88u as=0.65p ps=3.02u w=2.5u l=1u
X586 VSS EN xl2.xout.nm VSS nfet_03v3 ad=0.52p pd=2.52u as=0.52p ps=2.52u w=2u l=0.28u
X587 VSS xl2.xout.nd xl2.xout.i1 VSS nfet_03v3 ad=0.39p pd=2.02u as=0.39p ps=2.02u w=1.5u l=0.28u
X588 xl0.xpre.tp xl0.gp xl0.xpre.fa xl0.xpre.tp pfet_03v3 ad=1.248p pd=5.32u as=1.248p ps=5.32u w=4.8u l=0.4u
X589 xl1.xpre.tp xl1.gp xl1.xpre.fa xl1.xpre.tp pfet_03v3 ad=1.248p pd=5.32u as=1.248p ps=5.32u w=4.8u l=0.4u
X590 xl1.xpre.fb vref xl1.xpre.tp xl1.xpre.tp pfet_03v3 ad=1.248p pd=5.32u as=1.248p ps=5.32u w=4.8u l=0.4u
X591 xl2.xpre.fb vref xl2.xpre.tp xl2.xpre.tp pfet_03v3 ad=1.248p pd=5.32u as=1.248p ps=5.32u w=4.8u l=0.4u
X592 xl2.xpre.fb xl2.gn xl2.xpre.tp xl2.xpre.tp pfet_03v3 ad=1.248p pd=5.32u as=1.248p ps=5.32u w=4.8u l=0.4u
X593 VDD VDD xl0.d2b VDD pfet_03v3 ad=0.88p pd=4.88u as=0.52p ps=2.52u w=2u l=0.4u
X594 VSS vbn xl0.xpre.fa VSS nfet_03v3 ad=0.65p pd=3.02u as=0.65p ps=3.02u w=2.5u l=1u
X595 VDD xl2.d2a xl2.xout.n3a VDD pfet_03v3 ad=0.52p pd=2.52u as=0.52p ps=2.52u w=2u l=0.4u
X596 VDD xl2.d2a xl2.d2a VDD pfet_03v3 ad=0.52p pd=2.52u as=0.52p ps=2.52u w=2u l=0.4u
X597 VDD xl1.d2b xl1.d2a VDD pfet_03v3 ad=0.52p pd=2.52u as=0.52p ps=2.52u w=2u l=0.4u
X598 xl1.xpre.fa vb2 xl1.oa VSS nfet_03v3 ad=1.1752p pd=5.04u as=1.1752p ps=5.04u w=4.52u l=0.5u
X599 VSS vbn xl1.xpre.fb VSS nfet_03v3 ad=0.65p pd=3.02u as=0.65p ps=3.02u w=2.5u l=1u
X600 VSS VSS xl0.xpre.tn VSS nfet_03v3 ad=1.1p pd=5.88u as=0.65p ps=3.02u w=2.5u l=1u
X601 RX1_O VDD VDD VDD pfet_03v3 ad=1.3p pd=5.52u as=2.2p ps=10.88u w=5u l=0.28u
X602 xl1.d2b VSS VSS VSS nfet_03v3 ad=1.0036p pd=4.38u as=1.6984p ps=8.6u w=3.86u l=0.5u
X603 VDD vbp xl0.xpre.tp VDD pfet_03v3 ad=1.3p pd=5.52u as=1.3p ps=5.52u w=5u l=1u
X604 xl1.xpre.tp vref xl1.xpre.fa xl1.xpre.tp pfet_03v3 ad=1.248p pd=5.32u as=1.248p ps=5.32u w=4.8u l=0.4u
X605 xl0.xpre.tp xl0.gn xl0.xpre.fb xl0.xpre.tp pfet_03v3 ad=1.248p pd=5.32u as=1.248p ps=5.32u w=4.8u l=0.4u
X606 xl1.xpre.fa vb2 xl1.oa VSS nfet_03v3 ad=1.1752p pd=5.04u as=1.1752p ps=5.04u w=4.52u l=0.5u
X607 xl1.d2a xl1.d2b VDD VDD pfet_03v3 ad=0.52p pd=2.52u as=0.52p ps=2.52u w=2u l=0.4u
X608 VDD xl1.rlb_m1 VSS ppolyf_u_1k r_width=2u r_length=9.11u
X609 xl1.xpre.tn vref xl1.oa VSS nfet_03v3 ad=1.235p pd=5.27u as=1.235p ps=5.27u w=4.75u l=0.5u
X610 xbias.rf_m1 xbias.vf VSS ppolyf_u_1k r_width=2u r_length=23.07u
X611 xl2.xpre.tp vref xl2.xpre.fa xl2.xpre.tp pfet_03v3 ad=1.248p pd=5.32u as=1.248p ps=5.32u w=4.8u l=0.4u
X612 xl1.xpre.fa VSS VSS VSS nfet_03v3 ad=0.65p pd=3.02u as=1.1p ps=5.88u w=2.5u l=1u
X613 xl1.xpre.fb vb2 xl1.ob VSS nfet_03v3 ad=1.1752p pd=5.04u as=1.1752p ps=5.04u w=4.52u l=0.5u
X614 xl0.xpre.tn vref xl0.ob VSS nfet_03v3 ad=1.235p pd=5.27u as=2.09p ps=10.38u w=4.75u l=0.5u
X615 xl0.xpre.tn vref xl0.oa VSS nfet_03v3 ad=1.235p pd=5.27u as=1.235p ps=5.27u w=4.75u l=0.5u
X616 xl1.xpre.tp vref xl1.xpre.fa xl1.xpre.tp pfet_03v3 ad=1.248p pd=5.32u as=1.248p ps=5.32u w=4.8u l=0.4u
X617 xl1.xout.i1 VSS VSS VSS nfet_03v3 ad=0.39p pd=2.02u as=0.66p ps=3.88u w=1.5u l=0.28u
X618 xl0.xout.i2 xl0.xout.i1 VDD VDD pfet_03v3 ad=0.975p pd=4.27u as=0.975p ps=4.27u w=3.75u l=0.28u
X619 xl0.xpre.fb xl0.gn xl0.xpre.tp xl0.xpre.tp pfet_03v3 ad=1.248p pd=5.32u as=1.248p ps=5.32u w=4.8u l=0.4u
X620 xl1.xpre.tp vref xl1.xpre.fb xl1.xpre.tp pfet_03v3 ad=1.248p pd=5.32u as=1.248p ps=5.32u w=4.8u l=0.4u
X621 xl2.xpre.tp xl2.gp xl2.xpre.fa xl2.xpre.tp pfet_03v3 ad=1.248p pd=5.32u as=1.248p ps=5.32u w=4.8u l=0.4u
X622 xl0.xpre.tp vref xl0.xpre.fb xl0.xpre.tp pfet_03v3 ad=1.248p pd=5.32u as=1.248p ps=5.32u w=4.8u l=0.4u
X623 VSS xbias.enb vbn VSS nfet_03v3 ad=0.52p pd=2.52u as=0.52p ps=2.52u w=2u l=0.5u
X624 xl2.xpre.tp xl2.gn xl2.xpre.fb xl2.xpre.tp pfet_03v3 ad=1.248p pd=5.32u as=1.248p ps=5.32u w=4.8u l=0.4u
X625 VDD xl2.d2b xl2.xout.d3 VDD pfet_03v3 ad=0.52p pd=2.52u as=0.52p ps=2.52u w=2u l=0.4u
X626 VDD xl1.d2b xl1.xout.d3 VDD pfet_03v3 ad=0.52p pd=2.52u as=0.52p ps=2.52u w=2u l=0.4u
D7 xl1.gp VDD diode_pd2nw_03v3 pj=26u area=40p
X627 xl1.xpre.tn xl1.gn xl1.ob VSS nfet_03v3 ad=1.235p pd=5.27u as=1.235p ps=5.27u w=4.75u l=0.5u
X628 VSS VSS VSS VSS nfet_03v3 ad=0.52p pd=2.52u as=0 ps=0 w=2u l=0.28u
X629 VDD xl2.d2b xl2.d2a VDD pfet_03v3 ad=0.52p pd=2.52u as=0.52p ps=2.52u w=2u l=0.4u
X630 VDD xl1.d2b xl1.d2b VDD pfet_03v3 ad=0.52p pd=2.52u as=0.52p ps=2.52u w=2u l=0.4u
X631 xl2.xpre.fb xl2.gn xl2.xpre.tp xl2.xpre.tp pfet_03v3 ad=1.248p pd=5.32u as=1.248p ps=5.32u w=4.8u l=0.4u
X632 xl1.xpre.fa vbn VSS VSS nfet_03v3 ad=0.65p pd=3.02u as=0.65p ps=3.02u w=2.5u l=1u
X633 xl2.xpre.fa vbn VSS VSS nfet_03v3 ad=0.65p pd=3.02u as=0.65p ps=3.02u w=2.5u l=1u
X634 VDD VDD VDD VDD pfet_03v3 ad=0.962p pd=4.22u as=0 ps=0 w=3.7u l=0.28u
X635 VSS vbn xl0.xpre.tn VSS nfet_03v3 ad=0.65p pd=3.02u as=0.65p ps=3.02u w=2.5u l=1u
X636 xl1.xpre.tp vbp VDD VDD pfet_03v3 ad=1.3p pd=5.52u as=1.3p ps=5.52u w=5u l=1u
X637 xl0.xpre.tp vref xl0.xpre.fa xl0.xpre.tp pfet_03v3 ad=1.248p pd=5.32u as=1.248p ps=5.32u w=4.8u l=0.4u
X638 xl1.xpre.tn vref xl1.oa VSS nfet_03v3 ad=1.235p pd=5.27u as=1.235p ps=5.27u w=4.75u l=0.5u
X639 xl2.xhyst.sb xl2.ob xl2.d2b VSS nfet_03v3 ad=1.0036p pd=4.38u as=1.0036p ps=4.38u w=3.86u l=0.5u
X640 xl1.d2b xl1.d2a VDD VDD pfet_03v3 ad=0.52p pd=2.52u as=0.52p ps=2.52u w=2u l=0.4u
X641 xl1.xpre.tp xl1.gn xl1.xpre.fb xl1.xpre.tp pfet_03v3 ad=1.248p pd=5.32u as=1.248p ps=5.32u w=4.8u l=0.4u
X642 xl0.xpre.tp vref xl0.xpre.fa xl0.xpre.tp pfet_03v3 ad=1.248p pd=5.32u as=1.248p ps=5.32u w=4.8u l=0.4u
X643 VDD xl1.xout.i1 xl1.xout.i2 VDD pfet_03v3 ad=0.975p pd=4.27u as=0.975p ps=4.27u w=3.75u l=0.28u
X644 VSS EN xbias.enb VSS nfet_03v3 ad=0.44p pd=2.88u as=0.44p ps=2.88u w=1u l=0.28u
X645 xl2.xpre.fb vref xl2.xpre.tp xl2.xpre.tp pfet_03v3 ad=1.248p pd=5.32u as=1.248p ps=5.32u w=4.8u l=0.4u
X646 VSS vbn xl1.xpre.fa VSS nfet_03v3 ad=0.65p pd=3.02u as=0.65p ps=3.02u w=2.5u l=1u
X647 VSS vbn xl2.xpre.fb VSS nfet_03v3 ad=0.65p pd=3.02u as=0.65p ps=3.02u w=2.5u l=1u
X648 VSS vbn xl1.xpre.tn VSS nfet_03v3 ad=0.65p pd=3.02u as=0.65p ps=3.02u w=2.5u l=1u
X649 VDD VDD RX1_O VDD pfet_03v3 ad=2.2p pd=10.88u as=1.3p ps=5.52u w=5u l=0.28u
X650 xl1.ob xl1.gn xl1.xpre.tn VSS nfet_03v3 ad=1.235p pd=5.27u as=1.235p ps=5.27u w=4.75u l=0.5u
X651 xl0.xout.nd VDD VDD VDD pfet_03v3 ad=0.78p pd=3.52u as=1.32p ps=6.88u w=3u l=0.28u
X652 VDD xl0.d2b xl0.xout.d3 VDD pfet_03v3 ad=0.52p pd=2.52u as=0.52p ps=2.52u w=2u l=0.4u
X653 VSS vbn xl2.xpre.fa VSS nfet_03v3 ad=0.65p pd=3.02u as=0.65p ps=3.02u w=2.5u l=1u
X654 xl2.ob vb2 xl2.xpre.fb VSS nfet_03v3 ad=1.1752p pd=5.04u as=1.1752p ps=5.04u w=4.52u l=0.5u
X655 xl0.xhyst.ts vbn VSS VSS nfet_03v3 ad=0.65p pd=3.02u as=0.65p ps=3.02u w=2.5u l=1u
X656 xl1.xout.d3 xl1.xout.n3a VSS VSS nfet_03v3 ad=0.6734p pd=3.11u as=0.6734p ps=3.11u w=2.59u l=0.28u
X657 VDD xl0.d2a xl0.d2b VDD pfet_03v3 ad=0.52p pd=2.52u as=0.52p ps=2.52u w=2u l=0.4u
X658 xl1.xout.nd VSS VSS VSS nfet_03v3 ad=0.52p pd=2.52u as=0.88p ps=4.88u w=2u l=0.28u
X659 xl2.oa vref xl2.xpre.tn VSS nfet_03v3 ad=1.235p pd=5.27u as=1.235p ps=5.27u w=4.75u l=0.5u
X660 xl0.xpre.fa xl0.gp xl0.xpre.tp xl0.xpre.tp pfet_03v3 ad=1.248p pd=5.32u as=1.248p ps=5.32u w=4.8u l=0.4u
X661 xl1.xhyst.ts VSS VSS VSS nfet_03v3 ad=0.65p pd=3.02u as=1.1p ps=5.88u w=2.5u l=1u
X662 xl0.d2b xl0.ob xl0.xhyst.sb VSS nfet_03v3 ad=1.0036p pd=4.38u as=1.0036p ps=4.38u w=3.86u l=0.5u
X663 xl0.xpre.tp vref xl0.xpre.fa xl0.xpre.tp pfet_03v3 ad=1.248p pd=5.32u as=1.248p ps=5.32u w=4.8u l=0.4u
X664 xl2.xpre.tp xl2.gn xl2.xpre.fb xl2.xpre.tp pfet_03v3 ad=1.248p pd=5.32u as=1.248p ps=5.32u w=4.8u l=0.4u
X665 xl2.ob vb2 xl2.xpre.fb VSS nfet_03v3 ad=1.1752p pd=5.04u as=1.1752p ps=5.04u w=4.52u l=0.5u
X666 xl0.xpre.tn vref xl0.oa VSS nfet_03v3 ad=1.235p pd=5.27u as=1.235p ps=5.27u w=4.75u l=0.5u
X667 xl1.ob xl1.gn xl1.xpre.tn VSS nfet_03v3 ad=1.235p pd=5.27u as=1.235p ps=5.27u w=4.75u l=0.5u
X668 VDD VDD VDD VDD pfet_03v3 ad=0.52p pd=2.52u as=0 ps=0 w=2u l=0.5u
X669 xl0.d2b xl0.d2b VDD VDD pfet_03v3 ad=0.52p pd=2.52u as=0.52p ps=2.52u w=2u l=0.4u
X670 xl0.oa xl0.rla_m1 VSS ppolyf_u_1k r_width=2u r_length=9.11u
X671 xl0.xpre.fa vref xl0.xpre.tp xl0.xpre.tp pfet_03v3 ad=1.248p pd=5.32u as=1.248p ps=5.32u w=4.8u l=0.4u
X672 xl2.xpre.tp xl2.gp xl2.xpre.fa xl2.xpre.tp pfet_03v3 ad=1.248p pd=5.32u as=1.248p ps=5.32u w=4.8u l=0.4u
X673 xl0.xpre.fb vb2 xl0.ob VSS nfet_03v3 ad=1.1752p pd=5.04u as=1.1752p ps=5.04u w=4.52u l=0.5u
X674 VSS EN xl1.xout.nm VSS nfet_03v3 ad=0.52p pd=2.52u as=0.52p ps=2.52u w=2u l=0.28u
X675 VSS xl1.xout.nd xl1.xout.i1 VSS nfet_03v3 ad=0.39p pd=2.02u as=0.39p ps=2.02u w=1.5u l=0.28u
X676 xl1.xpre.fb vbn VSS VSS nfet_03v3 ad=0.65p pd=3.02u as=0.65p ps=3.02u w=2.5u l=1u
X677 xl0.xpre.tn vref xl0.ob VSS nfet_03v3 ad=1.235p pd=5.27u as=1.235p ps=5.27u w=4.75u l=0.5u
X678 xl1.oa xl1.gp xl1.xpre.tn VSS nfet_03v3 ad=1.235p pd=5.27u as=1.235p ps=5.27u w=4.75u l=0.5u
X679 xl1.d2a xl1.d2a VDD VDD pfet_03v3 ad=0.52p pd=2.52u as=0.52p ps=2.52u w=2u l=0.4u
X680 xl2.xpre.tp vref xl2.xpre.fa xl2.xpre.tp pfet_03v3 ad=1.248p pd=5.32u as=1.248p ps=5.32u w=4.8u l=0.4u
X681 xl2.ob VSS VSS VSS nfet_03v3 ad=1.1752p pd=5.04u as=1.9888p ps=9.92u w=4.52u l=0.5u
X682 VDD EN xl0.d2b VDD pfet_03v3 ad=0.52p pd=2.52u as=0.52p ps=2.52u w=2u l=0.5u
X683 xl0.d2a VDD VDD VDD pfet_03v3 ad=0.52p pd=2.52u as=0.88p ps=4.88u w=2u l=0.5u
X684 xl1.xpre.tn vbn VSS VSS nfet_03v3 ad=0.65p pd=3.02u as=0.65p ps=3.02u w=2.5u l=1u
X685 xl1.xpre.tp VDD VDD VDD pfet_03v3 ad=1.3p pd=5.52u as=2.2p ps=10.88u w=5u l=1u
X686 xl0.xpre.fa vref xl0.xpre.tp xl0.xpre.tp pfet_03v3 ad=1.248p pd=5.32u as=1.248p ps=5.32u w=4.8u l=0.4u
X687 VSS vbn xl0.xpre.fa VSS nfet_03v3 ad=0.65p pd=3.02u as=0.65p ps=3.02u w=2.5u l=1u
X688 xl0.xpre.fb vb2 xl0.ob VSS nfet_03v3 ad=1.1752p pd=5.04u as=1.1752p ps=5.04u w=4.52u l=0.5u
X689 VDD vbp vb2 VDD pfet_03v3 ad=1.3p pd=5.52u as=1.3p ps=5.52u w=5u l=1u
X690 xl1.xpre.tp xl1.gp xl1.xpre.fa xl1.xpre.tp pfet_03v3 ad=1.248p pd=5.32u as=1.248p ps=5.32u w=4.8u l=0.4u
X691 VSS xl2.xout.n3a xl2.xout.n3a VSS nfet_03v3 ad=0.6734p pd=3.11u as=0.6734p ps=3.11u w=2.59u l=0.28u
X692 VDD vbp xl0.xpre.tp VDD pfet_03v3 ad=1.3p pd=5.52u as=1.3p ps=5.52u w=5u l=1u
X693 xl0.xpre.tp vref xl0.xpre.fb xl0.xpre.tp pfet_03v3 ad=1.248p pd=5.32u as=1.248p ps=5.32u w=4.8u l=0.4u
X694 xl1.xpre.fa xl1.gp xl1.xpre.tp xl1.xpre.tp pfet_03v3 ad=1.248p pd=5.32u as=1.248p ps=5.32u w=4.8u l=0.4u
X695 xl2.xpre.fa vref xl2.xpre.tp xl2.xpre.tp pfet_03v3 ad=1.248p pd=5.32u as=1.248p ps=5.32u w=4.8u l=0.4u
X696 xbias.vf vb2 vb2 VSS nfet_03v3 ad=2.0566p pd=8.43u as=2.0566p ps=8.43u w=7.91u l=0.5u
X697 RX0_O VDD VDD VDD pfet_03v3 ad=1.3p pd=5.52u as=2.2p ps=10.88u w=5u l=0.28u
X698 VDD VDD xl0.xout.nd VDD pfet_03v3 ad=1.32p pd=6.88u as=0.78p ps=3.52u w=3u l=0.28u
X699 xl0.ob xl0.rlb_m1 VSS ppolyf_u_1k r_width=2u r_length=9.11u
X700 xl2.xpre.tn xl2.gp xl2.oa VSS nfet_03v3 ad=1.235p pd=5.27u as=1.235p ps=5.27u w=4.75u l=0.5u
X701 xl0.gn RX0_N VDD ppolyf_u r_width=5u r_length=1.8u
X702 xl2.xpre.fa vbn VSS VSS nfet_03v3 ad=0.65p pd=3.02u as=0.65p ps=3.02u w=2.5u l=1u
X703 xl1.xpre.tp vref xl1.xpre.fb xl1.xpre.tp pfet_03v3 ad=1.248p pd=5.32u as=1.248p ps=5.32u w=4.8u l=0.4u
X704 RX1_O xl1.xout.i2 VDD VDD pfet_03v3 ad=1.3p pd=5.52u as=1.3p ps=5.52u w=5u l=0.28u
X705 VDD xl0.d2a xl0.xout.n3a VDD pfet_03v3 ad=0.52p pd=2.52u as=0.52p ps=2.52u w=2u l=0.4u
X706 VSS VSS VSS VSS nfet_03v3 ad=0.52p pd=2.52u as=0 ps=0 w=2u l=0.5u
X707 xl2.xpre.fb vbn VSS VSS nfet_03v3 ad=0.65p pd=3.02u as=0.65p ps=3.02u w=2.5u l=1u
X708 xl2.xpre.tn vbn VSS VSS nfet_03v3 ad=0.65p pd=3.02u as=0.65p ps=3.02u w=2.5u l=1u
X709 VSS vbn xl1.xhyst.ts VSS nfet_03v3 ad=0.65p pd=3.02u as=0.65p ps=3.02u w=2.5u l=1u
X710 xl2.xpre.tp vbp VDD VDD pfet_03v3 ad=1.3p pd=5.52u as=1.3p ps=5.52u w=5u l=1u
X711 xl2.xout.d3 xl2.d2b VDD VDD pfet_03v3 ad=0.52p pd=2.52u as=0.52p ps=2.52u w=2u l=0.4u
X712 xl1.xpre.fa xl1.gp xl1.xpre.tp xl1.xpre.tp pfet_03v3 ad=1.248p pd=5.32u as=1.248p ps=5.32u w=4.8u l=0.4u
X713 xl2.d2b xl2.d2b VDD VDD pfet_03v3 ad=0.52p pd=2.52u as=0.52p ps=2.52u w=2u l=0.4u
X714 vb2 VSS VSS VSS nfet_03v3 ad=0.52p pd=2.52u as=0.88p ps=4.88u w=2u l=0.5u
X715 RX2_O VDD VDD VDD pfet_03v3 ad=1.3p pd=5.52u as=2.2p ps=10.88u w=5u l=0.28u
X716 xbias.enb VDD VDD VDD pfet_03v3 ad=0.65p pd=3.02u as=1.1p ps=5.88u w=2.5u l=0.28u
X717 vref xbias.rdt_m3 VSS ppolyf_u_1k r_width=2u r_length=21.01u
X718 xl0.xpre.fb vref xl0.xpre.tp xl0.xpre.tp pfet_03v3 ad=1.248p pd=5.32u as=1.248p ps=5.32u w=4.8u l=0.4u
X719 xl1.xpre.fb vref xl1.xpre.tp xl1.xpre.tp pfet_03v3 ad=1.248p pd=5.32u as=1.248p ps=5.32u w=4.8u l=0.4u
X720 xl0.xhyst.ts xl0.xhyst.sa VSS ppolyf_u_1k r_width=2u r_length=8.86u
X721 xl0.xpre.tp vbp VDD VDD pfet_03v3 ad=1.3p pd=5.52u as=1.3p ps=5.52u w=5u l=1u
X722 xl2.xpre.tp xl2.gn xl2.xpre.fb xl2.xpre.tp pfet_03v3 ad=1.248p pd=5.32u as=1.248p ps=5.32u w=4.8u l=0.4u
X723 xl2.xpre.tn xl2.gp xl2.oa VSS nfet_03v3 ad=1.235p pd=5.27u as=1.235p ps=5.27u w=4.75u l=0.5u
X724 VSS vbn xl2.xpre.fb VSS nfet_03v3 ad=0.65p pd=3.02u as=0.65p ps=3.02u w=2.5u l=1u
X725 xl1.xout.nd EN VDD VDD pfet_03v3 ad=0.78p pd=3.52u as=0.78p ps=3.52u w=3u l=0.28u
X726 xl1.xhyst.sa xl1.oa xl1.d2a VSS nfet_03v3 ad=1.0036p pd=4.38u as=1.0036p ps=4.38u w=3.86u l=0.5u
X727 xl1.xpre.tp xl1.gp xl1.xpre.fa xl1.xpre.tp pfet_03v3 ad=1.248p pd=5.32u as=1.248p ps=5.32u w=4.8u l=0.4u
X728 VSS vbn vbn VSS nfet_03v3 ad=0.65p pd=3.02u as=0.65p ps=3.02u w=2.5u l=1u
X729 xl0.xout.i1 VSS VSS VSS nfet_03v3 ad=0.39p pd=2.02u as=0.66p ps=3.88u w=1.5u l=0.28u
X730 VDD xl1.d2b xl1.d2a VDD pfet_03v3 ad=0.52p pd=2.52u as=0.52p ps=2.52u w=2u l=0.4u
X731 VSS vbn xl1.xpre.tn VSS nfet_03v3 ad=0.65p pd=3.02u as=0.65p ps=3.02u w=2.5u l=1u
X732 vbp vbn VSS VSS nfet_03v3 ad=0.65p pd=3.02u as=0.65p ps=3.02u w=2.5u l=1u
X733 VDD vbp xl1.xpre.tp VDD pfet_03v3 ad=1.3p pd=5.52u as=1.3p ps=5.52u w=5u l=1u
X734 xl2.xpre.fb vref xl2.xpre.tp xl2.xpre.tp pfet_03v3 ad=1.248p pd=5.32u as=1.248p ps=5.32u w=4.8u l=0.4u
X735 VSS VSS VSS ppolyf_u_1k r_width=2u r_length=9.11u
X736 xl2.xpre.tn xl2.gp xl2.oa VSS nfet_03v3 ad=1.235p pd=5.27u as=1.235p ps=5.27u w=4.75u l=0.5u
X737 VDD vbp xl2.xpre.tp VDD pfet_03v3 ad=1.3p pd=5.52u as=1.3p ps=5.52u w=5u l=1u
X738 xl1.xpre.fa vbn VSS VSS nfet_03v3 ad=0.65p pd=3.02u as=0.65p ps=3.02u w=2.5u l=1u
X739 xl0.ob xl0.gn xl0.xpre.tn VSS nfet_03v3 ad=1.235p pd=5.27u as=1.235p ps=5.27u w=4.75u l=0.5u
X740 xl0.xpre.fb xl0.gn xl0.xpre.tp xl0.xpre.tp pfet_03v3 ad=1.248p pd=5.32u as=1.248p ps=5.32u w=4.8u l=0.4u
X741 VSS VSS VSS VSS nfet_03v3 ad=0.52p pd=2.52u as=0 ps=0 w=2u l=0.28u
X742 xl2.xpre.tn xl2.gn xl2.ob VSS nfet_03v3 ad=1.235p pd=5.27u as=1.235p ps=5.27u w=4.75u l=0.5u
X743 xl1.xpre.tp vbp VDD VDD pfet_03v3 ad=1.3p pd=5.52u as=1.3p ps=5.52u w=5u l=1u
X744 xl1.xpre.fa vb2 xl1.oa VSS nfet_03v3 ad=1.1752p pd=5.04u as=1.1752p ps=5.04u w=4.52u l=0.5u
X745 VSS VSS VSS ppolyf_u_1k r_width=2u r_length=8.86u
X746 xl0.xpre.fa xl0.gp xl0.xpre.tp xl0.xpre.tp pfet_03v3 ad=1.248p pd=5.32u as=1.248p ps=5.32u w=4.8u l=0.4u
X747 xl1.xpre.tp vref xl1.xpre.fa xl1.xpre.tp pfet_03v3 ad=1.248p pd=5.32u as=1.248p ps=5.32u w=4.8u l=0.4u
X748 xl2.xpre.tp vref xl2.xpre.fa xl2.xpre.tp pfet_03v3 ad=1.248p pd=5.32u as=1.248p ps=5.32u w=4.8u l=0.4u
D8 VSS xl1.gp diode_nd2ps_03v3 pj=26u area=40p
X749 xl0.oa xl0.gp xl0.xpre.tn VSS nfet_03v3 ad=1.235p pd=5.27u as=1.235p ps=5.27u w=4.75u l=0.5u
X750 xl1.xpre.tn vbn VSS VSS nfet_03v3 ad=0.65p pd=3.02u as=0.65p ps=3.02u w=2.5u l=1u
X751 VDD xbias.enb xbias.nrb VDD pfet_03v3 ad=1.3p pd=5.52u as=1.3p ps=5.52u w=5u l=0.5u
X752 xl0.xpre.tp xl0.gn xl0.xpre.fb xl0.xpre.tp pfet_03v3 ad=1.248p pd=5.32u as=1.248p ps=5.32u w=4.8u l=0.4u
X753 xl2.xpre.fb xl2.gn xl2.xpre.tp xl2.xpre.tp pfet_03v3 ad=1.248p pd=5.32u as=1.248p ps=5.32u w=4.8u l=0.4u
X754 xl1.xpre.fa vb2 xl1.oa VSS nfet_03v3 ad=1.1752p pd=5.04u as=1.1752p ps=5.04u w=4.52u l=0.5u
X755 xl2.xpre.tn VSS VSS VSS nfet_03v3 ad=0.65p pd=3.02u as=1.1p ps=5.88u w=2.5u l=1u
X756 xl2.xpre.tp vref xl2.xpre.fa xl2.xpre.tp pfet_03v3 ad=1.248p pd=5.32u as=1.248p ps=5.32u w=4.8u l=0.4u
X757 xl2.oa vref xl2.xpre.tn VSS nfet_03v3 ad=1.235p pd=5.27u as=1.235p ps=5.27u w=4.75u l=0.5u
X758 xl2.xout.n3a xl2.d2a VDD VDD pfet_03v3 ad=0.52p pd=2.52u as=0.52p ps=2.52u w=2u l=0.4u
X759 xl1.xout.n3a xl1.d2a VDD VDD pfet_03v3 ad=0.52p pd=2.52u as=0.52p ps=2.52u w=2u l=0.4u
X760 xl0.xpre.tn vref xl0.ob VSS nfet_03v3 ad=1.235p pd=5.27u as=1.235p ps=5.27u w=4.75u l=0.5u
X761 xl1.d2a xl1.d2b VDD VDD pfet_03v3 ad=0.52p pd=2.52u as=0.52p ps=2.52u w=2u l=0.4u
X762 VDD xl1.rla_m1 VSS ppolyf_u_1k r_width=2u r_length=9.11u
X763 xl0.gp RX0_P VDD ppolyf_u r_width=5u r_length=1.8u
X764 VDD VDD RX0_O VDD pfet_03v3 ad=2.2p pd=10.88u as=1.3p ps=5.52u w=5u l=0.28u
X765 VDD vbp xl0.xpre.tp VDD pfet_03v3 ad=1.3p pd=5.52u as=1.3p ps=5.52u w=5u l=1u
X766 xl1.xpre.tn xl1.gp xl1.oa VSS nfet_03v3 ad=1.235p pd=5.27u as=1.235p ps=5.27u w=4.75u l=0.5u
X767 xl2.ob vref xl2.xpre.tn VSS nfet_03v3 ad=1.235p pd=5.27u as=1.235p ps=5.27u w=4.75u l=0.5u
X768 xl1.xpre.tp vref xl1.xpre.fb xl1.xpre.tp pfet_03v3 ad=1.248p pd=5.32u as=2.112p ps=10.48u w=4.8u l=0.4u
X769 xl0.xout.nd VSS VSS VSS nfet_03v3 ad=0.52p pd=2.52u as=0.88p ps=4.88u w=2u l=0.28u
X770 VDD xl1.d2a xl1.d2b VDD pfet_03v3 ad=0.52p pd=2.52u as=0.52p ps=2.52u w=2u l=0.4u
X771 xl1.xpre.fa xl1.gp xl1.xpre.tp xl1.xpre.tp pfet_03v3 ad=1.248p pd=5.32u as=1.248p ps=5.32u w=4.8u l=0.4u
X772 vb2 vbp VDD VDD pfet_03v3 ad=1.3p pd=5.52u as=1.3p ps=5.52u w=5u l=1u
X773 xl2.xpre.fa vref xl2.xpre.tp xl2.xpre.tp pfet_03v3 ad=1.248p pd=5.32u as=1.248p ps=5.32u w=4.8u l=0.4u
X774 xl1.xpre.tn xl1.gn xl1.ob VSS nfet_03v3 ad=1.235p pd=5.27u as=1.235p ps=5.27u w=4.75u l=0.5u
X775 xl2.oa vref xl2.xpre.tn VSS nfet_03v3 ad=1.235p pd=5.27u as=1.235p ps=5.27u w=4.75u l=0.5u
X776 xl0.xpre.fa vbn VSS VSS nfet_03v3 ad=0.65p pd=3.02u as=0.65p ps=3.02u w=2.5u l=1u
X777 xl2.xpre.tp vbp VDD VDD pfet_03v3 ad=1.3p pd=5.52u as=1.3p ps=5.52u w=5u l=1u
X778 xl2.xpre.fa xl2.gp xl2.xpre.tp xl2.xpre.tp pfet_03v3 ad=1.248p pd=5.32u as=1.248p ps=5.32u w=4.8u l=0.4u
X779 xl1.d2a VSS VSS VSS nfet_03v3 ad=1.0036p pd=4.38u as=1.6984p ps=8.6u w=3.86u l=0.5u
X780 xl0.xpre.tp vbp VDD VDD pfet_03v3 ad=1.3p pd=5.52u as=1.3p ps=5.52u w=5u l=1u
X781 xl0.xpre.fb vbn VSS VSS nfet_03v3 ad=0.65p pd=3.02u as=0.65p ps=3.02u w=2.5u l=1u
X782 xl1.xpre.fb vbn VSS VSS nfet_03v3 ad=0.65p pd=3.02u as=0.65p ps=3.02u w=2.5u l=1u
X783 VDD VDD RX2_O VDD pfet_03v3 ad=2.2p pd=10.88u as=1.3p ps=5.52u w=5u l=0.28u
X784 xl1.xhyst.ts xl1.xhyst.sb VSS ppolyf_u_1k r_width=2u r_length=8.86u
X785 VSS xl0.xout.nd xl0.xout.i1 VSS nfet_03v3 ad=0.39p pd=2.02u as=0.39p ps=2.02u w=1.5u l=0.28u
X786 VSS EN xl0.xout.nm VSS nfet_03v3 ad=0.52p pd=2.52u as=0.52p ps=2.52u w=2u l=0.28u
X787 xl1.xpre.tn vref xl1.ob VSS nfet_03v3 ad=1.235p pd=5.27u as=1.235p ps=5.27u w=4.75u l=0.5u
X788 xl1.xpre.tp vbp VDD VDD pfet_03v3 ad=1.3p pd=5.52u as=1.3p ps=5.52u w=5u l=1u
X789 xl1.xpre.tp vref xl1.xpre.fb xl1.xpre.tp pfet_03v3 ad=1.248p pd=5.32u as=1.248p ps=5.32u w=4.8u l=0.4u
X790 xl0.xout.i1 VDD VDD VDD pfet_03v3 ad=0.962p pd=4.22u as=1.628p ps=8.28u w=3.7u l=0.28u
X791 xl0.xpre.tp xl0.gp xl0.xpre.fa xl0.xpre.tp pfet_03v3 ad=1.248p pd=5.32u as=1.248p ps=5.32u w=4.8u l=0.4u
X792 xl0.xpre.fb vref xl0.xpre.tp xl0.xpre.tp pfet_03v3 ad=1.248p pd=5.32u as=1.248p ps=5.32u w=4.8u l=0.4u
X793 xl1.xpre.fb vref xl1.xpre.tp xl1.xpre.tp pfet_03v3 ad=1.248p pd=5.32u as=1.248p ps=5.32u w=4.8u l=0.4u
X794 xl2.xpre.fa xl2.gp xl2.xpre.tp xl2.xpre.tp pfet_03v3 ad=1.248p pd=5.32u as=1.248p ps=5.32u w=4.8u l=0.4u
X795 VSS vbn xl2.xpre.tn VSS nfet_03v3 ad=0.65p pd=3.02u as=0.65p ps=3.02u w=2.5u l=1u
X796 xl1.xpre.tp vref xl1.xpre.fb xl1.xpre.tp pfet_03v3 ad=1.248p pd=5.32u as=1.248p ps=5.32u w=4.8u l=0.4u
X797 xl2.xpre.tp xl2.gn xl2.xpre.fb xl2.xpre.tp pfet_03v3 ad=1.248p pd=5.32u as=1.248p ps=5.32u w=4.8u l=0.4u
X798 xl2.ob vref xl2.xpre.tn VSS nfet_03v3 ad=2.09p pd=10.38u as=1.235p ps=5.27u w=4.75u l=0.5u
X799 VDD vbp xl2.xpre.tp VDD pfet_03v3 ad=1.3p pd=5.52u as=1.3p ps=5.52u w=5u l=1u
X800 xl1.oa xl1.gp xl1.xpre.tn VSS nfet_03v3 ad=1.235p pd=5.27u as=1.235p ps=5.27u w=4.75u l=0.5u
X801 xl2.xpre.fb xl2.gn xl2.xpre.tp xl2.xpre.tp pfet_03v3 ad=1.248p pd=5.32u as=1.248p ps=5.32u w=4.8u l=0.4u
X802 VSS VSS xl2.xpre.fb VSS nfet_03v3 ad=1.9888p pd=9.92u as=1.1752p ps=5.04u w=4.52u l=0.5u
X803 VDD xl1.d2a xl1.d2a VDD pfet_03v3 ad=0.52p pd=2.52u as=0.52p ps=2.52u w=2u l=0.4u
X804 VDD xl1.d2a xl1.xout.n3a VDD pfet_03v3 ad=0.52p pd=2.52u as=0.52p ps=2.52u w=2u l=0.4u
X805 VDD xl0.d2b xl0.d2a VDD pfet_03v3 ad=0.52p pd=2.52u as=0.52p ps=2.52u w=2u l=0.4u
X806 VSS VSS xl2.xhyst.sa VSS nfet_03v3 ad=1.6984p pd=8.6u as=1.0036p ps=4.38u w=3.86u l=0.5u
X807 xl0.xpre.fa vb2 xl0.oa VSS nfet_03v3 ad=1.1752p pd=5.04u as=1.1752p ps=5.04u w=4.52u l=0.5u
X808 VSS vbn xl0.xpre.fb VSS nfet_03v3 ad=0.65p pd=3.02u as=0.65p ps=3.02u w=2.5u l=1u
X809 RX0_O xl0.xout.i2 VDD VDD pfet_03v3 ad=1.3p pd=5.52u as=1.3p ps=5.52u w=5u l=0.28u
X810 VDD VDD VDD VDD pfet_03v3 ad=0.52p pd=2.52u as=0 ps=0 w=2u l=0.5u
X811 xl0.d2b VSS VSS VSS nfet_03v3 ad=1.0036p pd=4.38u as=1.6984p ps=8.6u w=3.86u l=0.5u
X812 xl0.xpre.tp vref xl0.xpre.fa xl0.xpre.tp pfet_03v3 ad=1.248p pd=5.32u as=1.248p ps=5.32u w=4.8u l=0.4u
X813 xl2.xhyst.ts vbn VSS VSS nfet_03v3 ad=0.65p pd=3.02u as=0.65p ps=3.02u w=2.5u l=1u
X814 xl0.xpre.fa vb2 xl0.oa VSS nfet_03v3 ad=1.1752p pd=5.04u as=1.1752p ps=5.04u w=4.52u l=0.5u
X815 xl2.xpre.tp xl2.gn xl2.xpre.fb xl2.xpre.tp pfet_03v3 ad=1.248p pd=5.32u as=1.248p ps=5.32u w=4.8u l=0.4u
X816 xl0.d2a xl0.d2b VDD VDD pfet_03v3 ad=0.52p pd=2.52u as=0.52p ps=2.52u w=2u l=0.4u
X817 VDD xl0.rlb_m1 VSS ppolyf_u_1k r_width=2u r_length=9.11u
X818 xl2.xpre.fb xl2.gn xl2.xpre.tp xl2.xpre.tp pfet_03v3 ad=1.248p pd=5.32u as=1.248p ps=5.32u w=4.8u l=0.4u
X819 xl0.xpre.tn vref xl0.oa VSS nfet_03v3 ad=1.235p pd=5.27u as=1.235p ps=5.27u w=4.75u l=0.5u
X820 VSS vbn xl1.xpre.fb VSS nfet_03v3 ad=0.65p pd=3.02u as=0.65p ps=3.02u w=2.5u l=1u
X821 xl0.xpre.fa VSS VSS VSS nfet_03v3 ad=0.65p pd=3.02u as=1.1p ps=5.88u w=2.5u l=1u
X822 RX2_O xl2.xout.i2 VDD VDD pfet_03v3 ad=1.3p pd=5.52u as=1.3p ps=5.52u w=5u l=0.28u
X823 xl0.xpre.fb vb2 xl0.ob VSS nfet_03v3 ad=1.1752p pd=5.04u as=1.1752p ps=5.04u w=4.52u l=0.5u
X824 VDD vbp xl1.xpre.tp VDD pfet_03v3 ad=1.3p pd=5.52u as=1.3p ps=5.52u w=5u l=1u
X825 VSS VSS xl1.xhyst.sb VSS nfet_03v3 ad=1.6984p pd=8.6u as=1.0036p ps=4.38u w=3.86u l=0.5u
X826 xl1.xpre.tp xl1.gp xl1.xpre.fa xl1.xpre.tp pfet_03v3 ad=1.248p pd=5.32u as=1.248p ps=5.32u w=4.8u l=0.4u
X827 vbp vbn VSS VSS nfet_03v3 ad=0.65p pd=3.02u as=0.65p ps=3.02u w=2.5u l=1u
X828 xl0.xpre.tp vref xl0.xpre.fa xl0.xpre.tp pfet_03v3 ad=1.248p pd=5.32u as=1.248p ps=5.32u w=4.8u l=0.4u
X829 xl0.xpre.tp vref xl0.xpre.fb xl0.xpre.tp pfet_03v3 ad=1.248p pd=5.32u as=1.248p ps=5.32u w=4.8u l=0.4u
X830 xl2.xpre.fa xl2.gp xl2.xpre.tp xl2.xpre.tp pfet_03v3 ad=1.248p pd=5.32u as=1.248p ps=5.32u w=4.8u l=0.4u
X831 xbias.rb_m3 vbn VSS ppolyf_u_1k r_width=2u r_length=22.27u
X832 VDD xl1.d2b xl1.xout.d3 VDD pfet_03v3 ad=0.52p pd=2.52u as=0.52p ps=2.52u w=2u l=0.4u
X833 VDD xl0.d2b xl0.xout.d3 VDD pfet_03v3 ad=0.52p pd=2.52u as=0.52p ps=2.52u w=2u l=0.4u
X834 xl0.xpre.tn xl0.gn xl0.ob VSS nfet_03v3 ad=1.235p pd=5.27u as=1.235p ps=5.27u w=4.75u l=0.5u
X835 VDD xl1.d2b xl1.d2a VDD pfet_03v3 ad=0.52p pd=2.52u as=0.52p ps=2.52u w=2u l=0.4u
X836 VDD xl0.d2b xl0.d2b VDD pfet_03v3 ad=0.52p pd=2.52u as=0.52p ps=2.52u w=2u l=0.4u
X837 xl1.xpre.fb xl1.gn xl1.xpre.tp xl1.xpre.tp pfet_03v3 ad=1.248p pd=5.32u as=1.248p ps=5.32u w=4.8u l=0.4u
X838 xl0.xpre.fa vbn VSS VSS nfet_03v3 ad=0.65p pd=3.02u as=0.65p ps=3.02u w=2.5u l=1u
X839 VDD VDD VDD VDD pfet_03v3 ad=0.962p pd=4.22u as=0 ps=0 w=3.7u l=0.28u
X840 xl0.xpre.tp vbp VDD VDD pfet_03v3 ad=1.3p pd=5.52u as=1.3p ps=5.52u w=5u l=1u
X841 xl0.xpre.tn vref xl0.oa VSS nfet_03v3 ad=1.235p pd=5.27u as=1.235p ps=5.27u w=4.75u l=0.5u
X842 xl0.d2b xl0.d2a VDD VDD pfet_03v3 ad=0.52p pd=2.52u as=0.52p ps=2.52u w=2u l=0.4u
X843 xl0.xpre.tp xl0.gn xl0.xpre.fb xl0.xpre.tp pfet_03v3 ad=1.248p pd=5.32u as=1.248p ps=5.32u w=4.8u l=0.4u
X844 xl1.xpre.tp xl1.gn xl1.xpre.fb xl1.xpre.tp pfet_03v3 ad=1.248p pd=5.32u as=1.248p ps=5.32u w=4.8u l=0.4u
X845 xl2.xpre.tn xl2.gn xl2.ob VSS nfet_03v3 ad=1.235p pd=5.27u as=1.235p ps=5.27u w=4.75u l=0.5u
X846 xl0.xout.n3a VSS VSS VSS nfet_03v3 ad=0.6734p pd=3.11u as=1.1396p ps=6.06u w=2.59u l=0.28u
X847 xl1.xpre.fb vref xl1.xpre.tp xl1.xpre.tp pfet_03v3 ad=1.248p pd=5.32u as=1.248p ps=5.32u w=4.8u l=0.4u
X848 xl2.xpre.tp xl2.gn xl2.xpre.fb xl2.xpre.tp pfet_03v3 ad=1.248p pd=5.32u as=1.248p ps=5.32u w=4.8u l=0.4u
X849 VSS vbn xl0.xpre.fa VSS nfet_03v3 ad=0.65p pd=3.02u as=0.65p ps=3.02u w=2.5u l=1u
X850 VDD xl0.xout.i1 xl0.xout.i2 VDD pfet_03v3 ad=0.975p pd=4.27u as=0.975p ps=4.27u w=3.75u l=0.28u
X851 xl2.xpre.tn xl2.gp xl2.oa VSS nfet_03v3 ad=1.235p pd=5.27u as=1.235p ps=5.27u w=4.75u l=0.5u
X852 VSS vbn xl1.xpre.fb VSS nfet_03v3 ad=0.65p pd=3.02u as=0.65p ps=3.02u w=2.5u l=1u
X853 VSS vbn xl0.xpre.tn VSS nfet_03v3 ad=0.65p pd=3.02u as=0.65p ps=3.02u w=2.5u l=1u
X854 xl2.xhyst.ts vbn VSS VSS nfet_03v3 ad=0.65p pd=3.02u as=0.65p ps=3.02u w=2.5u l=1u
D9 xl2.gn VDD diode_pd2nw_03v3 pj=26u area=40p
X855 xl0.ob xl0.gn xl0.xpre.tn VSS nfet_03v3 ad=1.235p pd=5.27u as=1.235p ps=5.27u w=4.75u l=0.5u
X856 xl2.xpre.fb vref xl2.xpre.tp xl2.xpre.tp pfet_03v3 ad=2.112p pd=10.48u as=1.248p ps=5.32u w=4.8u l=0.4u
X857 xl0.xhyst.ts VSS VSS VSS nfet_03v3 ad=0.65p pd=3.02u as=1.1p ps=5.88u w=2.5u l=1u
X858 xl2.xpre.fb xl2.gn xl2.xpre.tp xl2.xpre.tp pfet_03v3 ad=1.248p pd=5.32u as=1.248p ps=5.32u w=4.8u l=0.4u
X859 xl0.ob xl0.gn xl0.xpre.tn VSS nfet_03v3 ad=1.235p pd=5.27u as=1.235p ps=5.27u w=4.75u l=0.5u
X860 VDD xbias.enb xbias.nrb VDD pfet_03v3 ad=1.3p pd=5.52u as=1.3p ps=5.52u w=5u l=0.5u
X861 VDD VDD xbias.nrb VDD pfet_03v3 ad=2.2p pd=10.88u as=1.3p ps=5.52u w=5u l=0.5u
X862 xl1.xpre.tp xl1.gp xl1.xpre.fa xl1.xpre.tp pfet_03v3 ad=1.248p pd=5.32u as=1.248p ps=5.32u w=4.8u l=0.4u
X863 xl1.oa vref xl1.xpre.tn VSS nfet_03v3 ad=1.235p pd=5.27u as=1.235p ps=5.27u w=4.75u l=0.5u
X864 xl0.xpre.fb vbn VSS VSS nfet_03v3 ad=0.65p pd=3.02u as=0.65p ps=3.02u w=2.5u l=1u
X865 xl0.oa xl0.gp xl0.xpre.tn VSS nfet_03v3 ad=1.235p pd=5.27u as=1.235p ps=5.27u w=4.75u l=0.5u
X866 xl2.xhyst.sb xl2.ob xl2.d2b VSS nfet_03v3 ad=1.0036p pd=4.38u as=1.0036p ps=4.38u w=3.86u l=0.5u
X867 VSS vbn xl2.xpre.fb VSS nfet_03v3 ad=0.65p pd=3.02u as=0.65p ps=3.02u w=2.5u l=1u
X868 VDD xbias.enb xbias.nrb VDD pfet_03v3 ad=1.3p pd=5.52u as=1.3p ps=5.52u w=5u l=0.5u
X869 VDD xl2.d2a xl2.d2a VDD pfet_03v3 ad=0.52p pd=2.52u as=0.52p ps=2.52u w=2u l=0.4u
X870 xl0.d2a xl0.d2a VDD VDD pfet_03v3 ad=0.52p pd=2.52u as=0.52p ps=2.52u w=2u l=0.4u
X871 xl2.xpre.fb xl2.gn xl2.xpre.tp xl2.xpre.tp pfet_03v3 ad=1.248p pd=5.32u as=1.248p ps=5.32u w=4.8u l=0.4u
X872 xl0.xpre.tn vbn VSS VSS nfet_03v3 ad=0.65p pd=3.02u as=0.65p ps=3.02u w=2.5u l=1u
X873 xl2.d2a VDD VDD VDD pfet_03v3 ad=0.52p pd=2.52u as=0.88p ps=4.88u w=2u l=0.4u
X874 xl2.xout.d3 xl2.d2b VDD VDD pfet_03v3 ad=0.52p pd=2.52u as=0.52p ps=2.52u w=2u l=0.4u
X875 xl0.xpre.tp VDD VDD VDD pfet_03v3 ad=1.3p pd=5.52u as=2.2p ps=10.88u w=5u l=1u
X876 xl1.ob vb2 xl1.xpre.fb VSS nfet_03v3 ad=1.1752p pd=5.04u as=1.1752p ps=5.04u w=4.52u l=0.5u
X877 VSS VSS xl0.xout.d3 VSS nfet_03v3 ad=1.1396p pd=6.06u as=0.6734p ps=3.11u w=2.59u l=0.28u
X878 VSS vbn xl2.xhyst.ts VSS nfet_03v3 ad=0.65p pd=3.02u as=0.65p ps=3.02u w=2.5u l=1u
D10 VSS xl2.gn diode_nd2ps_03v3 pj=26u area=40p
X879 xl0.xpre.tp xl0.gp xl0.xpre.fa xl0.xpre.tp pfet_03v3 ad=1.248p pd=5.32u as=1.248p ps=5.32u w=4.8u l=0.4u
X880 xl1.ob vref xl1.xpre.tn VSS nfet_03v3 ad=1.235p pd=5.27u as=1.235p ps=5.27u w=4.75u l=0.5u
X881 vbn VSS VSS VSS nfet_03v3 ad=0.65p pd=3.02u as=1.1p ps=5.88u w=2.5u l=1u
X882 VSS xl1.xout.n3a xl1.xout.n3a VSS nfet_03v3 ad=0.6734p pd=3.11u as=0.6734p ps=3.11u w=2.59u l=0.28u
X883 VDD vbp vbp VDD pfet_03v3 ad=1.3p pd=5.52u as=1.3p ps=5.52u w=5u l=1u
X884 xl2.xout.nm xl2.xout.d3 xl2.xout.nd VSS nfet_03v3 ad=0.52p pd=2.52u as=0.52p ps=2.52u w=2u l=0.28u
X885 xl2.xout.i2 VDD VDD VDD pfet_03v3 ad=0.975p pd=4.27u as=1.65p ps=8.38u w=3.75u l=0.28u
X886 xl0.xpre.fa xl0.gp xl0.xpre.tp xl0.xpre.tp pfet_03v3 ad=1.248p pd=5.32u as=1.248p ps=5.32u w=4.8u l=0.4u
X887 xl1.xpre.fa vref xl1.xpre.tp xl1.xpre.tp pfet_03v3 ad=1.248p pd=5.32u as=1.248p ps=5.32u w=4.8u l=0.4u
X888 xl1.xpre.tn xl1.gp xl1.oa VSS nfet_03v3 ad=1.235p pd=5.27u as=1.235p ps=5.27u w=4.75u l=0.5u
X889 xbias.rdt_m2 xbias.rdt_m3 VSS ppolyf_u_1k r_width=2u r_length=21.01u
X890 xl1.xpre.fa vbn VSS VSS nfet_03v3 ad=0.65p pd=3.02u as=0.65p ps=3.02u w=2.5u l=1u
X891 xl0.xpre.tp vref xl0.xpre.fb xl0.xpre.tp pfet_03v3 ad=1.248p pd=5.32u as=1.248p ps=5.32u w=4.8u l=0.4u
X892 xl2.xpre.fb vref xl2.xpre.tp xl2.xpre.tp pfet_03v3 ad=1.248p pd=5.32u as=1.248p ps=5.32u w=4.8u l=0.4u
X893 VSS VSS VSS ppolyf_u_1k r_width=2u r_length=9.11u
X894 xl1.xpre.fa vref xl1.xpre.tp xl1.xpre.tp pfet_03v3 ad=1.248p pd=5.32u as=1.248p ps=5.32u w=4.8u l=0.4u
X895 xl1.xpre.tn vbn VSS VSS nfet_03v3 ad=0.65p pd=3.02u as=0.65p ps=3.02u w=2.5u l=1u
X896 xl2.xpre.fa vref xl2.xpre.tp xl2.xpre.tp pfet_03v3 ad=1.248p pd=5.32u as=1.248p ps=5.32u w=4.8u l=0.4u
X897 VSS vbn xl0.xhyst.ts VSS nfet_03v3 ad=0.65p pd=3.02u as=0.65p ps=3.02u w=2.5u l=1u
X898 xl1.xout.d3 xl1.d2b VDD VDD pfet_03v3 ad=0.52p pd=2.52u as=0.52p ps=2.52u w=2u l=0.4u
X899 xl0.xpre.fa xl0.gp xl0.xpre.tp xl0.xpre.tp pfet_03v3 ad=1.248p pd=5.32u as=1.248p ps=5.32u w=4.8u l=0.4u
X900 xl2.xpre.tp vref xl2.xpre.fa xl2.xpre.tp pfet_03v3 ad=1.248p pd=5.32u as=1.248p ps=5.32u w=4.8u l=0.4u
X901 VSS vbn xl1.xhyst.ts VSS nfet_03v3 ad=0.65p pd=3.02u as=0.65p ps=3.02u w=2.5u l=1u
X902 xl1.d2b xl1.d2b VDD VDD pfet_03v3 ad=0.52p pd=2.52u as=0.52p ps=2.52u w=2u l=0.4u
X903 VDD VDD xl1.xout.i2 VDD pfet_03v3 ad=1.65p pd=8.38u as=0.975p ps=4.27u w=3.75u l=0.28u
X904 xl0.xpre.fb vref xl0.xpre.tp xl0.xpre.tp pfet_03v3 ad=1.248p pd=5.32u as=1.248p ps=5.32u w=4.8u l=0.4u
X905 xl1.xpre.tp xl1.gn xl1.xpre.fb xl1.xpre.tp pfet_03v3 ad=1.248p pd=5.32u as=1.248p ps=5.32u w=4.8u l=0.4u
X906 xl1.xpre.fa vref xl1.xpre.tp xl1.xpre.tp pfet_03v3 ad=1.248p pd=5.32u as=1.248p ps=5.32u w=4.8u l=0.4u
X907 xl0.xout.nd EN VDD VDD pfet_03v3 ad=0.78p pd=3.52u as=0.78p ps=3.52u w=3u l=0.28u
X908 VSS VSS VSS ppolyf_u_1k r_width=2u r_length=8.86u
X909 xl0.xhyst.sa xl0.oa xl0.d2a VSS nfet_03v3 ad=1.0036p pd=4.38u as=1.0036p ps=4.38u w=3.86u l=0.5u
X910 xl0.xpre.tp xl0.gp xl0.xpre.fa xl0.xpre.tp pfet_03v3 ad=1.248p pd=5.32u as=1.248p ps=5.32u w=4.8u l=0.4u
X911 xl2.xpre.fa xl2.gp xl2.xpre.tp xl2.xpre.tp pfet_03v3 ad=1.248p pd=5.32u as=1.248p ps=5.32u w=4.8u l=0.4u
X912 VSS vbn xl0.xpre.tn VSS nfet_03v3 ad=0.65p pd=3.02u as=0.65p ps=3.02u w=2.5u l=1u
X913 vbn vbn VSS VSS nfet_03v3 ad=0.65p pd=3.02u as=0.65p ps=3.02u w=2.5u l=1u
X914 VDD xl0.d2b xl0.d2a VDD pfet_03v3 ad=0.52p pd=2.52u as=0.52p ps=2.52u w=2u l=0.4u
X915 VDD vbp xl0.xpre.tp VDD pfet_03v3 ad=1.3p pd=5.52u as=1.3p ps=5.52u w=5u l=1u
X916 xl1.xpre.tp vref xl1.xpre.fb xl1.xpre.tp pfet_03v3 ad=1.248p pd=5.32u as=1.248p ps=5.32u w=4.8u l=0.4u
X917 xl2.xpre.tp xl2.gn xl2.xpre.fb xl2.xpre.tp pfet_03v3 ad=1.248p pd=5.32u as=1.248p ps=5.32u w=4.8u l=0.4u
X918 VSS vbn xl2.xpre.fa VSS nfet_03v3 ad=0.65p pd=3.02u as=0.65p ps=3.02u w=2.5u l=1u
X919 xl2.d2a xl2.oa xl2.xhyst.sa VSS nfet_03v3 ad=1.0036p pd=4.38u as=1.0036p ps=4.38u w=3.86u l=0.5u
X920 VSS VSS VSS ppolyf_u_1k r_width=2u r_length=9.11u
X921 xl2.d2b VDD VDD VDD pfet_03v3 ad=0.52p pd=2.52u as=0.88p ps=4.88u w=2u l=0.5u
X922 VDD vbp xl1.xpre.tp VDD pfet_03v3 ad=1.3p pd=5.52u as=1.3p ps=5.52u w=5u l=1u
X923 xl0.xpre.fa vbn VSS VSS nfet_03v3 ad=0.65p pd=3.02u as=0.65p ps=3.02u w=2.5u l=1u
X924 vbp vbp VDD VDD pfet_03v3 ad=1.3p pd=5.52u as=1.3p ps=5.52u w=5u l=1u
X925 xl0.xpre.tp vbp VDD VDD pfet_03v3 ad=1.3p pd=5.52u as=1.3p ps=5.52u w=5u l=1u
X926 xl0.xpre.fa vb2 xl0.oa VSS nfet_03v3 ad=1.1752p pd=5.04u as=1.1752p ps=5.04u w=4.52u l=0.5u
X927 xl0.xpre.tp vref xl0.xpre.fa xl0.xpre.tp pfet_03v3 ad=1.248p pd=5.32u as=1.248p ps=5.32u w=4.8u l=0.4u
X928 xl1.xpre.tp vref xl1.xpre.fa xl1.xpre.tp pfet_03v3 ad=1.248p pd=5.32u as=1.248p ps=5.32u w=4.8u l=0.4u
D11 VSS xl0.gp diode_nd2ps_03v3 pj=26u area=40p
X929 xl1.xpre.fb xl1.gn xl1.xpre.tp xl1.xpre.tp pfet_03v3 ad=1.248p pd=5.32u as=1.248p ps=5.32u w=4.8u l=0.4u
X930 xl0.xpre.tn vbn VSS VSS nfet_03v3 ad=0.65p pd=3.02u as=0.65p ps=3.02u w=2.5u l=1u
X931 VDD VDD VDD VDD pfet_03v3 ad=0.52p pd=2.52u as=0 ps=0 w=2u l=0.5u
X932 VSS vbn xl2.xpre.fb VSS nfet_03v3 ad=0.65p pd=3.02u as=0.65p ps=3.02u w=2.5u l=1u
X933 xl0.xpre.fa vb2 xl0.oa VSS nfet_03v3 ad=1.1752p pd=5.04u as=1.1752p ps=5.04u w=4.52u l=0.5u
X934 xl2.oa vb2 xl2.xpre.fa VSS nfet_03v3 ad=1.1752p pd=5.04u as=1.1752p ps=5.04u w=4.52u l=0.5u
X935 xl1.xpre.tn VSS VSS VSS nfet_03v3 ad=0.65p pd=3.02u as=1.1p ps=5.88u w=2.5u l=1u
X936 VDD vbp xl2.xpre.tp VDD pfet_03v3 ad=1.3p pd=5.52u as=1.3p ps=5.52u w=5u l=1u
X937 xl1.oa vref xl1.xpre.tn VSS nfet_03v3 ad=1.235p pd=5.27u as=1.235p ps=5.27u w=4.75u l=0.5u
X938 VDD EN xl2.d2a VDD pfet_03v3 ad=0.52p pd=2.52u as=0.52p ps=2.52u w=2u l=0.5u
X939 xl1.xout.n3a xl1.d2a VDD VDD pfet_03v3 ad=0.52p pd=2.52u as=0.52p ps=2.52u w=2u l=0.4u
X940 xl0.xout.n3a xl0.d2a VDD VDD pfet_03v3 ad=0.52p pd=2.52u as=0.52p ps=2.52u w=2u l=0.4u
X941 vbp VDD VDD VDD pfet_03v3 ad=0.52p pd=2.52u as=0.88p ps=4.88u w=2u l=0.5u
X942 xl0.d2a xl0.d2b VDD VDD pfet_03v3 ad=0.52p pd=2.52u as=0.52p ps=2.52u w=2u l=0.4u
X943 VDD xl0.rla_m1 VSS ppolyf_u_1k r_width=2u r_length=9.11u
X944 VDD VDD xl2.xpre.tp VDD pfet_03v3 ad=2.2p pd=10.88u as=1.3p ps=5.52u w=5u l=1u
X945 xl2.oa VSS VSS VSS nfet_03v3 ad=1.1752p pd=5.04u as=1.9888p ps=9.92u w=4.52u l=0.5u
X946 xl0.xpre.tn xl0.gp xl0.oa VSS nfet_03v3 ad=1.235p pd=5.27u as=1.235p ps=5.27u w=4.75u l=0.5u
X947 xl1.ob vref xl1.xpre.tn VSS nfet_03v3 ad=1.235p pd=5.27u as=1.235p ps=5.27u w=4.75u l=0.5u
X948 xl0.xpre.tp vref xl0.xpre.fb xl0.xpre.tp pfet_03v3 ad=1.248p pd=5.32u as=2.112p ps=10.48u w=4.8u l=0.4u
X949 xl2.xpre.fb xl2.gn xl2.xpre.tp xl2.xpre.tp pfet_03v3 ad=1.248p pd=5.32u as=1.248p ps=5.32u w=4.8u l=0.4u
X950 VDD xl0.d2a xl0.d2b VDD pfet_03v3 ad=0.52p pd=2.52u as=0.52p ps=2.52u w=2u l=0.4u
X951 xl0.xpre.fa xl0.gp xl0.xpre.tp xl0.xpre.tp pfet_03v3 ad=1.248p pd=5.32u as=1.248p ps=5.32u w=4.8u l=0.4u
X952 xl1.xpre.tp vref xl1.xpre.fa xl1.xpre.tp pfet_03v3 ad=1.248p pd=5.32u as=1.248p ps=5.32u w=4.8u l=0.4u
X953 xl2.xpre.fb vbn VSS VSS nfet_03v3 ad=0.65p pd=3.02u as=0.65p ps=3.02u w=2.5u l=1u
X954 xl2.oa xl2.gp xl2.xpre.tn VSS nfet_03v3 ad=1.235p pd=5.27u as=1.235p ps=5.27u w=4.75u l=0.5u
X955 xl2.xpre.tp xl2.gp xl2.xpre.fa xl2.xpre.tp pfet_03v3 ad=1.248p pd=5.32u as=1.248p ps=5.32u w=4.8u l=0.4u
X956 xl0.xpre.tn xl0.gn xl0.ob VSS nfet_03v3 ad=1.235p pd=5.27u as=1.235p ps=5.27u w=4.75u l=0.5u
X957 xl1.oa vref xl1.xpre.tn VSS nfet_03v3 ad=1.235p pd=5.27u as=1.235p ps=5.27u w=4.75u l=0.5u
X958 VDD xl2.d2a xl2.xout.n3a VDD pfet_03v3 ad=0.52p pd=2.52u as=0.52p ps=2.52u w=2u l=0.4u
X959 xl1.xpre.tp vbp VDD VDD pfet_03v3 ad=1.3p pd=5.52u as=1.3p ps=5.52u w=5u l=1u
X960 xl1.xpre.fa xl1.gp xl1.xpre.tp xl1.xpre.tp pfet_03v3 ad=1.248p pd=5.32u as=1.248p ps=5.32u w=4.8u l=0.4u
X961 xl2.xpre.fa xl2.gp xl2.xpre.tp xl2.xpre.tp pfet_03v3 ad=1.248p pd=5.32u as=1.248p ps=5.32u w=4.8u l=0.4u
X962 vbp vbp VDD VDD pfet_03v3 ad=1.3p pd=5.52u as=1.3p ps=5.52u w=5u l=1u
X963 xl0.xpre.fb vbn VSS VSS nfet_03v3 ad=0.65p pd=3.02u as=0.65p ps=3.02u w=2.5u l=1u
X964 VDD VDD VDD VDD pfet_03v3 ad=0.65p pd=3.02u as=0 ps=0 w=2.5u l=0.28u
X965 xl0.xhyst.ts xl0.xhyst.sb VSS ppolyf_u_1k r_width=2u r_length=8.86u
X966 xl0.d2a VSS VSS VSS nfet_03v3 ad=1.0036p pd=4.38u as=1.6984p ps=8.6u w=3.86u l=0.5u
X967 xl2.xpre.tp vbp VDD VDD pfet_03v3 ad=1.3p pd=5.52u as=1.3p ps=5.52u w=5u l=1u
X968 xl2.ob xl2.gn xl2.xpre.tn VSS nfet_03v3 ad=1.235p pd=5.27u as=1.235p ps=5.27u w=4.75u l=0.5u
X969 xl0.xpre.tn vref xl0.ob VSS nfet_03v3 ad=1.235p pd=5.27u as=1.235p ps=5.27u w=4.75u l=0.5u
X970 xl0.xpre.tp vbp VDD VDD pfet_03v3 ad=1.3p pd=5.52u as=1.3p ps=5.52u w=5u l=1u
X971 xl0.xpre.tp vref xl0.xpre.fb xl0.xpre.tp pfet_03v3 ad=1.248p pd=5.32u as=1.248p ps=5.32u w=4.8u l=0.4u
X972 xl1.xpre.tp xl1.gp xl1.xpre.fa xl1.xpre.tp pfet_03v3 ad=1.248p pd=5.32u as=1.248p ps=5.32u w=4.8u l=0.4u
X973 xl2.ob vref xl2.xpre.tn VSS nfet_03v3 ad=1.235p pd=5.27u as=1.235p ps=5.27u w=4.75u l=0.5u
X974 xl0.xpre.fb vref xl0.xpre.tp xl0.xpre.tp pfet_03v3 ad=1.248p pd=5.32u as=1.248p ps=5.32u w=4.8u l=0.4u
X975 VSS vbn xl2.xpre.fa VSS nfet_03v3 ad=0.65p pd=3.02u as=0.65p ps=3.02u w=2.5u l=1u
X976 VSS vbn xl1.xpre.tn VSS nfet_03v3 ad=0.65p pd=3.02u as=0.65p ps=3.02u w=2.5u l=1u
X977 xl0.xpre.tp vref xl0.xpre.fb xl0.xpre.tp pfet_03v3 ad=1.248p pd=5.32u as=1.248p ps=5.32u w=4.8u l=0.4u
X978 xl1.xpre.tp xl1.gn xl1.xpre.fb xl1.xpre.tp pfet_03v3 ad=1.248p pd=5.32u as=1.248p ps=5.32u w=4.8u l=0.4u
X979 xl1.xpre.tp xl1.gn xl1.xpre.fb xl1.xpre.tp pfet_03v3 ad=1.248p pd=5.32u as=1.248p ps=5.32u w=4.8u l=0.4u
X980 vbn vbn VSS VSS nfet_03v3 ad=0.65p pd=3.02u as=0.65p ps=3.02u w=2.5u l=1u
X981 xl2.xpre.tn xl2.gn xl2.ob VSS nfet_03v3 ad=1.235p pd=5.27u as=1.235p ps=5.27u w=4.75u l=0.5u
X982 vbp vbp VDD VDD pfet_03v3 ad=1.3p pd=5.52u as=1.3p ps=5.52u w=5u l=1u
X983 xl2.xpre.fa vref xl2.xpre.tp xl2.xpre.tp pfet_03v3 ad=1.248p pd=5.32u as=1.248p ps=5.32u w=4.8u l=0.4u
X984 VSS vbn xl2.xpre.tn VSS nfet_03v3 ad=0.65p pd=3.02u as=0.65p ps=3.02u w=2.5u l=1u
X985 xl1.xout.nm xl1.xout.d3 xl1.xout.nd VSS nfet_03v3 ad=0.52p pd=2.52u as=0.52p ps=2.52u w=2u l=0.28u
X986 xl1.xpre.fa vbn VSS VSS nfet_03v3 ad=0.65p pd=3.02u as=0.65p ps=3.02u w=2.5u l=1u
X987 RX1_O xl1.xout.i2 VSS VSS nfet_03v3 ad=1.04p pd=4.52u as=1.04p ps=4.52u w=4u l=0.28u
X988 xl1.xpre.fb xl1.gn xl1.xpre.tp xl1.xpre.tp pfet_03v3 ad=1.248p pd=5.32u as=1.248p ps=5.32u w=4.8u l=0.4u
X989 xl0.oa xl0.gp xl0.xpre.tn VSS nfet_03v3 ad=1.235p pd=5.27u as=1.235p ps=5.27u w=4.75u l=0.5u
X990 VDD xl0.d2a xl0.xout.n3a VDD pfet_03v3 ad=0.52p pd=2.52u as=0.52p ps=2.52u w=2u l=0.4u
X991 VSS VSS xl1.xhyst.sa VSS nfet_03v3 ad=1.6984p pd=8.6u as=1.0036p ps=4.38u w=3.86u l=0.5u
X992 VDD vbp xl2.xpre.tp VDD pfet_03v3 ad=1.3p pd=5.52u as=1.3p ps=5.52u w=5u l=1u
X993 xl2.d2b xl2.d2a VDD VDD pfet_03v3 ad=0.52p pd=2.52u as=0.52p ps=2.52u w=2u l=0.4u
X994 VDD xl0.d2a xl0.d2a VDD pfet_03v3 ad=0.52p pd=2.52u as=0.52p ps=2.52u w=2u l=0.4u
X995 xl1.xhyst.sb xl1.ob xl1.d2b VSS nfet_03v3 ad=1.0036p pd=4.38u as=1.0036p ps=4.38u w=3.86u l=0.5u
X996 VDD xbias.enb xbias.nrb VDD pfet_03v3 ad=1.3p pd=5.52u as=1.3p ps=5.52u w=5u l=0.5u
X997 VDD vbp vbp VDD pfet_03v3 ad=1.3p pd=5.52u as=1.3p ps=5.52u w=5u l=1u
X998 xl1.xpre.fb xl1.gn xl1.xpre.tp xl1.xpre.tp pfet_03v3 ad=1.248p pd=5.32u as=1.248p ps=5.32u w=4.8u l=0.4u
X999 xl2.xpre.fb xl2.gn xl2.xpre.tp xl2.xpre.tp pfet_03v3 ad=1.248p pd=5.32u as=1.248p ps=5.32u w=4.8u l=0.4u
X1000 VSS vbn xl0.xpre.fb VSS nfet_03v3 ad=0.65p pd=3.02u as=0.65p ps=3.02u w=2.5u l=1u
X1001 VDD xl1.xout.i2 RX1_O VDD pfet_03v3 ad=1.3p pd=5.52u as=1.3p ps=5.52u w=5u l=0.28u
X1002 VDD vbp xl2.xpre.tp VDD pfet_03v3 ad=1.3p pd=5.52u as=1.3p ps=5.52u w=5u l=1u
X1003 xl2.xpre.tp vref xl2.xpre.fb xl2.xpre.tp pfet_03v3 ad=1.248p pd=5.32u as=1.248p ps=5.32u w=4.8u l=0.4u
X1004 VSS vbn xl1.xpre.fa VSS nfet_03v3 ad=0.65p pd=3.02u as=0.65p ps=3.02u w=2.5u l=1u
X1005 xl1.ob vb2 xl1.xpre.fb VSS nfet_03v3 ad=1.1752p pd=5.04u as=1.1752p ps=5.04u w=4.52u l=0.5u
X1006 VDD vbp xl0.xpre.tp VDD pfet_03v3 ad=1.3p pd=5.52u as=1.3p ps=5.52u w=5u l=1u
X1007 xl1.oa vref xl1.xpre.tn VSS nfet_03v3 ad=1.235p pd=5.27u as=1.235p ps=5.27u w=4.75u l=0.5u
X1008 xl1.xpre.tp xl1.gn xl1.xpre.fb xl1.xpre.tp pfet_03v3 ad=1.248p pd=5.32u as=1.248p ps=5.32u w=4.8u l=0.4u
X1009 xl1.ob vb2 xl1.xpre.fb VSS nfet_03v3 ad=1.1752p pd=5.04u as=1.1752p ps=5.04u w=4.52u l=0.5u
X1010 xl2.xpre.fb vbn VSS VSS nfet_03v3 ad=0.65p pd=3.02u as=0.65p ps=3.02u w=2.5u l=1u
X1011 xbias.rf_m1 VSS VSS ppolyf_u_1k r_width=2u r_length=23.07u
X1012 VSS VSS xl0.xhyst.sb VSS nfet_03v3 ad=1.6984p pd=8.6u as=1.0036p ps=4.38u w=3.86u l=0.5u
X1013 xl0.xpre.tp xl0.gp xl0.xpre.fa xl0.xpre.tp pfet_03v3 ad=1.248p pd=5.32u as=1.248p ps=5.32u w=4.8u l=0.4u
X1014 xl2.xpre.fb vref xl2.xpre.tp xl2.xpre.tp pfet_03v3 ad=1.248p pd=5.32u as=1.248p ps=5.32u w=4.8u l=0.4u
X1015 xl2.xpre.tn vbn VSS VSS nfet_03v3 ad=0.65p pd=3.02u as=0.65p ps=3.02u w=2.5u l=1u
X1016 xl2.xpre.tp vbp VDD VDD pfet_03v3 ad=1.3p pd=5.52u as=1.3p ps=5.52u w=5u l=1u
X1017 xbias.rdb_m2 xbias.rdb_m1 VSS ppolyf_u_1k r_width=2u r_length=19.26u
X1018 xl1.xpre.fa xl1.gp xl1.xpre.tp xl1.xpre.tp pfet_03v3 ad=1.248p pd=5.32u as=1.248p ps=5.32u w=4.8u l=0.4u
X1019 xl1.ob VSS VSS VSS nfet_03v3 ad=1.1752p pd=5.04u as=1.9888p ps=9.92u w=4.52u l=0.5u
X1020 VDD xl0.d2b xl0.xout.d3 VDD pfet_03v3 ad=0.52p pd=2.52u as=0.52p ps=2.52u w=2u l=0.4u
X1021 xl2.xpre.tp vbp VDD VDD pfet_03v3 ad=1.3p pd=5.52u as=1.3p ps=5.52u w=5u l=1u
X1022 xl1.xpre.tp vref xl1.xpre.fa xl1.xpre.tp pfet_03v3 ad=1.248p pd=5.32u as=1.248p ps=5.32u w=4.8u l=0.4u
X1023 VDD xl0.d2b xl0.d2a VDD pfet_03v3 ad=0.52p pd=2.52u as=0.52p ps=2.52u w=2u l=0.4u
X1024 xl0.xpre.fb xl0.gn xl0.xpre.tp xl0.xpre.tp pfet_03v3 ad=1.248p pd=5.32u as=1.248p ps=5.32u w=4.8u l=0.4u
X1025 xl2.xpre.tp xl2.gp xl2.xpre.fa xl2.xpre.tp pfet_03v3 ad=1.248p pd=5.32u as=1.248p ps=5.32u w=4.8u l=0.4u
X1026 xl2.d2a xl2.d2a VDD VDD pfet_03v3 ad=0.52p pd=2.52u as=0.52p ps=2.52u w=2u l=0.4u
X1027 VDD xl2.d2a xl2.xout.n3a VDD pfet_03v3 ad=0.52p pd=2.52u as=0.52p ps=2.52u w=2u l=0.4u
X1028 VDD VDD VDD VDD pfet_03v3 ad=0.962p pd=4.22u as=0 ps=0 w=3.7u l=0.28u
C0 xl1.d2b xl1.rla_m1 0.00475f
C1 xl0.gp xl0.xpre.fb 0.86843f
C2 xl0.ob xl0.oa 0.59251f
C3 xl0.xpre.tp vbp 3.37779f
C4 xl1.xout.d3 EN 0.54374f
C5 xl0.d2a xl0.xout.d3 2.65586f
C6 xbias.rb_m3 xbias.rf_m1 0.04347f
C7 xl0.xpre.tn VDD 0.19528f
C8 xl0.xout.d3 EN 0.54374f
C9 xl0.xpre.tn vbn 0.82513f
C10 xl0.gn RX0_N 0.14621f
C11 xl2.gn xl2.xpre.tn 0.99696f
C12 vref vbp 0.0747f
C13 xl2.xpre.tp xl2.gp 12.8757f
C14 xl0.gn xl0.oa 0.30476f
C15 xbias.rb_m2 vbn 0.03954f
C16 xl1.rlb_m1 xl1.rla_m1 0.39394f
C17 xl2.gp xl2.gn 2.07546f
C18 RX2_P VDD 2.27847f
C19 xl2.gp vb2 0.05601f
C20 xbias.rdb_m3 xbias.rdt_m1 0.41833f
C21 vbn xl0.xpre.fb 1.48704f
C22 xl0.xpre.fa xl0.xpre.fb 0.80129f
C23 xl2.xpre.fa vbn 2.39287f
C24 RX2_O VDD 4.00067f
C25 xl2.xhyst.sa VDD 0.00564f
C26 xl1.xpre.fa vb2 1.75715f
C27 xl2.xhyst.ts vref 0.00271f
C28 xl2.d2a EN 0.18482f
C29 xl1.xpre.fa xl1.xpre.tp 25.3704f
C30 vref xl0.xpre.tp 14.925f
C31 xl1.xout.d3 xl1.xout.nd 0.22426f
C32 xl0.xhyst.ts VDD 0.55022f
C33 xl0.xhyst.ts vbn 0.52623f
C34 VDD xl0.xout.n3a 5.30403f
C35 VDD xl1.xout.n3a 5.30403f
C36 xl2.xout.n3a xl2.d2a 0.37969f
C37 xl0.xhyst.sa VDD 0.00564f
C38 xl0.ob xl0.d2b 0.20289f
C39 xl2.xout.nd xl2.xout.nm 0.2193f
C40 xl2.xpre.fb vbn 1.48704f
C41 xl1.ob xl1.xpre.fa 0
C42 xl2.xpre.tp xl2.gn 13.4594f
C43 xl2.ob xl2.xhyst.sb 0.28465f
C44 xl0.gn vbp 0.26446f
C45 xl2.xpre.tp vb2 0.05309f
C46 xl0.oa xl0.gp 1.25114f
C47 xl2.gn vb2 0.05558f
C48 xl2.ob xl2.xpre.fa 0
C49 vb2 xl1.xpre.tp 0.05309f
C50 xl2.ob xl2.xhyst.sa 0.01084f
C51 xl1.d2b xl1.xhyst.sa 0.20733f
C52 xl0.ob vref 2.70252f
C53 xl0.xout.i1 EN 0.26447f
C54 xl1.xpre.fa xl1.gn 0.67123f
C55 RX0_N VDD 2.56543f
C56 xl2.d2a xl2.xout.d3 2.65586f
C57 xl1.xout.i2 EN 0.31483f
C58 xl0.gn xl0.xpre.tp 13.4594f
C59 xl1.ob vb2 0.57476f
C60 xl0.xhyst.sb xl0.xhyst.sa 0.77697f
C61 xl1.d2b xl1.xout.d3 0.35626f
C62 xl0.oa VDD 1.59618f
C63 vbn xl0.oa 0.33374f
C64 xl0.xpre.fa xl0.oa 2.90441f
C65 xl2.xpre.fb xl2.ob 2.81909f
C66 RX2_N VDD 2.56543f
C67 xl0.gn vref 2.33633f
C68 xl1.rlb_m1 xl1.xhyst.sa 0
C69 xbias.vf VDD 0.00294f
C70 xl0.gp vbp 0.26446f
C71 xbias.vf vbn 1.54524f
C72 VDD RX1_O 4.00061f
C73 vb2 xl1.gn 0.05558f
C74 xl1.gn xl1.xpre.tp 13.4594f
C75 xbias.rdt_m3 xbias.rdt_m1 0.08167f
C76 xl2.d2b EN 0.43087f
C77 vbp RX0_P 0.03875f
C78 xl0.ob xl0.gn 1.03804f
C79 vb2 EN 2.2084f
C80 xl2.xout.n3a xl2.d2b 0.50895f
C81 xl2.xout.i2 xl2.xout.i1 0.28557f
C82 xl0.xout.i1 xl0.xout.i2 0.28557f
C83 RX1_N vbp 0.03712f
C84 vbp RX1_P 0.03967f
C85 xl0.gp xl0.xpre.tp 12.8757f
C86 xl1.ob xl1.gn 1.03804f
C87 xl1.xpre.tn vref 1.62411f
C88 xl1.xout.i2 xl1.xout.i1 0.28557f
C89 VDD vbp 0.11404p
C90 xbias.nrb VDD 5.10108f
C91 vbn vbp 7.61409f
C92 xbias.nrb vbn 0.04436f
C93 xl1.gp vbp 0.26446f
C94 xl1.d2a EN 0.18482f
C95 xl0.gp vref 1.91483f
C96 vref xl1.oa 2.14744f
C97 xl2.xout.i2 EN 0.31483f
C98 xbias.vf xbias.enb 1.18587f
C99 xl2.xout.nd VDD 2.72518f
C100 xl1.xout.d3 xl1.xout.n3a 0.59994f
C101 xl0.rlb_m1 xl0.rla_m1 0.39394f
C102 VDD xl0.d2b 12.259f
C103 xl0.xout.d3 xl0.xout.n3a 0.59994f
C104 xbias.rb_m3 xbias.rb_m1 0.06955f
C105 xl1.xhyst.sb xl1.xhyst.sa 0.77697f
C106 xl2.xhyst.ts VDD 0.55022f
C107 xl2.xhyst.ts vbn 0.52623f
C108 VDD xl0.xpre.tp 11.3411f
C109 xl2.xout.d3 xl2.d2b 0.35626f
C110 xl0.xpre.fa xl0.xpre.tp 25.3704f
C111 xl0.ob xl0.gp 0.3633f
C112 xl2.xout.i1 EN 0.26447f
C113 xl2.xhyst.sa xl2.d2a 1.70252f
C114 xl1.xpre.fa xl1.xpre.fb 0.80129f
C115 vref VDD 2.13357f
C116 vbn vref 2.95645f
C117 VDD RX0_O 3.99882f
C118 xl0.xpre.fa vref 2.64932f
C119 xl2.xpre.fa xl2.oa 2.90441f
C120 vref xl1.gp 1.91483f
C121 xl2.xhyst.sa xl2.rlb_m1 0
C122 xl0.rlb_m1 xl0.xhyst.sa 0
C123 xbias.enb vbp 1.1468f
C124 xbias.nrb xbias.enb 0.83214f
C125 xl2.xhyst.sa xl2.oa 0.20057f
C126 xl0.d2a EN 0.18482f
C127 xl0.xhyst.sb xl0.d2b 0.85915f
C128 xl0.gn xl0.gp 2.07546f
C129 xl2.xout.n3a EN 0.07539f
C130 xl0.ob VDD 1.9912f
C131 xl0.ob vbn 0.19136f
C132 xl0.xpre.fa xl0.ob 0
C133 xl1.xpre.fb vb2 2.14447f
C134 RX2_P xl2.gp 0.14621f
C135 xl1.xpre.fb xl1.xpre.tp 25.7437f
C136 xl2.xpre.fa xl2.gp 2.44274f
C137 vbp xbias.nmid 0.03404f
C138 xl2.ob vref 2.70252f
C139 vref xbias.enb 0.14548f
C140 xl2.rla_m1 xl2.d2a 0.00155f
C141 xl0.xout.nd xl0.xout.nm 0.2193f
C142 xl0.gn VDD 4.52025f
C143 xbias.rb_m1 EN 0.00476f
C144 xl0.gn vbn 0.11482f
C145 xl0.xpre.fa xl0.gn 0.67123f
C146 xl1.xout.nd EN 0.90578f
C147 xl1.ob xl1.xpre.fb 2.81909f
C148 xl2.rla_m1 xl2.rlb_m1 0.39394f
C149 xl1.xpre.tn xl1.oa 9.87797f
C150 xl1.xout.d3 xl1.xout.nm 0.01765f
C151 xl2.xout.d3 EN 0.54374f
C152 xl1.d2b xl1.d2a 2.80463f
C153 xl0.xhyst.sb xl0.ob 0.28465f
C154 xbias.enb xbias.rdt_m1 0.0052f
C155 EN xl1.xout.i1 0.26447f
C156 xl2.xhyst.sb xl2.d2b 0.85915f
C157 xl0.xout.nd VDD 2.72518f
C158 xl1.ob xl1.d2b 0.20289f
C159 xl2.xpre.fb xl2.gp 0.86843f
C160 xl0.xout.i2 EN 0.31483f
C161 xl2.xout.n3a xl2.xout.d3 0.59994f
C162 vref xbias.rdt_m2 0.00234f
C163 xl1.xpre.fb xl1.gn 2.59553f
C164 xl0.gp RX0_P 0.14621f
C165 vref xbias.nmid 0
C166 xl2.xhyst.sa xl2.d2b 0.20733f
C167 vb2 xl0.xpre.fb 2.14447f
C168 xl2.xpre.tp xl2.xpre.fa 25.3704f
C169 xl2.xpre.fa xl2.gn 0.67123f
C170 xl2.xpre.fa vb2 1.75715f
C171 xl1.xpre.tn VDD 0.19528f
C172 xl1.xpre.tn vbn 0.82513f
C173 xl0.xout.d3 xl0.d2b 0.35626f
C174 xl1.xpre.tn xl1.gp 1.20627f
C175 xl0.gp VDD 4.53691f
C176 vbn xl0.gp 0.14191f
C177 xl0.xpre.fa xl0.gp 2.44274f
C178 VDD xl1.oa 1.59618f
C179 vbn xl1.oa 0.33374f
C180 xl1.gp xl1.oa 1.25114f
C181 xl1.xout.nd xl1.xout.i1 0.21598f
C182 xl1.d2b EN 0.43087f
C183 VDD RX0_P 2.27023f
C184 xl2.xout.i2 RX2_O 0.50509f
C185 xl2.xpre.fb xl2.xpre.tp 25.7437f
C186 xl2.xpre.fb xl2.gn 2.59553f
C187 xl2.xpre.fb vb2 2.14447f
C188 xbias.rdb_m1 xbias.rdt_m3 0.22342f
C189 VDD RX1_N 2.56543f
C190 VDD RX1_P 2.27847f
C191 xl1.xout.n3a xl1.d2a 0.37969f
C192 xl1.xout.i2 RX1_O 0.50509f
C193 xl1.gp RX1_P 0.14621f
C194 vbn VDD 3.76135f
C195 xl2.rla_m1 xl2.d2b 0.00475f
C196 xl2.xout.i1 RX2_O 0
C197 xl0.xpre.fa vbn 2.39287f
C198 xl1.gp VDD 4.53691f
C199 vbn xl1.gp 0.14191f
C200 xl0.d2a xl0.rla_m1 0.00155f
C201 RX2_O EN 0.005f
C202 xl2.gp vbp 0.26446f
C203 xl0.oa vb2 0.57905f
C204 RX2_N xl2.gn 0.14621f
C205 xl1.ob xl1.xhyst.sb 0.28465f
C206 vref xl2.oa 2.14744f
C207 xbias.vf vb2 0.92899f
C208 xl0.d2a xl0.xout.n3a 0.37969f
C209 xl0.xout.n3a EN 0.07539f
C210 xl2.ob VDD 1.9912f
C211 xl1.xout.n3a EN 0.07539f
C212 xl2.ob vbn 0.19136f
C213 xl0.xhyst.sa xl0.d2a 1.70252f
C214 VDD xbias.enb 6.1787f
C215 vbn xbias.enb 0.2848f
C216 xl0.xout.nd xl0.xout.d3 0.22426f
C217 vref xl2.xpre.tn 1.62411f
C218 RX0_O xl0.xout.i1 0
C219 xl1.xhyst.sa xl1.oa 0.20057f
C220 xl2.gp vref 1.91483f
C221 xl2.xpre.tp vbp 3.37779f
C222 xl2.gn vbp 0.26446f
C223 xbias.nrb vb2 0.03936f
C224 vb2 vbp 5.46578f
C225 vbp xl1.xpre.tp 3.37779f
C226 VDD xbias.rdt_m2 0.00209f
C227 VDD xbias.nmid 0.89656f
C228 xl1.xpre.fa vref 2.64932f
C229 vbn xbias.nmid 0.11617f
C230 xl0.d2a xl0.oa 0.23141f
C231 VDD xl1.xhyst.sa 0.00564f
C232 xl1.rla_m1 xl1.xhyst.sa 0.30587f
C233 xl0.xout.d3 xl0.xout.nm 0.01765f
C234 xl0.xpre.tp vb2 0.05309f
C235 xbias.vf EN 0.02265f
C236 RX1_O EN 0.00492f
C237 xl2.xpre.tp vref 14.925f
C238 vref xl2.gn 2.33633f
C239 vref vb2 24.5935f
C240 VDD xl1.xout.d3 4.25479f
C241 xl0.xout.d3 VDD 4.25479f
C242 vref xl1.xpre.tp 14.925f
C243 vbp xl1.gn 0.26446f
C244 vref xbias.rdb_m2 0.09091f
C245 xl0.xout.nd xl0.xout.i1 0.21598f
C246 xl1.xout.nm EN 0.02238f
C247 xbias.enb xbias.nmid 0.71708f
C248 xl2.xout.nd xl2.xout.i1 0.21598f
C249 xl1.ob vref 2.70252f
C250 xl0.ob vb2 0.57476f
C251 xbias.nrb EN 0.24322f
C252 vbp EN 0.30684f
C253 xl1.d2b xl1.xout.n3a 0.50895f
C254 xl2.d2a VDD 13.0234f
C255 xl0.d2a xl0.d2b 2.80463f
C256 xl2.xout.nd EN 0.90578f
C257 xl0.d2b EN 0.43087f
C258 xbias.rdt_m2 xbias.nmid 0.00432f
C259 xl2.xhyst.sa xl2.xhyst.sb 0.77697f
C260 RX1_O xl1.xout.i1 0
C261 vref xl1.gn 2.33633f
C262 VDD xl2.oa 1.59618f
C263 xl0.gn vb2 0.05558f
C264 vbn xl2.oa 0.33374f
C265 xl1.xhyst.sb xl1.d2b 0.85915f
C266 xl1.xout.nm xl1.xout.nd 0.2193f
C267 vbp xbias.rb_m1 0.0038f
C268 RX0_O EN 1.94682f
C269 xl0.xhyst.sa xl0.rla_m1 0.30587f
C270 xl1.xpre.fa xl1.oa 2.90441f
C271 VDD xl2.xpre.tn 0.19528f
C272 vbn xl2.xpre.tn 0.82513f
C273 VDD xl0.xout.i1 2.62227f
C274 xl2.xpre.fb xl2.xpre.fa 0.80129f
C275 xl2.gp VDD 4.53691f
C276 vbn xl2.gp 0.14191f
C277 xl1.xout.i2 VDD 4.2835f
C278 xl2.xout.nd xl2.xout.d3 0.22426f
C279 xl2.ob xl2.oa 0.59251f
C280 xl0.xpre.tn xl0.oa 9.87797f
C281 xl2.xout.nm EN 0.02238f
C282 xl0.gp vb2 0.05601f
C283 vbn xl1.xpre.fa 2.39287f
C284 vb2 xl1.oa 0.57905f
C285 xl1.xpre.fa xl1.gp 2.44274f
C286 xl2.rla_m1 xl2.xhyst.sa 0.30587f
C287 xl1.ob xl1.xpre.tn 9.55392f
C288 xl2.ob xl2.xpre.tn 9.55392f
C289 xl1.d2a xl1.oa 0.23141f
C290 xbias.rb_m2 xbias.vf 0.08519f
C291 VDD xl2.d2b 12.259f
C292 vref xl1.xhyst.ts 0.00271f
C293 RX0_O xl0.xout.i2 0.50501f
C294 xl1.ob xl1.oa 0.59251f
C295 xl2.ob xl2.gp 0.3633f
C296 xl2.xpre.tp VDD 11.3411f
C297 VDD xl2.gn 4.52025f
C298 vbn xl2.gn 0.11482f
C299 VDD vb2 6.61063f
C300 vbn vb2 0.63813f
C301 xl0.xpre.fa vb2 1.75715f
C302 xl1.xpre.tn xl1.gn 0.99696f
C303 VDD xl1.xpre.tp 11.3411f
C304 xl0.xout.nd EN 0.90578f
C305 xl1.gp vb2 0.05601f
C306 xl1.gp xl1.xpre.tp 12.8757f
C307 VDD xbias.rdb_m2 0.00594f
C308 xl2.xout.nm xl2.xout.d3 0.01765f
C309 xl0.xhyst.sa xl0.oa 0.20057f
C310 xl1.xpre.fb vref 2.88984f
C311 VDD xl1.d2a 13.0234f
C312 xl1.gn xl1.oa 0.30476f
C313 xl1.rla_m1 xl1.d2a 0.00155f
C314 xbias.rb_m2 xbias.nrb 0.03837f
C315 xl2.xout.i2 VDD 4.2835f
C316 RX2_P vbp 0.03967f
C317 xl1.ob VDD 1.9912f
C318 xl1.ob vbn 0.19136f
C319 xl1.ob xl1.gp 0.3633f
C320 xl2.ob xl2.d2b 0.20289f
C321 xl2.ob xl2.gn 1.03804f
C322 RX1_N xl1.gn 0.14621f
C323 xl2.ob vb2 0.57476f
C324 xl2.xout.i1 VDD 2.62227f
C325 xl0.xout.nm EN 0.02238f
C326 xl0.rla_m1 xl0.d2b 0.00475f
C327 VDD xl1.gn 4.52025f
C328 vbn xl1.gn 0.11482f
C329 xbias.enb vb2 2.12636f
C330 xl0.xpre.tn vref 1.62411f
C331 xl1.gp xl1.gn 2.07546f
C332 xl0.xpre.tp xl0.xpre.fb 25.7437f
C333 xl0.d2a VDD 13.0234f
C334 VDD EN 65.1213f
C335 vbn EN 0.42114f
C336 vref xl0.xpre.fb 2.88984f
C337 xl0.d2b xl0.xout.n3a 0.50895f
C338 xl2.d2a xl2.oa 0.23141f
C339 xl2.xpre.fa vref 2.64932f
C340 xl0.ob xl0.xpre.tn 9.55392f
C341 xl0.xhyst.sa xl0.d2b 0.20733f
C342 xl2.xout.n3a VDD 5.30403f
C343 vb2 xbias.nmid 0.91956f
C344 xbias.rdt_m2 xbias.rdb_m2 0.37f
C345 xl0.xhyst.ts vref 0.00271f
C346 xbias.rdb_m2 xbias.nmid 0.04228f
C347 RX0_N vbp 0.03712f
C348 xl0.ob xl0.xpre.fb 2.81909f
C349 xl0.xpre.tn xl0.gn 0.99696f
C350 xl2.xpre.fb vref 2.88984f
C351 VDD xl1.xout.nd 2.72518f
C352 xl2.xpre.tn xl2.oa 9.87797f
C353 RX2_N vbp 0.03712f
C354 xl1.d2a xl1.xhyst.sa 1.70252f
C355 xbias.vf vbp 0.3587f
C356 VDD xl2.xout.d3 4.25479f
C357 xbias.nrb xbias.vf 0.76263f
C358 xbias.enb EN 4.04436f
C359 xl2.gp xl2.oa 1.25114f
C360 xl1.ob xl1.xhyst.sa 0.01084f
C361 VDD xl1.xout.i1 2.62227f
C362 xl0.gn xl0.xpre.fb 2.59553f
C363 xl0.ob xl0.xhyst.sa 0.01084f
C364 VDD xl1.xhyst.ts 0.55022f
C365 VDD xl0.xout.i2 4.2835f
C366 vbn xl1.xhyst.ts 0.52623f
C367 xl1.xout.d3 xl1.d2a 2.65586f
C368 xl2.d2a xl2.d2b 2.80463f
C369 xl2.gp xl2.xpre.tn 1.20627f
C370 xl0.oa vref 2.14744f
C371 xbias.nmid EN 0.59891f
C372 xl0.xpre.tn xl0.gp 1.20627f
C373 vbn xl1.xpre.fb 1.48704f
C374 xbias.nrb vbp 0.36246f
C375 xl1.xpre.fb xl1.gp 0.86843f
C376 xbias.enb xbias.rb_m1 0
C377 xl2.gn xl2.oa 0.30476f
C378 xl1.d2b VDD 12.259f
C379 vb2 xl2.oa 0.57905f
C380 RX2_O VSS 18.8961f
C381 RX1_O VSS 11.8271f
C382 RX0_O VSS 11.1616f
C383 EN VSS 37.0197f
C384 RX2_N VSS 3.34389f
C385 RX2_P VSS 3.63059f
C386 RX1_N VSS 3.34389f
C387 RX1_P VSS 3.63059f
C388 RX0_N VSS 3.34389f
C389 RX0_P VSS 3.63059f
C390 VDD VSS 0.74482p
C391 xbias.rb_m3 VSS 1.32997f
C392 xbias.rb_m2 VSS 1.18198f
C393 xbias.rb_m1 VSS 1.29868f
C394 xbias.rf_m1 VSS 1.40226f
C395 xbias.vf VSS 3.02831f
C396 xbias.nrb VSS 1.98311f
C397 xl2.xout.i2 VSS 4.24296f
C398 xl2.xout.i1 VSS 3.72118f
C399 xl2.xout.nm VSS 0.31567f
C400 xl2.xout.nd VSS 3.35102f
C401 xl1.xout.i2 VSS 4.24296f
C402 xl1.xout.i1 VSS 3.72118f
C403 xl1.xout.nm VSS 0.31567f
C404 xl1.xout.nd VSS 3.35102f
C405 xl0.xout.i2 VSS 4.24296f
C406 xl0.xout.i1 VSS 3.72118f
C407 xl0.xout.nm VSS 0.31567f
C408 xl0.xout.nd VSS 3.35102f
C409 xl2.xout.d3 VSS 5.75604f
C410 xl2.xout.n3a VSS 3.16279f
C411 xl1.xout.d3 VSS 5.75604f
C412 xl1.xout.n3a VSS 3.16279f
C413 xl0.xout.d3 VSS 5.75604f
C414 xl0.xout.n3a VSS 3.16279f
C415 xbias.rdb_m1 VSS 1.12023f
C416 xbias.rdt_m3 VSS 1.81265f
C417 xbias.rdb_m2 VSS 1.89154f
C418 xbias.rdb_m3 VSS 1.13703f
C419 xbias.rdt_m1 VSS 1.66241f
C420 xbias.rdt_m2 VSS 1.18196f
C421 xbias.nmid VSS 4.29306f
C422 xl2.xhyst.sb VSS 2.75864f
C423 xl2.d2b VSS 4.72656f
C424 xl2.rlb_m1 VSS 1.11225f
C425 xl2.rla_m1 VSS 1.48073f
C426 xl2.xhyst.sa VSS 4.78816f
C427 xl2.d2a VSS 3.05391f
C428 xl1.xhyst.sb VSS 2.75864f
C429 xl1.d2b VSS 4.72656f
C430 xl1.rlb_m1 VSS 1.11225f
C431 xl1.rla_m1 VSS 1.48073f
C432 xl1.xhyst.sa VSS 4.78816f
C433 xl1.d2a VSS 3.05391f
C434 xl0.xhyst.sb VSS 2.75864f
C435 xl0.d2b VSS 4.72656f
C436 xl0.rlb_m1 VSS 1.11225f
C437 xl0.rla_m1 VSS 1.48073f
C438 xl0.xhyst.sa VSS 4.78816f
C439 xl0.d2a VSS 3.05391f
C440 xl2.xhyst.ts VSS 5.5117f
C441 xl2.xpre.tn VSS 4.38043f
C442 xl1.xhyst.ts VSS 5.5117f
C443 xl1.xpre.tn VSS 4.38043f
C444 xl0.xhyst.ts VSS 5.5117f
C445 xl0.xpre.tn VSS 4.38043f
C446 xbias.enb VSS 8.34564f
C447 xl2.ob VSS 7.30967f
C448 xl2.oa VSS 7.54445f
C449 xl1.ob VSS 7.30967f
C450 xl1.oa VSS 7.54445f
C451 xl0.ob VSS 7.30967f
C452 vbn VSS 0.16633p
C453 xl0.oa VSS 7.54445f
C454 xl2.xpre.fa VSS 9.0556f
C455 xl2.xpre.fb VSS 7.93573f
C456 xl1.xpre.fa VSS 9.0556f
C457 xl1.xpre.fb VSS 7.93573f
C458 xl0.xpre.fa VSS 9.0556f
C459 xl0.xpre.fb VSS 7.93573f
C460 vref VSS 59.87f
C461 vb2 VSS 40.2263f
C462 xl2.gn VSS 13.9171f
C463 xl2.gp VSS 14.0995f
C464 xl1.gn VSS 13.9171f
C465 xl1.gp VSS 14.0995f
C466 xl0.gn VSS 13.9171f
C467 vbp VSS 20.6887f
C468 xl0.gp VSS 14.0995f
C469 xl2.xpre.tp VSS 0.1029p
C470 xl1.xpre.tp VSS 0.1029p
C471 xl0.xpre.tp VSS 0.1029p
.ends lvds_rx_x3
