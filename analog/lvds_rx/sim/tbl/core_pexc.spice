* core_pexc.spice -- GENERATED by sim/tbl/make_cores.py (T11); do not edit.
* = netlist/lvds_rx_core.spice (sha256 12b8123ca20db8679600e10ba1676027d46e39c3c76223967911f9096f415f85) without lvds_rx_x3
*   + results/layout/lvds_rx_x3.pex_c.spice (sha256 7db28907b7cb44b4b7914705ecf2ca3586d9b96c08d923e9bd6a9761b115f2ed) with its nodes renamed to the pre-layout paths.
* lvds_rx_core.spice -- LVDS receiver macro lvds_rx_x3 (3 lanes + shared bias), gf180mcuD 3.3 V devices.
* GENERATED by netlist/gen_core.py from netlist/lvds_circuit.py -- do not edit by hand.
* Every W/L/nf and poly size comes from the parameters of sizing/sizes.spice: the deck must  .include  sizes.spice BEFORE this file
* and the PDK sections (header of sim/harness).  Matched devices are one device with nf fingers (never m).
* Build flags (parameters of sizes.spice, redefine AFTER the include to switch): flag_nmos_pair flag_dump_devices (implemented);
*   flag_extra_gain_stage flag_bias_constgm flag_failsafe flag_on_die_term (NOT implemented in v0: setting one aborts the parse).
* Instance names are hierarchical, e.g. xl0.xpre.xmp1a; the BSIM device inside is  @m.<path>.m0[...] .

.subckt lvds_bias VDD VSS EN VBN VBP VB2 VREF
Xmen_p enb EN VDD VDD pfet_03v3 L={l_men_p} W={w_men_p} nf={nf_men_p} ad='int((nf+1)/2) * W/nf * ldiff' as='int((nf+2)/2) * W/nf * ldiff' pd='2*int((nf+1)/2) * (W/nf + ldiff)' ps='2*int((nf+2)/2) * (W/nf + ldiff)' nrd='0.18u / W' nrs='0.18u / W' sa=0 sb=0 sd=0
Xmen_n enb EN VSS VSS nfet_03v3 L={l_men_n} W={w_men_n} nf={nf_men_n} ad='int((nf+1)/2) * W/nf * ldiff' as='int((nf+2)/2) * W/nf * ldiff' pd='2*int((nf+1)/2) * (W/nf + ldiff)' ps='2*int((nf+2)/2) * (W/nf + ldiff)' nrd='0.18u / W' nrs='0.18u / W' sa=0 sb=0 sd=0
Xmsw nrb enb VDD VDD pfet_03v3 L={l_msw} W={w_msw} nf={nf_msw} ad='int((nf+1)/2) * W/nf * ldiff' as='int((nf+2)/2) * W/nf * ldiff' pd='2*int((nf+1)/2) * (W/nf + ldiff)' ps='2*int((nf+2)/2) * (W/nf + ldiff)' nrd='0.18u / W' nrs='0.18u / W' sa=0 sb=0 sd=0
Xrrb nrb VBN VSS ppolyf_u_1k r_width={rw_rb} r_length={rl_rb}
Xmbn VBN VBN VSS VSS nfet_03v3 L={l_mbn} W={w_mbn} nf={nf_mbn} ad='int((nf+1)/2) * W/nf * ldiff' as='int((nf+2)/2) * W/nf * ldiff' pd='2*int((nf+1)/2) * (W/nf + ldiff)' ps='2*int((nf+2)/2) * (W/nf + ldiff)' nrd='0.18u / W' nrs='0.18u / W' sa=0 sb=0 sd=0
Xmpd_n VBN enb VSS VSS nfet_03v3 L={l_mpd_n} W={w_mpd_n} nf={nf_mpd_n} ad='int((nf+1)/2) * W/nf * ldiff' as='int((nf+2)/2) * W/nf * ldiff' pd='2*int((nf+1)/2) * (W/nf + ldiff)' ps='2*int((nf+2)/2) * (W/nf + ldiff)' nrd='0.18u / W' nrs='0.18u / W' sa=0 sb=0 sd=0
Xmbs VBP VBN VSS VSS nfet_03v3 L={l_mbs} W={w_mbs} nf={nf_mbs} ad='int((nf+1)/2) * W/nf * ldiff' as='int((nf+2)/2) * W/nf * ldiff' pd='2*int((nf+1)/2) * (W/nf + ldiff)' ps='2*int((nf+2)/2) * (W/nf + ldiff)' nrd='0.18u / W' nrs='0.18u / W' sa=0 sb=0 sd=0
Xmbp VBP VBP VDD VDD pfet_03v3 L={l_mbp} W={w_mbp} nf={nf_mbp} ad='int((nf+1)/2) * W/nf * ldiff' as='int((nf+2)/2) * W/nf * ldiff' pd='2*int((nf+1)/2) * (W/nf + ldiff)' ps='2*int((nf+2)/2) * (W/nf + ldiff)' nrd='0.18u / W' nrs='0.18u / W' sa=0 sb=0 sd=0
Xmpu_p VBP EN VDD VDD pfet_03v3 L={l_mpu_p} W={w_mpu_p} nf={nf_mpu_p} ad='int((nf+1)/2) * W/nf * ldiff' as='int((nf+2)/2) * W/nf * ldiff' pd='2*int((nf+1)/2) * (W/nf + ldiff)' ps='2*int((nf+2)/2) * (W/nf + ldiff)' nrd='0.18u / W' nrs='0.18u / W' sa=0 sb=0 sd=0
Xmb2p VB2 VBP VDD VDD pfet_03v3 L={l_mb2p} W={w_mb2p} nf={nf_mb2p} ad='int((nf+1)/2) * W/nf * ldiff' as='int((nf+2)/2) * W/nf * ldiff' pd='2*int((nf+1)/2) * (W/nf + ldiff)' ps='2*int((nf+2)/2) * (W/nf + ldiff)' nrd='0.18u / W' nrs='0.18u / W' sa=0 sb=0 sd=0
Xmb2 VB2 VB2 vf VSS nfet_03v3 L={l_mb2} W={w_mb2} nf={nf_mb2} ad='int((nf+1)/2) * W/nf * ldiff' as='int((nf+2)/2) * W/nf * ldiff' pd='2*int((nf+1)/2) * (W/nf + ldiff)' ps='2*int((nf+2)/2) * (W/nf + ldiff)' nrd='0.18u / W' nrs='0.18u / W' sa=0 sb=0 sd=0
Xrrf vf VSS VSS ppolyf_u_1k r_width={rw_rf} r_length={rl_rf}
Xmpd_2 VB2 enb VSS VSS nfet_03v3 L={l_mpd_2} W={w_mpd_2} nf={nf_mpd_2} ad='int((nf+1)/2) * W/nf * ldiff' as='int((nf+2)/2) * W/nf * ldiff' pd='2*int((nf+1)/2) * (W/nf + ldiff)' ps='2*int((nf+2)/2) * (W/nf + ldiff)' nrd='0.18u / W' nrs='0.18u / W' sa=0 sb=0 sd=0
Xrrdt VDD VREF VSS ppolyf_u_1k r_width={rw_rdt} r_length={rl_rdt}
Xrrdb VREF nmid VSS ppolyf_u_1k r_width={rw_rdb} r_length={rl_rdb}
Xmvs nmid EN VSS VSS nfet_03v3 L={l_mvs} W={w_mvs} nf={nf_mvs} ad='int((nf+1)/2) * W/nf * ldiff' as='int((nf+2)/2) * W/nf * ldiff' pd='2*int((nf+1)/2) * (W/nf + ldiff)' ps='2*int((nf+2)/2) * (W/nf + ldiff)' nrd='0.18u / W' nrs='0.18u / W' sa=0 sb=0 sd=0
Xcvref VREF VSS cap_nmos_03v3 c_length={cap_vref_l} c_width={cap_vref_w}
* layout parasitic estimate (T11): wiring C per net, values from sizes.spice (cw_<stem>)
Ccw_bias_enb enb VSS {cw_bias_enb}
Ccwd_bias_enb enb VDD {cwd_bias_enb}
Ccw_bias_nrb nrb VSS {cw_bias_nrb}
Ccwd_bias_nrb nrb VDD {cwd_bias_nrb}
Ccw_bias_vf vf VSS {cw_bias_vf}
Ccwd_bias_vf vf VDD {cwd_bias_vf}
Ccw_bias_nmid nmid VSS {cw_bias_nmid}
Ccwd_bias_nmid nmid VDD {cwd_bias_nmid}
.ends lvds_bias

.subckt lvds_esd2 A B VDD VSS
Xresd A B VDD ppolyf_u r_width={rw_esd} r_length={rl_esd}
Ddesd_h B VDD diode_pd2nw_03v3 area={dw_esd*dl_esd} pj={2*(dw_esd+dl_esd)}
Ddesd_l VSS B diode_nd2ps_03v3 area={dw_esd*dl_esd} pj={2*(dw_esd+dl_esd)}
.ends lvds_esd2

.subckt lvds_pre VDD VSS INP INN VBN VBP VB2 VREF OA OB
Xrla VDD OA VSS ppolyf_u_1k r_width={rw_rl} r_length={rl_rl}
Xrlb VDD OB VSS ppolyf_u_1k r_width={rw_rl} r_length={rl_rl}
Xmpt tp VBP VDD VDD pfet_03v3 L={l_mpt} W={w_mpt} nf={nf_mpt} ad='int((nf+1)/2) * W/nf * ldiff' as='int((nf+2)/2) * W/nf * ldiff' pd='2*int((nf+1)/2) * (W/nf + ldiff)' ps='2*int((nf+2)/2) * (W/nf + ldiff)' nrd='0.18u / W' nrs='0.18u / W' sa=0 sb=0 sd=0
Xmp1a fa INP tp tp pfet_03v3 L={l_mp1} W={w_mp1} nf={nf_mp1} ad='int((nf+1)/2) * W/nf * ldiff' as='int((nf+2)/2) * W/nf * ldiff' pd='2*int((nf+1)/2) * (W/nf + ldiff)' ps='2*int((nf+2)/2) * (W/nf + ldiff)' nrd='0.18u / W' nrs='0.18u / W' sa=0 sb=0 sd=0
Xmp1b fb INN tp tp pfet_03v3 L={l_mp1} W={w_mp1} nf={nf_mp1} ad='int((nf+1)/2) * W/nf * ldiff' as='int((nf+2)/2) * W/nf * ldiff' pd='2*int((nf+1)/2) * (W/nf + ldiff)' ps='2*int((nf+2)/2) * (W/nf + ldiff)' nrd='0.18u / W' nrs='0.18u / W' sa=0 sb=0 sd=0
.if ((flag_dump_devices == 1))
Xmpda fa VREF tp tp pfet_03v3 L={l_mpd} W={w_mpd} nf={nf_mpd} ad='int((nf+1)/2) * W/nf * ldiff' as='int((nf+2)/2) * W/nf * ldiff' pd='2*int((nf+1)/2) * (W/nf + ldiff)' ps='2*int((nf+2)/2) * (W/nf + ldiff)' nrd='0.18u / W' nrs='0.18u / W' sa=0 sb=0 sd=0
Xmpdb fb VREF tp tp pfet_03v3 L={l_mpd} W={w_mpd} nf={nf_mpd} ad='int((nf+1)/2) * W/nf * ldiff' as='int((nf+2)/2) * W/nf * ldiff' pd='2*int((nf+1)/2) * (W/nf + ldiff)' ps='2*int((nf+2)/2) * (W/nf + ldiff)' nrd='0.18u / W' nrs='0.18u / W' sa=0 sb=0 sd=0
.endif
.if ((flag_nmos_pair == 1))
Xm3a fa VBN VSS VSS nfet_03v3 L={l_m3} W={w_m3} nf={nf_m3} ad='int((nf+1)/2) * W/nf * ldiff' as='int((nf+2)/2) * W/nf * ldiff' pd='2*int((nf+1)/2) * (W/nf + ldiff)' ps='2*int((nf+2)/2) * (W/nf + ldiff)' nrd='0.18u / W' nrs='0.18u / W' sa=0 sb=0 sd=0
Xm3b fb VBN VSS VSS nfet_03v3 L={l_m3} W={w_m3} nf={nf_m3} ad='int((nf+1)/2) * W/nf * ldiff' as='int((nf+2)/2) * W/nf * ldiff' pd='2*int((nf+1)/2) * (W/nf + ldiff)' ps='2*int((nf+2)/2) * (W/nf + ldiff)' nrd='0.18u / W' nrs='0.18u / W' sa=0 sb=0 sd=0
.endif
.if ((flag_nmos_pair != 1))
Xm3a fa VBN VSS VSS nfet_03v3 L={l_m3a} W={w_m3a} nf={nf_m3a} ad='int((nf+1)/2) * W/nf * ldiff' as='int((nf+2)/2) * W/nf * ldiff' pd='2*int((nf+1)/2) * (W/nf + ldiff)' ps='2*int((nf+2)/2) * (W/nf + ldiff)' nrd='0.18u / W' nrs='0.18u / W' sa=0 sb=0 sd=0
Xm3b fb VBN VSS VSS nfet_03v3 L={l_m3a} W={w_m3a} nf={nf_m3a} ad='int((nf+1)/2) * W/nf * ldiff' as='int((nf+2)/2) * W/nf * ldiff' pd='2*int((nf+1)/2) * (W/nf + ldiff)' ps='2*int((nf+2)/2) * (W/nf + ldiff)' nrd='0.18u / W' nrs='0.18u / W' sa=0 sb=0 sd=0
.endif
Xm5a OA VB2 fa VSS nfet_03v3 L={l_m5} W={w_m5} nf={nf_m5} ad='int((nf+1)/2) * W/nf * ldiff' as='int((nf+2)/2) * W/nf * ldiff' pd='2*int((nf+1)/2) * (W/nf + ldiff)' ps='2*int((nf+2)/2) * (W/nf + ldiff)' nrd='0.18u / W' nrs='0.18u / W' sa=0 sb=0 sd=0
Xm5b OB VB2 fb VSS nfet_03v3 L={l_m5} W={w_m5} nf={nf_m5} ad='int((nf+1)/2) * W/nf * ldiff' as='int((nf+2)/2) * W/nf * ldiff' pd='2*int((nf+1)/2) * (W/nf + ldiff)' ps='2*int((nf+2)/2) * (W/nf + ldiff)' nrd='0.18u / W' nrs='0.18u / W' sa=0 sb=0 sd=0
.if ((flag_nmos_pair == 1))
Xmnt tn VBN VSS VSS nfet_03v3 L={l_mnt} W={w_mnt} nf={nf_mnt} ad='int((nf+1)/2) * W/nf * ldiff' as='int((nf+2)/2) * W/nf * ldiff' pd='2*int((nf+1)/2) * (W/nf + ldiff)' ps='2*int((nf+2)/2) * (W/nf + ldiff)' nrd='0.18u / W' nrs='0.18u / W' sa=0 sb=0 sd=0
Xmn1a OA INP tn VSS nfet_03v3 L={l_mn1} W={w_mn1} nf={nf_mn1} ad='int((nf+1)/2) * W/nf * ldiff' as='int((nf+2)/2) * W/nf * ldiff' pd='2*int((nf+1)/2) * (W/nf + ldiff)' ps='2*int((nf+2)/2) * (W/nf + ldiff)' nrd='0.18u / W' nrs='0.18u / W' sa=0 sb=0 sd=0
Xmn1b OB INN tn VSS nfet_03v3 L={l_mn1} W={w_mn1} nf={nf_mn1} ad='int((nf+1)/2) * W/nf * ldiff' as='int((nf+2)/2) * W/nf * ldiff' pd='2*int((nf+1)/2) * (W/nf + ldiff)' ps='2*int((nf+2)/2) * (W/nf + ldiff)' nrd='0.18u / W' nrs='0.18u / W' sa=0 sb=0 sd=0
.endif
.if ((flag_nmos_pair == 1) && (flag_dump_devices == 1))
Xmnda OA VREF tn VSS nfet_03v3 L={l_mnd} W={w_mnd} nf={nf_mnd} ad='int((nf+1)/2) * W/nf * ldiff' as='int((nf+2)/2) * W/nf * ldiff' pd='2*int((nf+1)/2) * (W/nf + ldiff)' ps='2*int((nf+2)/2) * (W/nf + ldiff)' nrd='0.18u / W' nrs='0.18u / W' sa=0 sb=0 sd=0
Xmndb OB VREF tn VSS nfet_03v3 L={l_mnd} W={w_mnd} nf={nf_mnd} ad='int((nf+1)/2) * W/nf * ldiff' as='int((nf+2)/2) * W/nf * ldiff' pd='2*int((nf+1)/2) * (W/nf + ldiff)' ps='2*int((nf+2)/2) * (W/nf + ldiff)' nrd='0.18u / W' nrs='0.18u / W' sa=0 sb=0 sd=0
.endif
* layout parasitic estimate (T11): wiring C per net, values from sizes.spice (cw_<stem>)
Ccw_pre_fa fa VSS {cw_pre_fa}
Ccwd_pre_fa fa VDD {cwd_pre_fa}
Ccw_pre_fb fb VSS {cw_pre_fb}
Ccwd_pre_fb fb VDD {cwd_pre_fb}
Ccw_pre_tp tp VSS {cw_pre_tp}
Ccwd_pre_tp tp VDD {cwd_pre_tp}
Ccw_pre_tn tn VSS {cw_pre_tn}
Ccwd_pre_tn tn VDD {cwd_pre_tn}
.ends lvds_pre

.subckt lvds_hyst VDD VSS OA OB VBN EN D2A D2B
Xmt2 ts VBN VSS VSS nfet_03v3 L={l_mt2} W={w_mt2} nf={nf_mt2} ad='int((nf+1)/2) * W/nf * ldiff' as='int((nf+2)/2) * W/nf * ldiff' pd='2*int((nf+1)/2) * (W/nf + ldiff)' ps='2*int((nf+2)/2) * (W/nf + ldiff)' nrd='0.18u / W' nrs='0.18u / W' sa=0 sb=0 sd=0
Xms1 D2A OA sa VSS nfet_03v3 L={l_ms} W={w_ms} nf={nf_ms} ad='int((nf+1)/2) * W/nf * ldiff' as='int((nf+2)/2) * W/nf * ldiff' pd='2*int((nf+1)/2) * (W/nf + ldiff)' ps='2*int((nf+2)/2) * (W/nf + ldiff)' nrd='0.18u / W' nrs='0.18u / W' sa=0 sb=0 sd=0
Xms2 D2B OB sb VSS nfet_03v3 L={l_ms} W={w_ms} nf={nf_ms} ad='int((nf+1)/2) * W/nf * ldiff' as='int((nf+2)/2) * W/nf * ldiff' pd='2*int((nf+1)/2) * (W/nf + ldiff)' ps='2*int((nf+2)/2) * (W/nf + ldiff)' nrd='0.18u / W' nrs='0.18u / W' sa=0 sb=0 sd=0
Xrs1 sa ts VSS ppolyf_u_1k r_width={rw_rs} r_length={rl_rs}
Xrs2 sb ts VSS ppolyf_u_1k r_width={rw_rs} r_length={rl_rs}
Xmld1 D2A D2A VDD VDD pfet_03v3 L={l_mld} W={w_mld} nf={nf_mld} ad='int((nf+1)/2) * W/nf * ldiff' as='int((nf+2)/2) * W/nf * ldiff' pd='2*int((nf+1)/2) * (W/nf + ldiff)' ps='2*int((nf+2)/2) * (W/nf + ldiff)' nrd='0.18u / W' nrs='0.18u / W' sa=0 sb=0 sd=0
Xmld2 D2B D2B VDD VDD pfet_03v3 L={l_mld} W={w_mld} nf={nf_mld} ad='int((nf+1)/2) * W/nf * ldiff' as='int((nf+2)/2) * W/nf * ldiff' pd='2*int((nf+1)/2) * (W/nf + ldiff)' ps='2*int((nf+2)/2) * (W/nf + ldiff)' nrd='0.18u / W' nrs='0.18u / W' sa=0 sb=0 sd=0
Xmlc1 D2A D2B VDD VDD pfet_03v3 L={l_mlc} W={w_mlc} nf={nf_mlc} ad='int((nf+1)/2) * W/nf * ldiff' as='int((nf+2)/2) * W/nf * ldiff' pd='2*int((nf+1)/2) * (W/nf + ldiff)' ps='2*int((nf+2)/2) * (W/nf + ldiff)' nrd='0.18u / W' nrs='0.18u / W' sa=0 sb=0 sd=0
Xmlc2 D2B D2A VDD VDD pfet_03v3 L={l_mlc} W={w_mlc} nf={nf_mlc} ad='int((nf+1)/2) * W/nf * ldiff' as='int((nf+2)/2) * W/nf * ldiff' pd='2*int((nf+1)/2) * (W/nf + ldiff)' ps='2*int((nf+2)/2) * (W/nf + ldiff)' nrd='0.18u / W' nrs='0.18u / W' sa=0 sb=0 sd=0
Xmpu1 D2A EN VDD VDD pfet_03v3 L={l_mpu2} W={w_mpu2} nf={nf_mpu2} ad='int((nf+1)/2) * W/nf * ldiff' as='int((nf+2)/2) * W/nf * ldiff' pd='2*int((nf+1)/2) * (W/nf + ldiff)' ps='2*int((nf+2)/2) * (W/nf + ldiff)' nrd='0.18u / W' nrs='0.18u / W' sa=0 sb=0 sd=0
Xmpu2 D2B EN VDD VDD pfet_03v3 L={l_mpu2} W={w_mpu2} nf={nf_mpu2} ad='int((nf+1)/2) * W/nf * ldiff' as='int((nf+2)/2) * W/nf * ldiff' pd='2*int((nf+1)/2) * (W/nf + ldiff)' ps='2*int((nf+2)/2) * (W/nf + ldiff)' nrd='0.18u / W' nrs='0.18u / W' sa=0 sb=0 sd=0
* layout parasitic estimate (T11): wiring C per net, values from sizes.spice (cw_<stem>)
Ccw_hyst_sa sa VSS {cw_hyst_sa}
Ccwd_hyst_sa sa VDD {cwd_hyst_sa}
Ccw_hyst_sb sb VSS {cw_hyst_sb}
Ccwd_hyst_sb sb VDD {cwd_hyst_sb}
Ccw_hyst_ts ts VSS {cw_hyst_ts}
Ccwd_hyst_ts ts VDD {cwd_hyst_ts}
.ends lvds_hyst

.subckt lvds_out VDD VSS D2A D2B EN OUT
Xmp3a n3a D2A VDD VDD pfet_03v3 L={l_mp3} W={w_mp3} nf={nf_mp3} ad='int((nf+1)/2) * W/nf * ldiff' as='int((nf+2)/2) * W/nf * ldiff' pd='2*int((nf+1)/2) * (W/nf + ldiff)' ps='2*int((nf+2)/2) * (W/nf + ldiff)' nrd='0.18u / W' nrs='0.18u / W' sa=0 sb=0 sd=0
Xmp3b d3 D2B VDD VDD pfet_03v3 L={l_mp3} W={w_mp3} nf={nf_mp3} ad='int((nf+1)/2) * W/nf * ldiff' as='int((nf+2)/2) * W/nf * ldiff' pd='2*int((nf+1)/2) * (W/nf + ldiff)' ps='2*int((nf+2)/2) * (W/nf + ldiff)' nrd='0.18u / W' nrs='0.18u / W' sa=0 sb=0 sd=0
Xmn3a n3a n3a VSS VSS nfet_03v3 L={l_mn3} W={w_mn3} nf={nf_mn3} ad='int((nf+1)/2) * W/nf * ldiff' as='int((nf+2)/2) * W/nf * ldiff' pd='2*int((nf+1)/2) * (W/nf + ldiff)' ps='2*int((nf+2)/2) * (W/nf + ldiff)' nrd='0.18u / W' nrs='0.18u / W' sa=0 sb=0 sd=0
Xmn3b d3 n3a VSS VSS nfet_03v3 L={l_mn3} W={w_mn3} nf={nf_mn3} ad='int((nf+1)/2) * W/nf * ldiff' as='int((nf+2)/2) * W/nf * ldiff' pd='2*int((nf+1)/2) * (W/nf + ldiff)' ps='2*int((nf+2)/2) * (W/nf + ldiff)' nrd='0.18u / W' nrs='0.18u / W' sa=0 sb=0 sd=0
Xmnandp1 nd d3 VDD VDD pfet_03v3 L={l_nand_p} W={w_nand_p} nf={nf_nand_p} ad='int((nf+1)/2) * W/nf * ldiff' as='int((nf+2)/2) * W/nf * ldiff' pd='2*int((nf+1)/2) * (W/nf + ldiff)' ps='2*int((nf+2)/2) * (W/nf + ldiff)' nrd='0.18u / W' nrs='0.18u / W' sa=0 sb=0 sd=0
Xmnandp2 nd EN VDD VDD pfet_03v3 L={l_nand_p} W={w_nand_p} nf={nf_nand_p} ad='int((nf+1)/2) * W/nf * ldiff' as='int((nf+2)/2) * W/nf * ldiff' pd='2*int((nf+1)/2) * (W/nf + ldiff)' ps='2*int((nf+2)/2) * (W/nf + ldiff)' nrd='0.18u / W' nrs='0.18u / W' sa=0 sb=0 sd=0
Xmnandn1 nd d3 nm VSS nfet_03v3 L={l_nand_n} W={w_nand_n} nf={nf_nand_n} ad='int((nf+1)/2) * W/nf * ldiff' as='int((nf+2)/2) * W/nf * ldiff' pd='2*int((nf+1)/2) * (W/nf + ldiff)' ps='2*int((nf+2)/2) * (W/nf + ldiff)' nrd='0.18u / W' nrs='0.18u / W' sa=0 sb=0 sd=0
Xmnandn2 nm EN VSS VSS nfet_03v3 L={l_nand_n} W={w_nand_n} nf={nf_nand_n} ad='int((nf+1)/2) * W/nf * ldiff' as='int((nf+2)/2) * W/nf * ldiff' pd='2*int((nf+1)/2) * (W/nf + ldiff)' ps='2*int((nf+2)/2) * (W/nf + ldiff)' nrd='0.18u / W' nrs='0.18u / W' sa=0 sb=0 sd=0
Xminv1p i1 nd VDD VDD pfet_03v3 L={l_inv1_p} W={w_inv1_p} nf={nf_inv1_p} ad='int((nf+1)/2) * W/nf * ldiff' as='int((nf+2)/2) * W/nf * ldiff' pd='2*int((nf+1)/2) * (W/nf + ldiff)' ps='2*int((nf+2)/2) * (W/nf + ldiff)' nrd='0.18u / W' nrs='0.18u / W' sa=0 sb=0 sd=0
Xminv1n i1 nd VSS VSS nfet_03v3 L={l_inv1_n} W={w_inv1_n} nf={nf_inv1_n} ad='int((nf+1)/2) * W/nf * ldiff' as='int((nf+2)/2) * W/nf * ldiff' pd='2*int((nf+1)/2) * (W/nf + ldiff)' ps='2*int((nf+2)/2) * (W/nf + ldiff)' nrd='0.18u / W' nrs='0.18u / W' sa=0 sb=0 sd=0
Xminv2p i2 i1 VDD VDD pfet_03v3 L={l_inv2_p} W={w_inv2_p} nf={nf_inv2_p} ad='int((nf+1)/2) * W/nf * ldiff' as='int((nf+2)/2) * W/nf * ldiff' pd='2*int((nf+1)/2) * (W/nf + ldiff)' ps='2*int((nf+2)/2) * (W/nf + ldiff)' nrd='0.18u / W' nrs='0.18u / W' sa=0 sb=0 sd=0
Xminv2n i2 i1 VSS VSS nfet_03v3 L={l_inv2_n} W={w_inv2_n} nf={nf_inv2_n} ad='int((nf+1)/2) * W/nf * ldiff' as='int((nf+2)/2) * W/nf * ldiff' pd='2*int((nf+1)/2) * (W/nf + ldiff)' ps='2*int((nf+2)/2) * (W/nf + ldiff)' nrd='0.18u / W' nrs='0.18u / W' sa=0 sb=0 sd=0
Xminv3p OUT i2 VDD VDD pfet_03v3 L={l_inv3_p} W={w_inv3_p} nf={nf_inv3_p} ad='int((nf+1)/2) * W/nf * ldiff' as='int((nf+2)/2) * W/nf * ldiff' pd='2*int((nf+1)/2) * (W/nf + ldiff)' ps='2*int((nf+2)/2) * (W/nf + ldiff)' nrd='0.18u / W' nrs='0.18u / W' sa=0 sb=0 sd=0
Xminv3n OUT i2 VSS VSS nfet_03v3 L={l_inv3_n} W={w_inv3_n} nf={nf_inv3_n} ad='int((nf+1)/2) * W/nf * ldiff' as='int((nf+2)/2) * W/nf * ldiff' pd='2*int((nf+1)/2) * (W/nf + ldiff)' ps='2*int((nf+2)/2) * (W/nf + ldiff)' nrd='0.18u / W' nrs='0.18u / W' sa=0 sb=0 sd=0
* layout parasitic estimate (T11): wiring C per net, values from sizes.spice (cw_<stem>)
Ccw_out_n3a n3a VSS {cw_out_n3a}
Ccwd_out_n3a n3a VDD {cwd_out_n3a}
Ccw_out_d3 d3 VSS {cw_out_d3}
Ccwd_out_d3 d3 VDD {cwd_out_d3}
Ccw_out_nd nd VSS {cw_out_nd}
Ccwd_out_nd nd VDD {cwd_out_nd}
Ccw_out_nm nm VSS {cw_out_nm}
Ccwd_out_nm nm VDD {cwd_out_nm}
Ccw_out_i1 i1 VSS {cw_out_i1}
Ccwd_out_i1 i1 VDD {cwd_out_i1}
Ccw_out_i2 i2 VSS {cw_out_i2}
Ccwd_out_i2 i2 VDD {cwd_out_i2}
.ends lvds_out

.subckt lvds_lane VDD VSS INP INN EN VBN VBP VB2 VREF OUT
xesdp INP gp VDD VSS lvds_esd2
xesdn INN gn VDD VSS lvds_esd2
xpre VDD VSS gp gn VBN VBP VB2 VREF oa ob lvds_pre
xhyst VDD VSS oa ob VBN EN d2a d2b lvds_hyst
xout VDD VSS d2a d2b EN OUT lvds_out
* layout parasitic estimate (T11): wiring C per net, values from sizes.spice (cw_<stem>)
Ccw_lane_inp INP VSS {cw_lane_inp}
Ccwd_lane_inp INP VDD {cwd_lane_inp}
Ccw_lane_inn INN VSS {cw_lane_inn}
Ccwd_lane_inn INN VDD {cwd_lane_inn}
Ccw_lane_gp gp VSS {cw_lane_gp}
Ccwd_lane_gp gp VDD {cwd_lane_gp}
Ccw_lane_gn gn VSS {cw_lane_gn}
Ccwd_lane_gn gn VDD {cwd_lane_gn}
Ccw_lane_oa oa VSS {cw_lane_oa}
Ccwd_lane_oa oa VDD {cwd_lane_oa}
Ccw_lane_ob ob VSS {cw_lane_ob}
Ccwd_lane_ob ob VDD {cwd_lane_ob}
Ccw_lane_d2a d2a VSS {cw_lane_d2a}
Ccwd_lane_d2a d2a VDD {cwd_lane_d2a}
Ccw_lane_d2b d2b VSS {cw_lane_d2b}
Ccwd_lane_d2b d2b VDD {cwd_lane_d2b}
Ccw_lane_out OUT VSS {cw_lane_out}
Ccwd_lane_out OUT VDD {cwd_lane_out}
.ends lvds_lane

* (subckt lvds_rx_x3 removed: the extracted one follows)

.subckt lvds_rx_x3 VDD VSS RX0_P RX0_N RX1_P RX1_N RX2_P RX2_N EN RX0_O RX1_O RX2_O
X0 xl1.xpre.tp xl1.gp xl1.xpre.fa xl1.xpre.tp pfet_03v3 ad=1.248p pd=5.32u as=1.248p ps=5.32u w=4.8u l=0.4u
X1 VSS VSS xl2.d2b VSS nfet_03v3 ad=1.9228p pd=9.62u as=1.1362p ps=4.89u w=4.37u l=0.5u
X2 VSS VSS RX1_O VSS nfet_03v3 ad=1.76p pd=8.88u as=1.04p ps=4.52u w=4u l=0.28u
X3 xl2.xpre.fb xl2.gn xl2.xpre.tp xl2.xpre.tp pfet_03v3 ad=1.248p pd=5.32u as=1.248p ps=5.32u w=4.8u l=0.4u
X4 VSS vbn xl1.xpre.fb VSS nfet_03v3 ad=0.65p pd=3.02u as=0.65p ps=3.02u w=2.5u l=1u
X5 xl1.ob vb2 xl1.xpre.fb VSS nfet_03v3 ad=1.1752p pd=5.04u as=1.1752p ps=5.04u w=4.52u l=0.5u
X6 xl0.xpre.tn vbn VSS VSS nfet_03v3 ad=0.65p pd=3.02u as=0.65p ps=3.02u w=2.5u l=1u
X7 xbias.rb_m3 vbn VSS ppolyf_u_1k r_width=2u r_length=22.27u
X8 VSS vbn xl2.xhyst.ts VSS nfet_03v3 ad=0.65p pd=3.02u as=0.65p ps=3.02u w=2.5u l=1u
X9 xl0.xpre.tp xl0.gp xl0.xpre.fa xl0.xpre.tp pfet_03v3 ad=1.248p pd=5.32u as=1.248p ps=5.32u w=4.8u l=0.4u
X10 xl0.d2a xl0.d2a VDD VDD pfet_03v3 ad=0.481p pd=2.37u as=0.481p ps=2.37u w=1.85u l=0.28u
X11 xl0.xpre.tn xl0.gn xl0.ob VSS nfet_03v3 ad=1.235p pd=5.27u as=1.235p ps=5.27u w=4.75u l=0.5u
X12 xl0.xpre.fa xl0.gp xl0.xpre.tp xl0.xpre.tp pfet_03v3 ad=1.248p pd=5.32u as=1.248p ps=5.32u w=4.8u l=0.4u
X13 xl1.xpre.fa vref xl1.xpre.tp xl1.xpre.tp pfet_03v3 ad=1.248p pd=5.32u as=1.248p ps=5.32u w=4.8u l=0.4u
X14 xbias.rdt_m2 xbias.rdt_m3 VSS ppolyf_u_1k r_width=2u r_length=21.01u
X15 xl0.xpre.tn vref xl0.oa VSS nfet_03v3 ad=1.235p pd=5.27u as=1.235p ps=5.27u w=4.75u l=0.5u
X16 VDD xl0.d2a xl0.xout.n3a VDD pfet_03v3 ad=0.481p pd=2.37u as=0.481p ps=2.37u w=1.85u l=0.28u
X17 VSS VSS VSS ppolyf_u_1k r_width=2u r_length=9.11u
X18 VSS vbn xl2.xhyst.ts VSS nfet_03v3 ad=0.65p pd=3.02u as=0.65p ps=3.02u w=2.5u l=1u
X19 xl0.xpre.tp vref xl0.xpre.fb xl0.xpre.tp pfet_03v3 ad=1.248p pd=5.32u as=1.248p ps=5.32u w=4.8u l=0.4u
X20 xl2.xpre.fb vref xl2.xpre.tp xl2.xpre.tp pfet_03v3 ad=1.248p pd=5.32u as=1.248p ps=5.32u w=4.8u l=0.4u
X21 xl0.d2b xl0.d2a VDD VDD pfet_03v3 ad=0.481p pd=2.37u as=0.481p ps=2.37u w=1.85u l=0.28u
X22 xl2.xpre.tn xl2.gn xl2.ob VSS nfet_03v3 ad=1.235p pd=5.27u as=1.235p ps=5.27u w=4.75u l=0.5u
X23 xl1.xpre.fa vref xl1.xpre.tp xl1.xpre.tp pfet_03v3 ad=1.248p pd=5.32u as=1.248p ps=5.32u w=4.8u l=0.4u
X24 xl1.xpre.tn vbn VSS VSS nfet_03v3 ad=0.65p pd=3.02u as=0.65p ps=3.02u w=2.5u l=1u
X25 VDD VDD xl1.xout.n3a VDD pfet_03v3 ad=0.814p pd=4.58u as=0.481p ps=2.37u w=1.85u l=0.28u
X26 xl2.xpre.fa vref xl2.xpre.tp xl2.xpre.tp pfet_03v3 ad=1.248p pd=5.32u as=1.248p ps=5.32u w=4.8u l=0.4u
X27 VSS vbn xl0.xhyst.ts VSS nfet_03v3 ad=0.65p pd=3.02u as=0.65p ps=3.02u w=2.5u l=1u
X28 VSS VSS xl1.xout.d3 VSS nfet_03v3 ad=2.0504p pd=10.2u as=1.2116p ps=5.18u w=4.66u l=0.28u
X29 xl2.xpre.tn xl2.gp xl2.oa VSS nfet_03v3 ad=1.235p pd=5.27u as=1.235p ps=5.27u w=4.75u l=0.5u
X30 xl0.xpre.fa xl0.gp xl0.xpre.tp xl0.xpre.tp pfet_03v3 ad=1.248p pd=5.32u as=1.248p ps=5.32u w=4.8u l=0.4u
X31 xl2.xpre.tp vref xl2.xpre.fa xl2.xpre.tp pfet_03v3 ad=1.248p pd=5.32u as=1.248p ps=5.32u w=4.8u l=0.4u
X32 VSS vbn xl1.xhyst.ts VSS nfet_03v3 ad=0.65p pd=3.02u as=0.65p ps=3.02u w=2.5u l=1u
X33 VDD xl1.d2b xl1.d2b VDD pfet_03v3 ad=0.481p pd=2.37u as=0.481p ps=2.37u w=1.85u l=0.28u
X34 xl0.xpre.fb vref xl0.xpre.tp xl0.xpre.tp pfet_03v3 ad=1.248p pd=5.32u as=1.248p ps=5.32u w=4.8u l=0.4u
X35 xl0.ob xl0.gn xl0.xpre.tn VSS nfet_03v3 ad=1.235p pd=5.27u as=1.235p ps=5.27u w=4.75u l=0.5u
D0 xl2.gn VDD diode_pd2nw_03v3 pj=26u area=40p
X36 xl1.xpre.tp xl1.gn xl1.xpre.fb xl1.xpre.tp pfet_03v3 ad=1.248p pd=5.32u as=1.248p ps=5.32u w=4.8u l=0.4u
X37 xl1.xpre.fa vref xl1.xpre.tp xl1.xpre.tp pfet_03v3 ad=1.248p pd=5.32u as=1.248p ps=5.32u w=4.8u l=0.4u
X38 xl0.d2a xl0.oa xl0.xhyst.sa VSS nfet_03v3 ad=1.1362p pd=4.89u as=1.1362p ps=4.89u w=4.37u l=0.5u
X39 xl0.xpre.tp xl0.gp xl0.xpre.fa xl0.xpre.tp pfet_03v3 ad=1.248p pd=5.32u as=1.248p ps=5.32u w=4.8u l=0.4u
X40 xl2.xpre.fa xl2.gp xl2.xpre.tp xl2.xpre.tp pfet_03v3 ad=1.248p pd=5.32u as=1.248p ps=5.32u w=4.8u l=0.4u
X41 xl0.xout.nm xl0.xout.d3 xl0.xout.nd VSS nfet_03v3 ad=0.52p pd=2.52u as=0.52p ps=2.52u w=2u l=0.28u
X42 xl1.xpre.tp vref xl1.xpre.fb xl1.xpre.tp pfet_03v3 ad=1.248p pd=5.32u as=1.248p ps=5.32u w=4.8u l=0.4u
X43 VSS vbn xl0.xpre.tn VSS nfet_03v3 ad=0.65p pd=3.02u as=0.65p ps=3.02u w=2.5u l=1u
X44 xl0.ob xl0.gn xl0.xpre.tn VSS nfet_03v3 ad=1.235p pd=5.27u as=1.235p ps=5.27u w=4.75u l=0.5u
X45 RX0_O xl0.xout.i2 VSS VSS nfet_03v3 ad=1.04p pd=4.52u as=1.04p ps=4.52u w=4u l=0.28u
X46 VDD vbp xl0.xpre.tp VDD pfet_03v3 ad=1.3p pd=5.52u as=1.3p ps=5.52u w=5u l=1u
X47 xl2.xpre.tp xl2.gn xl2.xpre.fb xl2.xpre.tp pfet_03v3 ad=1.248p pd=5.32u as=1.248p ps=5.32u w=4.8u l=0.4u
X48 VSS vbn xl1.xpre.fa VSS nfet_03v3 ad=0.65p pd=3.02u as=0.65p ps=3.02u w=2.5u l=1u
X49 VSS vbn vbp VSS nfet_03v3 ad=0.65p pd=3.02u as=0.65p ps=3.02u w=2.5u l=1u
X50 VDD VDD VDD VDD pfet_03v3 ad=0.52p pd=2.52u as=0.29939n ps=1.39696m w=2u l=0.5u
X51 xl2.xhyst.sa xl2.oa xl2.d2a VSS nfet_03v3 ad=1.1362p pd=4.89u as=1.1362p ps=4.89u w=4.37u l=0.5u
X52 VSS VSS VSS ppolyf_u_1k r_width=2u r_length=9.11u
X53 xl2.xout.n3a xl2.d2a VDD VDD pfet_03v3 ad=0.481p pd=2.37u as=0.481p ps=2.37u w=1.85u l=0.28u
X54 VDD xl1.d2b xl1.d2a VDD pfet_03v3 ad=0.481p pd=2.37u as=0.481p ps=2.37u w=1.85u l=0.28u
X55 xl0.xout.n3a xl0.d2a VDD VDD pfet_03v3 ad=0.481p pd=2.37u as=0.481p ps=2.37u w=1.85u l=0.28u
X56 xl0.xpre.fa vbn VSS VSS nfet_03v3 ad=0.65p pd=3.02u as=0.65p ps=3.02u w=2.5u l=1u
X57 xl1.oa vref xl1.xpre.tn VSS nfet_03v3 ad=1.235p pd=5.27u as=1.235p ps=5.27u w=4.75u l=0.5u
X58 xl0.oa xl0.gp xl0.xpre.tn VSS nfet_03v3 ad=1.235p pd=5.27u as=1.235p ps=5.27u w=4.75u l=0.5u
X59 xl2.xout.d3 xl2.xout.n3a VSS VSS nfet_03v3 ad=1.2116p pd=5.18u as=1.2116p ps=5.18u w=4.66u l=0.28u
X60 xl0.xpre.fa vb2 xl0.oa VSS nfet_03v3 ad=1.1752p pd=5.04u as=1.1752p ps=5.04u w=4.52u l=0.5u
X61 VDD vbp xl1.xpre.tp VDD pfet_03v3 ad=1.3p pd=5.52u as=1.3p ps=5.52u w=5u l=1u
X62 xl0.xpre.tp vref xl0.xpre.fa xl0.xpre.tp pfet_03v3 ad=1.248p pd=5.32u as=1.248p ps=5.32u w=4.8u l=0.4u
X63 xl1.xpre.tp vref xl1.xpre.fa xl1.xpre.tp pfet_03v3 ad=1.248p pd=5.32u as=1.248p ps=5.32u w=4.8u l=0.4u
D1 VSS xl2.gn diode_nd2ps_03v3 pj=26u area=40p
X64 xl1.xpre.fb xl1.gn xl1.xpre.tp xl1.xpre.tp pfet_03v3 ad=1.248p pd=5.32u as=1.248p ps=5.32u w=4.8u l=0.4u
X65 xl0.xpre.tn vbn VSS VSS nfet_03v3 ad=0.65p pd=3.02u as=0.65p ps=3.02u w=2.5u l=1u
X66 xl1.ob vref xl1.xpre.tn VSS nfet_03v3 ad=1.235p pd=5.27u as=1.235p ps=5.27u w=4.75u l=0.5u
X67 RX2_O xl2.xout.i2 VSS VSS nfet_03v3 ad=1.04p pd=4.52u as=1.04p ps=4.52u w=4u l=0.28u
X68 xl2.oa vb2 xl2.xpre.fa VSS nfet_03v3 ad=1.1752p pd=5.04u as=1.1752p ps=5.04u w=4.52u l=0.5u
X69 xl0.d2b xl0.d2a VDD VDD pfet_03v3 ad=0.481p pd=2.37u as=0.481p ps=2.37u w=1.85u l=0.28u
X70 VDD vbp xl1.xpre.tp VDD pfet_03v3 ad=1.3p pd=5.52u as=1.3p ps=5.52u w=5u l=1u
X71 xl0.xpre.fa vb2 xl0.oa VSS nfet_03v3 ad=1.1752p pd=5.04u as=1.1752p ps=5.04u w=4.52u l=0.5u
X72 xl1.xpre.tn VSS VSS VSS nfet_03v3 ad=0.65p pd=3.02u as=1.1p ps=5.88u w=2.5u l=1u
X73 VDD xl0.xout.i2 RX0_O VDD pfet_03v3 ad=1.3p pd=5.52u as=1.3p ps=5.52u w=5u l=0.28u
X74 VDD xl2.xout.d3 xl2.xout.nd VDD pfet_03v3 ad=0.78p pd=3.52u as=0.78p ps=3.52u w=3u l=0.28u
X75 VDD VDD VDD VDD pfet_03v3 ad=0.481p pd=2.37u as=0 ps=0 w=1.85u l=0.28u
X76 VDD VDD xl0.xout.i2 VDD pfet_03v3 ad=1.65p pd=8.38u as=0.975p ps=4.27u w=3.75u l=0.28u
X77 VSS vbn xl2.xpre.fa VSS nfet_03v3 ad=0.65p pd=3.02u as=0.65p ps=3.02u w=2.5u l=1u
X78 xl1.xpre.tn xl1.gp xl1.oa VSS nfet_03v3 ad=1.235p pd=5.27u as=1.235p ps=5.27u w=4.75u l=0.5u
X79 xl1.xhyst.ts vbn VSS VSS nfet_03v3 ad=0.65p pd=3.02u as=0.65p ps=3.02u w=2.5u l=1u
X80 VDD xl0.d2b xl0.xout.d3 VDD pfet_03v3 ad=0.481p pd=2.37u as=0.481p ps=2.37u w=1.85u l=0.28u
X81 VDD xl0.rla_m1 VSS ppolyf_u_1k r_width=2u r_length=9.11u
X82 xl2.oa VSS VSS VSS nfet_03v3 ad=1.1752p pd=5.04u as=1.9888p ps=9.92u w=4.52u l=0.5u
X83 xl2.d2a xl2.d2b VDD VDD pfet_03v3 ad=0.481p pd=2.37u as=0.481p ps=2.37u w=1.85u l=0.28u
X84 xl0.d2a xl0.d2a VDD VDD pfet_03v3 ad=0.481p pd=2.37u as=0.481p ps=2.37u w=1.85u l=0.28u
X85 VSS vbn xl0.xpre.fa VSS nfet_03v3 ad=0.65p pd=3.02u as=0.65p ps=3.02u w=2.5u l=1u
X86 VDD xl1.d2b xl1.xout.d3 VDD pfet_03v3 ad=0.481p pd=2.37u as=0.481p ps=2.37u w=1.85u l=0.28u
X87 xl1.d2a xl1.d2b VDD VDD pfet_03v3 ad=0.481p pd=2.37u as=0.481p ps=2.37u w=1.85u l=0.28u
X88 xl1.xhyst.ts xl1.xhyst.sb VSS ppolyf_u_1k r_width=5u r_length=1.64u
X89 xl0.xpre.tp vref xl0.xpre.fb xl0.xpre.tp pfet_03v3 ad=1.248p pd=5.32u as=2.112p ps=10.48u w=4.8u l=0.4u
X90 xl2.xpre.fb xl2.gn xl2.xpre.tp xl2.xpre.tp pfet_03v3 ad=1.248p pd=5.32u as=1.248p ps=5.32u w=4.8u l=0.4u
X91 VDD xl2.xout.i2 RX2_O VDD pfet_03v3 ad=1.3p pd=5.52u as=1.3p ps=5.52u w=5u l=0.28u
X92 xl0.xpre.fa xl0.gp xl0.xpre.tp xl0.xpre.tp pfet_03v3 ad=1.248p pd=5.32u as=1.248p ps=5.32u w=4.8u l=0.4u
X93 xl1.xpre.tp vref xl1.xpre.fa xl1.xpre.tp pfet_03v3 ad=1.248p pd=5.32u as=1.248p ps=5.32u w=4.8u l=0.4u
X94 xl0.xpre.tp vbp VDD VDD pfet_03v3 ad=1.3p pd=5.52u as=1.3p ps=5.52u w=5u l=1u
X95 xl1.xpre.fb vbn VSS VSS nfet_03v3 ad=0.65p pd=3.02u as=0.65p ps=3.02u w=2.5u l=1u
X96 xl2.xpre.tp xl2.gp xl2.xpre.fa xl2.xpre.tp pfet_03v3 ad=1.248p pd=5.32u as=1.248p ps=5.32u w=4.8u l=0.4u
X97 xl1.xpre.tp vbp VDD VDD pfet_03v3 ad=1.3p pd=5.52u as=1.3p ps=5.52u w=5u l=1u
X98 xl1.xpre.fa xl1.gp xl1.xpre.tp xl1.xpre.tp pfet_03v3 ad=1.248p pd=5.32u as=1.248p ps=5.32u w=4.8u l=0.4u
X99 xl2.xpre.fa xl2.gp xl2.xpre.tp xl2.xpre.tp pfet_03v3 ad=1.248p pd=5.32u as=1.248p ps=5.32u w=4.8u l=0.4u
X100 xl2.xpre.fa vbn VSS VSS nfet_03v3 ad=0.65p pd=3.02u as=0.65p ps=3.02u w=2.5u l=1u
X101 VSS vbn xl1.xpre.fb VSS nfet_03v3 ad=0.65p pd=3.02u as=0.65p ps=3.02u w=2.5u l=1u
X102 VSS VSS RX0_O VSS nfet_03v3 ad=1.76p pd=8.88u as=1.04p ps=4.52u w=4u l=0.28u
X103 VDD xl0.d2b xl0.d2a VDD pfet_03v3 ad=0.481p pd=2.37u as=0.481p ps=2.37u w=1.85u l=0.28u
X104 VSS VSS xl2.xhyst.ts VSS nfet_03v3 ad=1.1p pd=5.88u as=0.65p ps=3.02u w=2.5u l=1u
X105 xl0.xpre.tp vref xl0.xpre.fb xl0.xpre.tp pfet_03v3 ad=1.248p pd=5.32u as=1.248p ps=5.32u w=4.8u l=0.4u
X106 VDD xl2.d2a xl2.d2b VDD pfet_03v3 ad=0.481p pd=2.37u as=0.481p ps=2.37u w=1.85u l=0.28u
X107 VDD VDD VDD VDD pfet_03v3 ad=0.814p pd=4.58u as=0 ps=0 w=1.85u l=0.28u
X108 xl1.xpre.tp xl1.gp xl1.xpre.fa xl1.xpre.tp pfet_03v3 ad=1.248p pd=5.32u as=1.248p ps=5.32u w=4.8u l=0.4u
X109 VDD EN xl2.d2b VDD pfet_03v3 ad=0.52p pd=2.52u as=0.52p ps=2.52u w=2u l=0.5u
X110 VDD VDD VDD VDD pfet_03v3 ad=1.3p pd=5.52u as=0 ps=0 w=5u l=1u
X111 xl0.xpre.fb vref xl0.xpre.tp xl0.xpre.tp pfet_03v3 ad=1.248p pd=5.32u as=1.248p ps=5.32u w=4.8u l=0.4u
X112 VSS vbn xl1.xpre.tn VSS nfet_03v3 ad=0.65p pd=3.02u as=0.65p ps=3.02u w=2.5u l=1u
X113 xl0.xout.d3 xl0.d2b VDD VDD pfet_03v3 ad=0.481p pd=2.37u as=0.481p ps=2.37u w=1.85u l=0.28u
X114 xl0.xpre.tp vref xl0.xpre.fb xl0.xpre.tp pfet_03v3 ad=1.248p pd=5.32u as=1.248p ps=5.32u w=4.8u l=0.4u
X115 xl1.xpre.tp xl1.gn xl1.xpre.fb xl1.xpre.tp pfet_03v3 ad=1.248p pd=5.32u as=1.248p ps=5.32u w=4.8u l=0.4u
X116 xl1.xpre.tp xl1.gn xl1.xpre.fb xl1.xpre.tp pfet_03v3 ad=1.248p pd=5.32u as=1.248p ps=5.32u w=4.8u l=0.4u
X117 xl2.xout.i2 xl2.xout.i1 VDD VDD pfet_03v3 ad=0.975p pd=4.27u as=0.975p ps=4.27u w=3.75u l=0.28u
X118 VDD xl2.d2a xl2.d2b VDD pfet_03v3 ad=0.481p pd=2.37u as=0.481p ps=2.37u w=1.85u l=0.28u
X119 vb2 vbp VDD VDD pfet_03v3 ad=1.3p pd=5.52u as=1.3p ps=5.52u w=5u l=1u
X120 xl2.xpre.fa vref xl2.xpre.tp xl2.xpre.tp pfet_03v3 ad=1.248p pd=5.32u as=1.248p ps=5.32u w=4.8u l=0.4u
X121 VSS vbn xl2.xpre.tn VSS nfet_03v3 ad=0.65p pd=3.02u as=0.65p ps=3.02u w=2.5u l=1u
X122 VDD xl0.d2b xl0.d2b VDD pfet_03v3 ad=0.481p pd=2.37u as=0.481p ps=2.37u w=1.85u l=0.28u
X123 xl1.xout.d3 xl1.d2b VDD VDD pfet_03v3 ad=0.481p pd=2.37u as=0.481p ps=2.37u w=1.85u l=0.28u
D2 VSS xl0.gp diode_nd2ps_03v3 pj=26u area=40p
X124 xl1.xpre.fb xl1.gn xl1.xpre.tp xl1.xpre.tp pfet_03v3 ad=1.248p pd=5.32u as=1.248p ps=5.32u w=4.8u l=0.4u
X125 VSS VSS RX2_O VSS nfet_03v3 ad=1.76p pd=8.88u as=1.04p ps=4.52u w=4u l=0.28u
X126 VSS VSS xl1.d2a VSS nfet_03v3 ad=1.9228p pd=9.62u as=1.1362p ps=4.89u w=4.37u l=0.5u
X127 xl0.xpre.fb vbn VSS VSS nfet_03v3 ad=0.65p pd=3.02u as=0.65p ps=3.02u w=2.5u l=1u
X128 xl1.xout.n3a VSS VSS VSS nfet_03v3 ad=1.2116p pd=5.18u as=2.0504p ps=10.2u w=4.66u l=0.28u
X129 xl1.xhyst.sb xl1.ob xl1.d2b VSS nfet_03v3 ad=1.1362p pd=4.89u as=1.1362p ps=4.89u w=4.37u l=0.5u
X130 xl1.oa vref xl1.xpre.tn VSS nfet_03v3 ad=1.235p pd=5.27u as=1.235p ps=5.27u w=4.75u l=0.5u
X131 xl1.d2a xl1.d2b VDD VDD pfet_03v3 ad=0.481p pd=2.37u as=0.481p ps=2.37u w=1.85u l=0.28u
X132 xl2.xout.n3a VDD VDD VDD pfet_03v3 ad=0.481p pd=2.37u as=0.814p ps=4.58u w=1.85u l=0.28u
X133 VDD vbp xl1.xpre.tp VDD pfet_03v3 ad=1.3p pd=5.52u as=1.3p ps=5.52u w=5u l=1u
X134 VDD vbp xl2.xpre.tp VDD pfet_03v3 ad=1.3p pd=5.52u as=1.3p ps=5.52u w=5u l=1u
X135 VDD vbp vb2 VDD pfet_03v3 ad=1.3p pd=5.52u as=1.3p ps=5.52u w=5u l=1u
X136 xl1.xpre.fb xl1.gn xl1.xpre.tp xl1.xpre.tp pfet_03v3 ad=1.248p pd=5.32u as=1.248p ps=5.32u w=4.8u l=0.4u
X137 xl2.xpre.fb xl2.gn xl2.xpre.tp xl2.xpre.tp pfet_03v3 ad=1.248p pd=5.32u as=1.248p ps=5.32u w=4.8u l=0.4u
X138 VSS vbn xl2.xpre.fa VSS nfet_03v3 ad=0.65p pd=3.02u as=0.65p ps=3.02u w=2.5u l=1u
X139 xl0.xpre.tn xl0.gp xl0.oa VSS nfet_03v3 ad=1.235p pd=5.27u as=1.235p ps=5.27u w=4.75u l=0.5u
X140 xl1.ob vref xl1.xpre.tn VSS nfet_03v3 ad=1.235p pd=5.27u as=1.235p ps=5.27u w=4.75u l=0.5u
X141 VSS vbn xl0.xpre.fb VSS nfet_03v3 ad=0.65p pd=3.02u as=0.65p ps=3.02u w=2.5u l=1u
X142 xl1.d2b xl1.d2b VDD VDD pfet_03v3 ad=0.481p pd=2.37u as=0.481p ps=2.37u w=1.85u l=0.28u
X143 xl2.xpre.tp vref xl2.xpre.fb xl2.xpre.tp pfet_03v3 ad=1.248p pd=5.32u as=1.248p ps=5.32u w=4.8u l=0.4u
X144 xl1.ob vb2 xl1.xpre.fb VSS nfet_03v3 ad=1.1752p pd=5.04u as=1.1752p ps=5.04u w=4.52u l=0.5u
X145 VDD xl2.d2a xl2.xout.n3a VDD pfet_03v3 ad=0.481p pd=2.37u as=0.481p ps=2.37u w=1.85u l=0.28u
X146 VSS vbn xl1.xpre.fa VSS nfet_03v3 ad=0.65p pd=3.02u as=0.65p ps=3.02u w=2.5u l=1u
X147 xl2.oa xl2.gp xl2.xpre.tn VSS nfet_03v3 ad=1.235p pd=5.27u as=1.235p ps=5.27u w=4.75u l=0.5u
X148 xl1.xpre.tp xl1.gn xl1.xpre.fb xl1.xpre.tp pfet_03v3 ad=1.248p pd=5.32u as=1.248p ps=5.32u w=4.8u l=0.4u
X149 xl0.xpre.tn xl0.gn xl0.ob VSS nfet_03v3 ad=1.235p pd=5.27u as=1.235p ps=5.27u w=4.75u l=0.5u
X150 xl1.oa vref xl1.xpre.tn VSS nfet_03v3 ad=1.235p pd=5.27u as=1.235p ps=5.27u w=4.75u l=0.5u
X151 xl1.ob vb2 xl1.xpre.fb VSS nfet_03v3 ad=1.1752p pd=5.04u as=1.1752p ps=5.04u w=4.52u l=0.5u
X152 xl1.xpre.tp vbp VDD VDD pfet_03v3 ad=1.3p pd=5.52u as=1.3p ps=5.52u w=5u l=1u
X153 xl0.xpre.tp xl0.gp xl0.xpre.fa xl0.xpre.tp pfet_03v3 ad=1.248p pd=5.32u as=1.248p ps=5.32u w=4.8u l=0.4u
X154 xl2.xpre.fb vref xl2.xpre.tp xl2.xpre.tp pfet_03v3 ad=1.248p pd=5.32u as=1.248p ps=5.32u w=4.8u l=0.4u
X155 xl2.ob xl2.gn xl2.xpre.tn VSS nfet_03v3 ad=1.235p pd=5.27u as=1.235p ps=5.27u w=4.75u l=0.5u
X156 VSS vbn vbn VSS nfet_03v3 ad=0.65p pd=3.02u as=0.65p ps=3.02u w=2.5u l=1u
X157 xl0.xpre.tn vref xl0.ob VSS nfet_03v3 ad=1.235p pd=5.27u as=1.235p ps=5.27u w=4.75u l=0.5u
X158 xl2.xpre.tn vbn VSS VSS nfet_03v3 ad=0.65p pd=3.02u as=0.65p ps=3.02u w=2.5u l=1u
X159 xl2.xpre.tp vbp VDD VDD pfet_03v3 ad=1.3p pd=5.52u as=1.3p ps=5.52u w=5u l=1u
X160 xl2.xpre.fa vbn VSS VSS nfet_03v3 ad=0.65p pd=3.02u as=0.65p ps=3.02u w=2.5u l=1u
X161 xbias.rdb_m2 xbias.rdb_m1 VSS ppolyf_u_1k r_width=2u r_length=19.26u
X162 xl1.xpre.fa xl1.gp xl1.xpre.tp xl1.xpre.tp pfet_03v3 ad=1.248p pd=5.32u as=1.248p ps=5.32u w=4.8u l=0.4u
X163 xl1.ob VSS VSS VSS nfet_03v3 ad=1.1752p pd=5.04u as=1.9888p ps=9.92u w=4.52u l=0.5u
X164 xl2.xpre.tp vbp VDD VDD pfet_03v3 ad=1.3p pd=5.52u as=1.3p ps=5.52u w=5u l=1u
X165 xl1.xpre.tp vref xl1.xpre.fa xl1.xpre.tp pfet_03v3 ad=1.248p pd=5.32u as=1.248p ps=5.32u w=4.8u l=0.4u
X166 VDD EN xbias.enb VDD pfet_03v3 ad=0.65p pd=3.02u as=0.65p ps=3.02u w=2.5u l=0.28u
X167 xl0.xpre.fb xl0.gn xl0.xpre.tp xl0.xpre.tp pfet_03v3 ad=1.248p pd=5.32u as=1.248p ps=5.32u w=4.8u l=0.4u
X168 xl2.xpre.tp xl2.gp xl2.xpre.fa xl2.xpre.tp pfet_03v3 ad=1.248p pd=5.32u as=1.248p ps=5.32u w=4.8u l=0.4u
X169 xl2.ob vref xl2.xpre.tn VSS nfet_03v3 ad=1.235p pd=5.27u as=1.235p ps=5.27u w=4.75u l=0.5u
X170 xl2.xpre.tn xl2.gn xl2.ob VSS nfet_03v3 ad=1.235p pd=5.27u as=1.235p ps=5.27u w=4.75u l=0.5u
X171 VSS VSS VSS VSS nfet_03v3 ad=0.52p pd=2.52u as=0.26641n ps=1.29436m w=2u l=0.5u
X172 xl0.oa xl0.gp xl0.xpre.tn VSS nfet_03v3 ad=1.235p pd=5.27u as=1.235p ps=5.27u w=4.75u l=0.5u
X173 VDD EN xl1.d2a VDD pfet_03v3 ad=0.52p pd=2.52u as=0.52p ps=2.52u w=2u l=0.5u
X174 xl1.xout.n3a xl1.d2a VDD VDD pfet_03v3 ad=0.481p pd=2.37u as=0.481p ps=2.37u w=1.85u l=0.28u
X175 xl0.xpre.tp xl0.gn xl0.xpre.fb xl0.xpre.tp pfet_03v3 ad=1.248p pd=5.32u as=1.248p ps=5.32u w=4.8u l=0.4u
X176 vbn VSS VSS VSS nfet_03v3 ad=0.52p pd=2.52u as=0.88p ps=4.88u w=2u l=0.5u
X177 VDD vbp xl1.xpre.tp VDD pfet_03v3 ad=1.3p pd=5.52u as=1.3p ps=5.52u w=5u l=1u
X178 xl0.xpre.fb vref xl0.xpre.tp xl0.xpre.tp pfet_03v3 ad=1.248p pd=5.32u as=1.248p ps=5.32u w=4.8u l=0.4u
X179 xl1.xpre.tp xl1.gn xl1.xpre.fb xl1.xpre.tp pfet_03v3 ad=1.248p pd=5.32u as=1.248p ps=5.32u w=4.8u l=0.4u
X180 xl0.xpre.tp vbp VDD VDD pfet_03v3 ad=1.3p pd=5.52u as=1.3p ps=5.52u w=5u l=1u
X181 xl1.xpre.fb vbn VSS VSS nfet_03v3 ad=0.65p pd=3.02u as=0.65p ps=3.02u w=2.5u l=1u
X182 VSS VSS xbias.vf VSS nfet_03v3 ad=3.4804p pd=16.7u as=2.0566p ps=8.43u w=7.91u l=0.5u
X183 xl1.d2b VDD VDD VDD pfet_03v3 ad=0.52p pd=2.52u as=0.88p ps=4.88u w=2u l=0.5u
X184 xl2.xhyst.ts xl2.xhyst.sa VSS ppolyf_u_1k r_width=5u r_length=1.64u
X185 vbp VDD VDD VDD pfet_03v3 ad=1.3p pd=5.52u as=2.2p ps=10.88u w=5u l=1u
X186 xl2.xpre.fa vref xl2.xpre.tp xl2.xpre.tp pfet_03v3 ad=1.248p pd=5.32u as=1.248p ps=5.32u w=4.8u l=0.4u
X187 VSS VSS xl2.xpre.fa VSS nfet_03v3 ad=1.9888p pd=9.92u as=1.1752p ps=5.04u w=4.52u l=0.5u
X188 VDD xl2.xout.nd xl2.xout.i1 VDD pfet_03v3 ad=0.962p pd=4.22u as=0.962p ps=4.22u w=3.7u l=0.28u
X189 VDD vbp vbp VDD pfet_03v3 ad=1.3p pd=5.52u as=1.3p ps=5.52u w=5u l=1u
X190 VDD vbp xl2.xpre.tp VDD pfet_03v3 ad=1.3p pd=5.52u as=1.3p ps=5.52u w=5u l=1u
X191 xl1.xpre.fb xl1.gn xl1.xpre.tp xl1.xpre.tp pfet_03v3 ad=1.248p pd=5.32u as=1.248p ps=5.32u w=4.8u l=0.4u
X192 xl1.oa vref xl1.xpre.tn VSS nfet_03v3 ad=1.235p pd=5.27u as=1.235p ps=5.27u w=4.75u l=0.5u
X193 xl2.xpre.tp vref xl2.xpre.fb xl2.xpre.tp pfet_03v3 ad=1.248p pd=5.32u as=1.248p ps=5.32u w=4.8u l=0.4u
X194 VDD vbp xl2.xpre.tp VDD pfet_03v3 ad=1.3p pd=5.52u as=1.3p ps=5.52u w=5u l=1u
X195 xl2.oa vb2 xl2.xpre.fa VSS nfet_03v3 ad=1.1752p pd=5.04u as=1.1752p ps=5.04u w=4.52u l=0.5u
X196 xl0.xpre.tp xl0.gp xl0.xpre.fa xl0.xpre.tp pfet_03v3 ad=1.248p pd=5.32u as=1.248p ps=5.32u w=4.8u l=0.4u
X197 xl1.xpre.fb vref xl1.xpre.tp xl1.xpre.tp pfet_03v3 ad=1.248p pd=5.32u as=1.248p ps=5.32u w=4.8u l=0.4u
X198 xl2.xpre.fb vb2 xl2.ob VSS nfet_03v3 ad=1.1752p pd=5.04u as=1.1752p ps=5.04u w=4.52u l=0.5u
X199 VSS vref VSS VSS nfet_03v3 ad=8.8p pd=40.88u as=0 ps=0 w=20u l=25.13u
X200 xl1.xout.i2 VDD VDD VDD pfet_03v3 ad=0.975p pd=4.27u as=1.65p ps=8.38u w=3.75u l=0.28u
X201 xbias.rf_m1 VSS VSS ppolyf_u_1k r_width=2u r_length=23.07u
X202 vb2 VSS VSS VSS nfet_03v3 ad=2.0566p pd=8.43u as=3.4804p ps=16.7u w=7.91u l=0.5u
X203 xl2.xpre.tp xl2.gp xl2.xpre.fa xl2.xpre.tp pfet_03v3 ad=1.248p pd=5.32u as=1.248p ps=5.32u w=4.8u l=0.4u
X204 VSS vbn xl0.xpre.fb VSS nfet_03v3 ad=0.65p pd=3.02u as=0.65p ps=3.02u w=2.5u l=1u
X205 xl0.ob vb2 xl0.xpre.fb VSS nfet_03v3 ad=1.1752p pd=5.04u as=1.1752p ps=5.04u w=4.52u l=0.5u
X206 xl2.xpre.tp vbp VDD VDD pfet_03v3 ad=1.3p pd=5.52u as=1.3p ps=5.52u w=5u l=1u
X207 xl0.xpre.fa vref xl0.xpre.tp xl0.xpre.tp pfet_03v3 ad=1.248p pd=5.32u as=1.248p ps=5.32u w=4.8u l=0.4u
X208 xl1.xpre.fb xl1.gn xl1.xpre.tp xl1.xpre.tp pfet_03v3 ad=1.248p pd=5.32u as=1.248p ps=5.32u w=4.8u l=0.4u
X209 xl2.xpre.fb vref xl2.xpre.tp xl2.xpre.tp pfet_03v3 ad=1.248p pd=5.32u as=1.248p ps=5.32u w=4.8u l=0.4u
X210 VDD VDD xl1.xpre.tp VDD pfet_03v3 ad=2.2p pd=10.88u as=1.3p ps=5.52u w=5u l=1u
X211 xl0.xpre.fa vref xl0.xpre.tp xl0.xpre.tp pfet_03v3 ad=1.248p pd=5.32u as=1.248p ps=5.32u w=4.8u l=0.4u
X212 xl1.xpre.tp vref xl1.xpre.fa xl1.xpre.tp pfet_03v3 ad=1.248p pd=5.32u as=1.248p ps=5.32u w=4.8u l=0.4u
X213 xl0.xpre.tn vbn VSS VSS nfet_03v3 ad=0.65p pd=3.02u as=0.65p ps=3.02u w=2.5u l=1u
X214 VDD VDD xl0.xout.n3a VDD pfet_03v3 ad=0.814p pd=4.58u as=0.481p ps=2.37u w=1.85u l=0.28u
X215 VSS vbn xl2.xhyst.ts VSS nfet_03v3 ad=0.65p pd=3.02u as=0.65p ps=3.02u w=2.5u l=1u
X216 VSS xbias.enb vb2 VSS nfet_03v3 ad=0.52p pd=2.52u as=0.52p ps=2.52u w=2u l=0.5u
X217 VSS vbn xl0.xhyst.ts VSS nfet_03v3 ad=0.65p pd=3.02u as=0.65p ps=3.02u w=2.5u l=1u
X218 xl1.xpre.tp vref xl1.xpre.fa xl1.xpre.tp pfet_03v3 ad=1.248p pd=5.32u as=1.248p ps=5.32u w=4.8u l=0.4u
X219 VDD xl0.d2b xl0.d2b VDD pfet_03v3 ad=0.481p pd=2.37u as=0.481p ps=2.37u w=1.85u l=0.28u
X220 xl0.xpre.tp xl0.gn xl0.xpre.fb xl0.xpre.tp pfet_03v3 ad=1.248p pd=5.32u as=1.248p ps=5.32u w=4.8u l=0.4u
X221 xl0.xpre.fa vref xl0.xpre.tp xl0.xpre.tp pfet_03v3 ad=1.248p pd=5.32u as=1.248p ps=5.32u w=4.8u l=0.4u
X222 xl1.xpre.fa vref xl1.xpre.tp xl1.xpre.tp pfet_03v3 ad=1.248p pd=5.32u as=1.248p ps=5.32u w=4.8u l=0.4u
X223 xl2.xpre.tp xl2.gp xl2.xpre.fa xl2.xpre.tp pfet_03v3 ad=1.248p pd=5.32u as=1.248p ps=5.32u w=4.8u l=0.4u
X224 xl1.xpre.tn xl1.gp xl1.oa VSS nfet_03v3 ad=1.235p pd=5.27u as=1.235p ps=5.27u w=4.75u l=0.5u
X225 xl0.xpre.tp vref xl0.xpre.fb xl0.xpre.tp pfet_03v3 ad=1.248p pd=5.32u as=1.248p ps=5.32u w=4.8u l=0.4u
X226 xl1.xpre.tp xl1.gn xl1.xpre.fb xl1.xpre.tp pfet_03v3 ad=1.248p pd=5.32u as=1.248p ps=5.32u w=4.8u l=0.4u
X227 xl2.xpre.fa xl2.gp xl2.xpre.tp xl2.xpre.tp pfet_03v3 ad=1.248p pd=5.32u as=1.248p ps=5.32u w=4.8u l=0.4u
X228 xbias.nrb VDD VDD VDD pfet_03v3 ad=1.3p pd=5.52u as=2.2p ps=10.88u w=5u l=0.5u
X229 xl1.xhyst.sa xl1.oa xl1.d2a VSS nfet_03v3 ad=1.1362p pd=4.89u as=1.1362p ps=4.89u w=4.37u l=0.5u
X230 VSS VSS VSS ppolyf_u_1k r_width=2u r_length=9.11u
X231 xl2.xpre.tn vref xl2.ob VSS nfet_03v3 ad=1.235p pd=5.27u as=1.235p ps=5.27u w=4.75u l=0.5u
X232 VSS vbn xl0.xpre.fa VSS nfet_03v3 ad=0.65p pd=3.02u as=0.65p ps=3.02u w=2.5u l=1u
X233 VSS VSS vbp VSS nfet_03v3 ad=1.1p pd=5.88u as=0.65p ps=3.02u w=2.5u l=1u
X234 xl1.xout.n3a xl1.d2a VDD VDD pfet_03v3 ad=0.481p pd=2.37u as=0.481p ps=2.37u w=1.85u l=0.28u
X235 VDD VDD VDD VDD pfet_03v3 ad=0.52p pd=2.52u as=0 ps=0 w=2u l=0.5u
X236 VDD xl0.d2b xl0.d2a VDD pfet_03v3 ad=0.481p pd=2.37u as=0.481p ps=2.37u w=1.85u l=0.28u
X237 xl0.oa vref xl0.xpre.tn VSS nfet_03v3 ad=1.235p pd=5.27u as=1.235p ps=5.27u w=4.75u l=0.5u
X238 xl1.xpre.tn xl1.gp xl1.oa VSS nfet_03v3 ad=1.235p pd=5.27u as=1.235p ps=5.27u w=4.75u l=0.5u
X239 xl1.xout.d3 xl1.xout.n3a VSS VSS nfet_03v3 ad=1.2116p pd=5.18u as=1.2116p ps=5.18u w=4.66u l=0.28u
X240 xl1.xpre.fa xl1.gp xl1.xpre.tp xl1.xpre.tp pfet_03v3 ad=1.248p pd=5.32u as=1.248p ps=5.32u w=4.8u l=0.4u
X241 VSS VSS xl1.xpre.fa VSS nfet_03v3 ad=1.1p pd=5.88u as=0.65p ps=3.02u w=2.5u l=1u
D3 xl0.gp VDD diode_pd2nw_03v3 pj=26u area=40p
X242 xl0.xpre.tp vref xl0.xpre.fa xl0.xpre.tp pfet_03v3 ad=1.248p pd=5.32u as=1.248p ps=5.32u w=4.8u l=0.4u
X243 VSS xl1.xout.i1 xl1.xout.i2 VSS nfet_03v3 ad=0.78p pd=3.52u as=0.78p ps=3.52u w=3u l=0.28u
X244 VSS xl1.xout.i2 RX1_O VSS nfet_03v3 ad=1.04p pd=4.52u as=1.04p ps=4.52u w=4u l=0.28u
X245 VDD vbp xl0.xpre.tp VDD pfet_03v3 ad=1.3p pd=5.52u as=1.3p ps=5.52u w=5u l=1u
X246 xl0.xpre.fb xl0.gn xl0.xpre.tp xl0.xpre.tp pfet_03v3 ad=1.248p pd=5.32u as=1.248p ps=5.32u w=4.8u l=0.4u
X247 xl0.ob vref xl0.xpre.tn VSS nfet_03v3 ad=1.235p pd=5.27u as=1.235p ps=5.27u w=4.75u l=0.5u
X248 xl1.xpre.tn xl1.gn xl1.ob VSS nfet_03v3 ad=1.235p pd=5.27u as=1.235p ps=5.27u w=4.75u l=0.5u
X249 xl2.xpre.tp vref xl2.xpre.fb xl2.xpre.tp pfet_03v3 ad=1.248p pd=5.32u as=1.248p ps=5.32u w=4.8u l=0.4u
X250 VDD vbp xl0.xpre.tp VDD pfet_03v3 ad=1.3p pd=5.52u as=1.3p ps=5.52u w=5u l=1u
X251 VDD vbp xl1.xpre.tp VDD pfet_03v3 ad=1.3p pd=5.52u as=1.3p ps=5.52u w=5u l=1u
X252 xl1.oa vb2 xl1.xpre.fa VSS nfet_03v3 ad=1.1752p pd=5.04u as=1.1752p ps=5.04u w=4.52u l=0.5u
X253 xl0.xpre.tn VSS VSS VSS nfet_03v3 ad=0.65p pd=3.02u as=1.1p ps=5.88u w=2.5u l=1u
X254 VSS VSS VSS ppolyf_u_1k r_width=5u r_length=1.64u
X255 xl2.xhyst.ts vbn VSS VSS nfet_03v3 ad=0.65p pd=3.02u as=0.65p ps=3.02u w=2.5u l=1u
X256 VSS VSS xl1.xpre.fb VSS nfet_03v3 ad=1.9888p pd=9.92u as=1.1752p ps=5.04u w=4.52u l=0.5u
X257 VDD xl1.xout.d3 xl1.xout.nd VDD pfet_03v3 ad=0.78p pd=3.52u as=0.78p ps=3.52u w=3u l=0.28u
X258 VDD VDD VDD VDD pfet_03v3 ad=0.481p pd=2.37u as=0 ps=0 w=1.85u l=0.28u
X259 xl0.xpre.tn xl0.gp xl0.oa VSS nfet_03v3 ad=1.235p pd=5.27u as=1.235p ps=5.27u w=4.75u l=0.5u
X260 xl0.xhyst.ts vbn VSS VSS nfet_03v3 ad=0.65p pd=3.02u as=0.65p ps=3.02u w=2.5u l=1u
X261 xl1.oa VSS VSS VSS nfet_03v3 ad=1.1752p pd=5.04u as=1.9888p ps=9.92u w=4.52u l=0.5u
X262 xl2.d2b xl2.d2b VDD VDD pfet_03v3 ad=0.481p pd=2.37u as=0.481p ps=2.37u w=1.85u l=0.28u
X263 xl1.d2a xl1.d2b VDD VDD pfet_03v3 ad=0.481p pd=2.37u as=0.481p ps=2.37u w=1.85u l=0.28u
X264 xl2.xpre.tp vref xl2.xpre.fb xl2.xpre.tp pfet_03v3 ad=1.248p pd=5.32u as=1.248p ps=5.32u w=4.8u l=0.4u
X265 xl1.xhyst.ts vbn VSS VSS nfet_03v3 ad=0.65p pd=3.02u as=0.65p ps=3.02u w=2.5u l=1u
X266 VDD xl0.d2b xl0.xout.d3 VDD pfet_03v3 ad=0.481p pd=2.37u as=0.481p ps=2.37u w=1.85u l=0.28u
X267 xl1.xpre.tp xl1.gn xl1.xpre.fb xl1.xpre.tp pfet_03v3 ad=1.248p pd=5.32u as=1.248p ps=5.32u w=4.8u l=0.4u
X268 xl2.oa xl2.gp xl2.xpre.tn VSS nfet_03v3 ad=1.235p pd=5.27u as=1.235p ps=5.27u w=4.75u l=0.5u
X269 RX1_O xl1.xout.i2 VDD VDD pfet_03v3 ad=1.3p pd=5.52u as=1.3p ps=5.52u w=5u l=0.28u
X270 xl0.xhyst.ts xl0.xhyst.sb VSS ppolyf_u_1k r_width=5u r_length=1.64u
X271 VSS xl2.xout.n3a xl2.xout.n3a VSS nfet_03v3 ad=1.2116p pd=5.18u as=1.2116p ps=5.18u w=4.66u l=0.28u
X272 xl0.d2a xl0.d2b VDD VDD pfet_03v3 ad=0.481p pd=2.37u as=0.481p ps=2.37u w=1.85u l=0.28u
X273 xl0.xpre.tp vref xl0.xpre.fa xl0.xpre.tp pfet_03v3 ad=1.248p pd=5.32u as=1.248p ps=5.32u w=4.8u l=0.4u
X274 xl2.xpre.fb vref xl2.xpre.tp xl2.xpre.tp pfet_03v3 ad=1.248p pd=5.32u as=1.248p ps=5.32u w=4.8u l=0.4u
X275 xl0.xpre.fb vbn VSS VSS nfet_03v3 ad=0.65p pd=3.02u as=0.65p ps=3.02u w=2.5u l=1u
X276 xl2.ob vref xl2.xpre.tn VSS nfet_03v3 ad=1.235p pd=5.27u as=1.235p ps=5.27u w=4.75u l=0.5u
X277 xl0.xpre.tp vbp VDD VDD pfet_03v3 ad=1.3p pd=5.52u as=1.3p ps=5.52u w=5u l=1u
X278 xl1.xpre.fa xl1.gp xl1.xpre.tp xl1.xpre.tp pfet_03v3 ad=1.248p pd=5.32u as=1.248p ps=5.32u w=4.8u l=0.4u
X279 xl0.xpre.fa xl0.gp xl0.xpre.tp xl0.xpre.tp pfet_03v3 ad=1.248p pd=5.32u as=1.248p ps=5.32u w=4.8u l=0.4u
X280 xl1.xpre.fa vbn VSS VSS nfet_03v3 ad=0.65p pd=3.02u as=0.65p ps=3.02u w=2.5u l=1u
X281 xl2.xout.nd VDD VDD VDD pfet_03v3 ad=0.78p pd=3.52u as=1.32p ps=6.88u w=3u l=0.28u
X282 VDD xl1.d2a xl1.d2a VDD pfet_03v3 ad=0.481p pd=2.37u as=0.481p ps=2.37u w=1.85u l=0.28u
X283 xl2.xpre.tp vref xl2.xpre.fa xl2.xpre.tp pfet_03v3 ad=1.248p pd=5.32u as=1.248p ps=5.32u w=4.8u l=0.4u
X284 VSS vbn xl0.xpre.fb VSS nfet_03v3 ad=0.65p pd=3.02u as=0.65p ps=3.02u w=2.5u l=1u
X285 VDD xl2.d2a xl2.xout.n3a VDD pfet_03v3 ad=0.481p pd=2.37u as=0.481p ps=2.37u w=1.85u l=0.28u
X286 xl1.xout.i2 VSS VSS VSS nfet_03v3 ad=0.78p pd=3.52u as=1.32p ps=6.88u w=3u l=0.28u
X287 RX1_O VSS VSS VSS nfet_03v3 ad=1.04p pd=4.52u as=1.76p ps=8.88u w=4u l=0.28u
X288 xl0.xpre.tp xl0.gp xl0.xpre.fa xl0.xpre.tp pfet_03v3 ad=1.248p pd=5.32u as=1.248p ps=5.32u w=4.8u l=0.4u
X289 VSS VSS VSS VSS nfet_03v3 ad=0.39p pd=2.02u as=0 ps=0 w=1.5u l=0.28u
X290 VDD VDD VDD VDD pfet_03v3 ad=0.814p pd=4.58u as=0 ps=0 w=1.85u l=0.28u
X291 xl1.xpre.tp vbp VDD VDD pfet_03v3 ad=1.3p pd=5.52u as=1.3p ps=5.52u w=5u l=1u
X292 VSS vbn xl0.xpre.tn VSS nfet_03v3 ad=0.65p pd=3.02u as=0.65p ps=3.02u w=2.5u l=1u
X293 VDD EN vbp VDD pfet_03v3 ad=0.52p pd=2.52u as=0.52p ps=2.52u w=2u l=0.5u
X294 xl0.xpre.tp xl0.gn xl0.xpre.fb xl0.xpre.tp pfet_03v3 ad=1.248p pd=5.32u as=1.248p ps=5.32u w=4.8u l=0.4u
X295 xl0.xpre.tp xl0.gn xl0.xpre.fb xl0.xpre.tp pfet_03v3 ad=1.248p pd=5.32u as=1.248p ps=5.32u w=4.8u l=0.4u
X296 VDD xl1.d2a xl1.d2b VDD pfet_03v3 ad=0.481p pd=2.37u as=0.481p ps=2.37u w=1.85u l=0.28u
X297 xl2.xhyst.ts vbn VSS VSS nfet_03v3 ad=0.65p pd=3.02u as=0.65p ps=3.02u w=2.5u l=1u
X298 xl1.xpre.fa vref xl1.xpre.tp xl1.xpre.tp pfet_03v3 ad=1.248p pd=5.32u as=1.248p ps=5.32u w=4.8u l=0.4u
X299 xl2.xpre.fa vref xl2.xpre.tp xl2.xpre.tp pfet_03v3 ad=1.248p pd=5.32u as=1.248p ps=5.32u w=4.8u l=0.4u
X300 xbias.nmid EN VSS VSS nfet_03v3 ad=1.3p pd=5.52u as=1.3p ps=5.52u w=5u l=0.5u
X301 xl2.xpre.fb vbn VSS VSS nfet_03v3 ad=0.65p pd=3.02u as=0.65p ps=3.02u w=2.5u l=1u
X302 VSS vbn xl1.xpre.tn VSS nfet_03v3 ad=0.65p pd=3.02u as=0.65p ps=3.02u w=2.5u l=1u
X303 VSS VSS VSS VSS nfet_03v3 ad=0.78p pd=3.52u as=0 ps=0 w=3u l=0.28u
X304 VSS vbn vbp VSS nfet_03v3 ad=0.65p pd=3.02u as=0.65p ps=3.02u w=2.5u l=1u
X305 xl0.xout.d3 xl0.d2b VDD VDD pfet_03v3 ad=0.481p pd=2.37u as=0.481p ps=2.37u w=1.85u l=0.28u
X306 xl2.d2b xl2.ob xl2.xhyst.sb VSS nfet_03v3 ad=1.1362p pd=4.89u as=1.1362p ps=4.89u w=4.37u l=0.5u
X307 xl0.xpre.fb xl0.gn xl0.xpre.tp xl0.xpre.tp pfet_03v3 ad=1.248p pd=5.32u as=1.248p ps=5.32u w=4.8u l=0.4u
X308 xl2.xpre.tp vref xl2.xpre.fa xl2.xpre.tp pfet_03v3 ad=1.248p pd=5.32u as=1.248p ps=5.32u w=4.8u l=0.4u
X309 xl1.ob vref xl1.xpre.tn VSS nfet_03v3 ad=2.09p pd=10.38u as=1.235p ps=5.27u w=4.75u l=0.5u
X310 VDD xbias.rdt_m1 VSS ppolyf_u_1k r_width=2u r_length=21.01u
X311 xl2.xpre.fa vbn VSS VSS nfet_03v3 ad=0.65p pd=3.02u as=0.65p ps=3.02u w=2.5u l=1u
X312 VSS vbn xl1.xhyst.ts VSS nfet_03v3 ad=0.65p pd=3.02u as=0.65p ps=3.02u w=2.5u l=1u
X313 xbias.nmid VSS VSS VSS nfet_03v3 ad=1.3p pd=5.52u as=2.2p ps=10.88u w=5u l=0.5u
X314 xl0.xhyst.sb xl0.ob xl0.d2b VSS nfet_03v3 ad=1.1362p pd=4.89u as=1.1362p ps=4.89u w=4.37u l=0.5u
X315 VSS VSS xl0.d2a VSS nfet_03v3 ad=1.9228p pd=9.62u as=1.1362p ps=4.89u w=4.37u l=0.5u
X316 xl2.xpre.fa vref xl2.xpre.tp xl2.xpre.tp pfet_03v3 ad=1.248p pd=5.32u as=1.248p ps=5.32u w=4.8u l=0.4u
X317 VDD xl1.xout.i2 RX1_O VDD pfet_03v3 ad=1.3p pd=5.52u as=1.3p ps=5.52u w=5u l=0.28u
X318 xl2.xpre.fb vb2 xl2.ob VSS nfet_03v3 ad=1.1752p pd=5.04u as=1.1752p ps=5.04u w=4.52u l=0.5u
X319 xl0.d2a xl0.d2b VDD VDD pfet_03v3 ad=0.481p pd=2.37u as=0.481p ps=2.37u w=1.85u l=0.28u
X320 xl0.oa vref xl0.xpre.tn VSS nfet_03v3 ad=1.235p pd=5.27u as=1.235p ps=5.27u w=4.75u l=0.5u
X321 xl1.xout.n3a VDD VDD VDD pfet_03v3 ad=0.481p pd=2.37u as=0.814p ps=4.58u w=1.85u l=0.28u
X322 xl2.xpre.fa vref xl2.xpre.tp xl2.xpre.tp pfet_03v3 ad=1.248p pd=5.32u as=1.248p ps=5.32u w=4.8u l=0.4u
X323 xl2.oa vb2 xl2.xpre.fa VSS nfet_03v3 ad=1.1752p pd=5.04u as=1.1752p ps=5.04u w=4.52u l=0.5u
X324 VDD VDD xl2.xout.nd VDD pfet_03v3 ad=1.32p pd=6.88u as=0.78p ps=3.52u w=3u l=0.28u
X325 xl2.d2b xl2.d2a VDD VDD pfet_03v3 ad=0.481p pd=2.37u as=0.481p ps=2.37u w=1.85u l=0.28u
X326 VDD vbp xl0.xpre.tp VDD pfet_03v3 ad=1.3p pd=5.52u as=1.3p ps=5.52u w=5u l=1u
X327 xl0.xpre.fb xl0.gn xl0.xpre.tp xl0.xpre.tp pfet_03v3 ad=1.248p pd=5.32u as=1.248p ps=5.32u w=4.8u l=0.4u
X328 xl1.xpre.fb xl1.gn xl1.xpre.tp xl1.xpre.tp pfet_03v3 ad=1.248p pd=5.32u as=1.248p ps=5.32u w=4.8u l=0.4u
X329 xl2.xpre.fb vb2 xl2.ob VSS nfet_03v3 ad=1.1752p pd=5.04u as=1.1752p ps=5.04u w=4.52u l=0.5u
X330 VSS vbn xl1.xpre.fa VSS nfet_03v3 ad=0.65p pd=3.02u as=0.65p ps=3.02u w=2.5u l=1u
X331 xl0.ob vref xl0.xpre.tn VSS nfet_03v3 ad=1.235p pd=5.27u as=1.235p ps=5.27u w=4.75u l=0.5u
X332 xl1.xhyst.ts vbn VSS VSS nfet_03v3 ad=0.65p pd=3.02u as=0.65p ps=3.02u w=2.5u l=1u
X333 VSS VSS VSS ppolyf_u_1k r_width=5u r_length=1.64u
X334 VDD xl2.xout.i1 xl2.xout.i2 VDD pfet_03v3 ad=0.975p pd=4.27u as=0.975p ps=4.27u w=3.75u l=0.28u
X335 VSS VSS VSS ppolyf_u_1k r_width=2u r_length=21.01u
X336 xbias.rdb_m2 xbias.rdb_m3 VSS ppolyf_u_1k r_width=2u r_length=19.26u
X337 xl2.xpre.tp vref xl2.xpre.fb xl2.xpre.tp pfet_03v3 ad=1.248p pd=5.32u as=1.248p ps=5.32u w=4.8u l=0.4u
X338 xl0.ob vb2 xl0.xpre.fb VSS nfet_03v3 ad=1.1752p pd=5.04u as=1.1752p ps=5.04u w=4.52u l=0.5u
X339 VSS vbn xl2.xpre.fb VSS nfet_03v3 ad=0.65p pd=3.02u as=0.65p ps=3.02u w=2.5u l=1u
X340 VDD xl1.d2a xl1.xout.n3a VDD pfet_03v3 ad=0.481p pd=2.37u as=0.481p ps=2.37u w=1.85u l=0.28u
X341 xl0.d2b xl0.d2b VDD VDD pfet_03v3 ad=0.481p pd=2.37u as=0.481p ps=2.37u w=1.85u l=0.28u
X342 xl1.xpre.fb vref xl1.xpre.tp xl1.xpre.tp pfet_03v3 ad=2.112p pd=10.48u as=1.248p ps=5.32u w=4.8u l=0.4u
X343 VSS vbn xl0.xpre.fa VSS nfet_03v3 ad=0.65p pd=3.02u as=0.65p ps=3.02u w=2.5u l=1u
X344 xl1.oa xl1.gp xl1.xpre.tn VSS nfet_03v3 ad=1.235p pd=5.27u as=1.235p ps=5.27u w=4.75u l=0.5u
X345 xl2.xpre.tn vref xl2.oa VSS nfet_03v3 ad=1.235p pd=5.27u as=1.235p ps=5.27u w=4.75u l=0.5u
X346 xl2.ob xl2.rlb_m1 VSS ppolyf_u_1k r_width=2u r_length=9.11u
X347 xl0.xpre.tp xl0.gn xl0.xpre.fb xl0.xpre.tp pfet_03v3 ad=1.248p pd=5.32u as=1.248p ps=5.32u w=4.8u l=0.4u
X348 xl0.oa vref xl0.xpre.tn VSS nfet_03v3 ad=1.235p pd=5.27u as=1.235p ps=5.27u w=4.75u l=0.5u
X349 VSS VSS VSS ppolyf_u_1k r_width=2u r_length=23.07u
X350 xl0.ob vb2 xl0.xpre.fb VSS nfet_03v3 ad=1.1752p pd=5.04u as=1.1752p ps=5.04u w=4.52u l=0.5u
X351 xl0.xpre.tp vbp VDD VDD pfet_03v3 ad=1.3p pd=5.52u as=1.3p ps=5.52u w=5u l=1u
X352 xl1.xpre.fb vref xl1.xpre.tp xl1.xpre.tp pfet_03v3 ad=1.248p pd=5.32u as=1.248p ps=5.32u w=4.8u l=0.4u
X353 xl1.xpre.tn vbn VSS VSS nfet_03v3 ad=0.65p pd=3.02u as=0.65p ps=3.02u w=2.5u l=1u
X354 xl1.ob xl1.gn xl1.xpre.tn VSS nfet_03v3 ad=1.235p pd=5.27u as=1.235p ps=5.27u w=4.75u l=0.5u
X355 xl1.xpre.tp vbp VDD VDD pfet_03v3 ad=1.3p pd=5.52u as=1.3p ps=5.52u w=5u l=1u
X356 VSS VSS xl1.d2b VSS nfet_03v3 ad=1.9228p pd=9.62u as=1.1362p ps=4.89u w=4.37u l=0.5u
X357 VDD vbp vbp VDD pfet_03v3 ad=1.3p pd=5.52u as=1.3p ps=5.52u w=5u l=1u
X358 xl0.xpre.fa xl0.gp xl0.xpre.tp xl0.xpre.tp pfet_03v3 ad=1.248p pd=5.32u as=1.248p ps=5.32u w=4.8u l=0.4u
X359 xl0.ob VSS VSS VSS nfet_03v3 ad=1.1752p pd=5.04u as=1.9888p ps=9.92u w=4.52u l=0.5u
X360 xl2.xpre.fa VSS VSS VSS nfet_03v3 ad=0.65p pd=3.02u as=1.1p ps=5.88u w=2.5u l=1u
X361 xl0.xpre.tp vref xl0.xpre.fa xl0.xpre.tp pfet_03v3 ad=1.248p pd=5.32u as=1.248p ps=5.32u w=4.8u l=0.4u
X362 xl1.xpre.fb xl1.gn xl1.xpre.tp xl1.xpre.tp pfet_03v3 ad=1.248p pd=5.32u as=1.248p ps=5.32u w=4.8u l=0.4u
X363 xl2.xpre.tn vbn VSS VSS nfet_03v3 ad=0.65p pd=3.02u as=0.65p ps=3.02u w=2.5u l=1u
X364 VSS xl0.xout.i2 RX0_O VSS nfet_03v3 ad=1.04p pd=4.52u as=1.04p ps=4.52u w=4u l=0.28u
X365 VSS xl0.xout.i1 xl0.xout.i2 VSS nfet_03v3 ad=0.78p pd=3.52u as=0.78p ps=3.52u w=3u l=0.28u
X366 xl2.gp RX2_P VDD ppolyf_u r_width=5u r_length=1.8u
X367 xl2.xpre.fb vbn VSS VSS nfet_03v3 ad=0.65p pd=3.02u as=0.65p ps=3.02u w=2.5u l=1u
X368 xl1.ob vref xl1.xpre.tn VSS nfet_03v3 ad=1.235p pd=5.27u as=1.235p ps=5.27u w=4.75u l=0.5u
X369 VSS vbn xl1.xhyst.ts VSS nfet_03v3 ad=0.65p pd=3.02u as=0.65p ps=3.02u w=2.5u l=1u
X370 xbias.nrb xbias.enb VDD VDD pfet_03v3 ad=1.3p pd=5.52u as=1.3p ps=5.52u w=5u l=0.5u
X371 xl2.xpre.fb vref xl2.xpre.tp xl2.xpre.tp pfet_03v3 ad=1.248p pd=5.32u as=1.248p ps=5.32u w=4.8u l=0.4u
X372 VDD xl2.d2a xl2.d2b VDD pfet_03v3 ad=0.481p pd=2.37u as=0.481p ps=2.37u w=1.85u l=0.28u
X373 xl2.d2a VSS VSS VSS nfet_03v3 ad=1.1362p pd=4.89u as=1.9228p ps=9.62u w=4.37u l=0.5u
X374 VDD xl2.d2b xl2.d2a VDD pfet_03v3 ad=0.481p pd=2.37u as=0.481p ps=2.37u w=1.85u l=0.28u
X375 VDD VDD VDD VDD pfet_03v3 ad=0.52p pd=2.52u as=0 ps=0 w=2u l=0.5u
X376 VDD EN xl0.d2a VDD pfet_03v3 ad=0.52p pd=2.52u as=0.52p ps=2.52u w=2u l=0.5u
X377 xl0.xout.n3a xl0.d2a VDD VDD pfet_03v3 ad=0.481p pd=2.37u as=0.481p ps=2.37u w=1.85u l=0.28u
X378 xbias.nrb xbias.enb VDD VDD pfet_03v3 ad=1.3p pd=5.52u as=1.3p ps=5.52u w=5u l=0.5u
X379 xl2.xpre.tn vref xl2.oa VSS nfet_03v3 ad=1.235p pd=5.27u as=1.235p ps=5.27u w=4.75u l=0.5u
X380 VDD vbp xl0.xpre.tp VDD pfet_03v3 ad=1.3p pd=5.52u as=1.3p ps=5.52u w=5u l=1u
X381 xl1.xpre.fb vref xl1.xpre.tp xl1.xpre.tp pfet_03v3 ad=1.248p pd=5.32u as=1.248p ps=5.32u w=4.8u l=0.4u
X382 VSS vbn xl1.xhyst.ts VSS nfet_03v3 ad=0.65p pd=3.02u as=0.65p ps=3.02u w=2.5u l=1u
X383 VSS xl2.xout.i1 xl2.xout.i2 VSS nfet_03v3 ad=0.78p pd=3.52u as=0.78p ps=3.52u w=3u l=0.28u
X384 VSS xl2.xout.i2 RX2_O VSS nfet_03v3 ad=1.04p pd=4.52u as=1.04p ps=4.52u w=4u l=0.28u
X385 VSS VSS VSS ppolyf_u_1k r_width=2u r_length=9.11u
X386 xl2.xpre.tp vbp VDD VDD pfet_03v3 ad=1.3p pd=5.52u as=1.3p ps=5.52u w=5u l=1u
X387 xl1.xpre.tn xl1.gn xl1.ob VSS nfet_03v3 ad=1.235p pd=5.27u as=1.235p ps=5.27u w=4.75u l=0.5u
X388 xl2.d2a VDD VDD VDD pfet_03v3 ad=0.52p pd=2.52u as=0.88p ps=4.88u w=2u l=0.5u
X389 xl0.xpre.tp xl0.gn xl0.xpre.fb xl0.xpre.tp pfet_03v3 ad=1.248p pd=5.32u as=1.248p ps=5.32u w=4.8u l=0.4u
X390 xl2.xpre.fb xl2.gn xl2.xpre.tp xl2.xpre.tp pfet_03v3 ad=1.248p pd=5.32u as=1.248p ps=5.32u w=4.8u l=0.4u
X391 xl2.xpre.fa vbn VSS VSS nfet_03v3 ad=0.65p pd=3.02u as=0.65p ps=3.02u w=2.5u l=1u
X392 xbias.nrb xbias.enb VDD VDD pfet_03v3 ad=1.3p pd=5.52u as=1.3p ps=5.52u w=5u l=0.5u
X393 RX0_O xl0.xout.i2 VDD VDD pfet_03v3 ad=1.3p pd=5.52u as=1.3p ps=5.52u w=5u l=0.28u
X394 xl2.xpre.tn vref xl2.ob VSS nfet_03v3 ad=1.235p pd=5.27u as=1.235p ps=5.27u w=4.75u l=0.5u
X395 xl1.xpre.fa vref xl1.xpre.tp xl1.xpre.tp pfet_03v3 ad=1.248p pd=5.32u as=1.248p ps=5.32u w=4.8u l=0.4u
X396 xl2.xpre.tp xl2.gp xl2.xpre.fa xl2.xpre.tp pfet_03v3 ad=1.248p pd=5.32u as=1.248p ps=5.32u w=4.8u l=0.4u
X397 xl0.xpre.fb vbn VSS VSS nfet_03v3 ad=0.65p pd=3.02u as=0.65p ps=3.02u w=2.5u l=1u
X398 xl0.d2b VDD VDD VDD pfet_03v3 ad=0.52p pd=2.52u as=0.88p ps=4.88u w=2u l=0.5u
X399 xl1.xpre.tn xl1.gp xl1.oa VSS nfet_03v3 ad=1.235p pd=5.27u as=1.235p ps=5.27u w=4.75u l=0.5u
X400 xl2.xout.d3 xl2.d2b VDD VDD pfet_03v3 ad=0.481p pd=2.37u as=0.481p ps=2.37u w=1.85u l=0.28u
X401 VSS VSS xl1.xpre.fa VSS nfet_03v3 ad=1.9888p pd=9.92u as=1.1752p ps=5.04u w=4.52u l=0.5u
X402 VDD xl1.xout.nd xl1.xout.i1 VDD pfet_03v3 ad=0.962p pd=4.22u as=0.962p ps=4.22u w=3.7u l=0.28u
X403 VDD vbp xl1.xpre.tp VDD pfet_03v3 ad=1.3p pd=5.52u as=1.3p ps=5.52u w=5u l=1u
D4 xl1.gn VDD diode_pd2nw_03v3 pj=26u area=40p
X404 xl0.xpre.fb xl0.gn xl0.xpre.tp xl0.xpre.tp pfet_03v3 ad=1.248p pd=5.32u as=1.248p ps=5.32u w=4.8u l=0.4u
X405 xl0.oa vref xl0.xpre.tn VSS nfet_03v3 ad=1.235p pd=5.27u as=1.235p ps=5.27u w=4.75u l=0.5u
X406 xl1.xpre.tp vref xl1.xpre.fb xl1.xpre.tp pfet_03v3 ad=1.248p pd=5.32u as=1.248p ps=5.32u w=4.8u l=0.4u
X407 VSS vbn xl2.xpre.fa VSS nfet_03v3 ad=0.65p pd=3.02u as=0.65p ps=3.02u w=2.5u l=1u
X408 VSS VSS xl2.xpre.tn VSS nfet_03v3 ad=1.1p pd=5.88u as=0.65p ps=3.02u w=2.5u l=1u
X409 RX2_O xl2.xout.i2 VDD VDD pfet_03v3 ad=1.3p pd=5.52u as=1.3p ps=5.52u w=5u l=0.28u
X410 xl2.gn RX2_N VDD ppolyf_u r_width=5u r_length=1.8u
X411 xl1.xpre.fa xl1.gp xl1.xpre.tp xl1.xpre.tp pfet_03v3 ad=1.248p pd=5.32u as=1.248p ps=5.32u w=4.8u l=0.4u
X412 xl1.oa vb2 xl1.xpre.fa VSS nfet_03v3 ad=1.1752p pd=5.04u as=1.1752p ps=5.04u w=4.52u l=0.5u
X413 xl0.xout.i2 VSS VSS VSS nfet_03v3 ad=0.78p pd=3.52u as=1.32p ps=6.88u w=3u l=0.28u
X414 VSS vbn xl2.xpre.fb VSS nfet_03v3 ad=0.65p pd=3.02u as=0.65p ps=3.02u w=2.5u l=1u
X415 RX0_O VSS VSS VSS nfet_03v3 ad=1.04p pd=4.52u as=1.76p ps=8.88u w=4u l=0.28u
X416 xl0.xpre.fb vref xl0.xpre.tp xl0.xpre.tp pfet_03v3 ad=1.248p pd=5.32u as=1.248p ps=5.32u w=4.8u l=0.4u
X417 xl2.ob xl2.gn xl2.xpre.tn VSS nfet_03v3 ad=1.235p pd=5.27u as=1.235p ps=5.27u w=4.75u l=0.5u
X418 VSS VSS VSS VSS nfet_03v3 ad=0.39p pd=2.02u as=0 ps=0 w=1.5u l=0.28u
X419 xl2.xpre.tp xl2.gn xl2.xpre.fb xl2.xpre.tp pfet_03v3 ad=1.248p pd=5.32u as=1.248p ps=5.32u w=4.8u l=0.4u
X420 xl0.xout.i2 VDD VDD VDD pfet_03v3 ad=0.975p pd=4.27u as=1.65p ps=8.38u w=3.75u l=0.28u
X421 xl1.xpre.tp xl1.gp xl1.xpre.fa xl1.xpre.tp pfet_03v3 ad=1.248p pd=5.32u as=1.248p ps=5.32u w=4.8u l=0.4u
X422 VSS VSS VSS VSS nfet_03v3 ad=0.78p pd=3.52u as=0 ps=0 w=3u l=0.28u
X423 xl2.xout.i1 VDD VDD VDD pfet_03v3 ad=0.962p pd=4.22u as=1.628p ps=8.28u w=3.7u l=0.28u
D5 VSS xl1.gn diode_nd2ps_03v3 pj=26u area=40p
X424 xl2.xout.i2 VSS VSS VSS nfet_03v3 ad=0.78p pd=3.52u as=1.32p ps=6.88u w=3u l=0.28u
X425 RX2_O VSS VSS VSS nfet_03v3 ad=1.04p pd=4.52u as=1.76p ps=8.88u w=4u l=0.28u
X426 vbp vbn VSS VSS nfet_03v3 ad=0.65p pd=3.02u as=0.65p ps=3.02u w=2.5u l=1u
X427 VDD xl0.xout.i2 RX0_O VDD pfet_03v3 ad=1.3p pd=5.52u as=1.3p ps=5.52u w=5u l=0.28u
X428 xl2.xpre.tp vbp VDD VDD pfet_03v3 ad=1.3p pd=5.52u as=1.3p ps=5.52u w=5u l=1u
X429 xl0.xpre.fb xl0.gn xl0.xpre.tp xl0.xpre.tp pfet_03v3 ad=1.248p pd=5.32u as=1.248p ps=5.32u w=4.8u l=0.4u
X430 xl2.xpre.fb vbn VSS VSS nfet_03v3 ad=0.65p pd=3.02u as=0.65p ps=3.02u w=2.5u l=1u
X431 xl2.oa vref xl2.xpre.tn VSS nfet_03v3 ad=1.235p pd=5.27u as=1.235p ps=5.27u w=4.75u l=0.5u
X432 VDD VDD xl0.xpre.tp VDD pfet_03v3 ad=2.2p pd=10.88u as=1.3p ps=5.52u w=5u l=1u
X433 xl0.xpre.tp vref xl0.xpre.fa xl0.xpre.tp pfet_03v3 ad=1.248p pd=5.32u as=1.248p ps=5.32u w=4.8u l=0.4u
X434 VSS vbn xl1.xpre.fa VSS nfet_03v3 ad=0.65p pd=3.02u as=0.65p ps=3.02u w=2.5u l=1u
X435 xl2.xpre.fb xl2.gn xl2.xpre.tp xl2.xpre.tp pfet_03v3 ad=1.248p pd=5.32u as=1.248p ps=5.32u w=4.8u l=0.4u
X436 VSS VSS VSS VSS nfet_03v3 ad=0.78p pd=3.52u as=0 ps=0 w=3u l=0.28u
X437 xl2.xpre.fb vref xl2.xpre.tp xl2.xpre.tp pfet_03v3 ad=1.248p pd=5.32u as=1.248p ps=5.32u w=4.8u l=0.4u
X438 xl2.ob xl2.gn xl2.xpre.tn VSS nfet_03v3 ad=1.235p pd=5.27u as=1.235p ps=5.27u w=4.75u l=0.5u
X439 vbp vbp VDD VDD pfet_03v3 ad=1.3p pd=5.52u as=1.3p ps=5.52u w=5u l=1u
X440 xl0.xpre.tp vref xl0.xpre.fa xl0.xpre.tp pfet_03v3 ad=1.248p pd=5.32u as=1.248p ps=5.32u w=4.8u l=0.4u
X441 xl2.xpre.tp vbp VDD VDD pfet_03v3 ad=1.3p pd=5.52u as=1.3p ps=5.52u w=5u l=1u
X442 xl1.xpre.fb xl1.gn xl1.xpre.tp xl1.xpre.tp pfet_03v3 ad=1.248p pd=5.32u as=1.248p ps=5.32u w=4.8u l=0.4u
X443 VDD xl2.xout.i2 RX2_O VDD pfet_03v3 ad=1.3p pd=5.52u as=1.3p ps=5.52u w=5u l=0.28u
X444 VSS vbn xl2.xpre.tn VSS nfet_03v3 ad=0.65p pd=3.02u as=0.65p ps=3.02u w=2.5u l=1u
X445 xl2.oa xl2.gp xl2.xpre.tn VSS nfet_03v3 ad=1.235p pd=5.27u as=1.235p ps=5.27u w=4.75u l=0.5u
X446 xl0.xpre.fa vref xl0.xpre.tp xl0.xpre.tp pfet_03v3 ad=1.248p pd=5.32u as=1.248p ps=5.32u w=4.8u l=0.4u
X447 xl1.xpre.tp xl1.gp xl1.xpre.fa xl1.xpre.tp pfet_03v3 ad=1.248p pd=5.32u as=1.248p ps=5.32u w=4.8u l=0.4u
X448 xl1.xpre.tp xl1.gp xl1.xpre.fa xl1.xpre.tp pfet_03v3 ad=1.248p pd=5.32u as=1.248p ps=5.32u w=4.8u l=0.4u
X449 xl2.xpre.tp vref xl2.xpre.fa xl2.xpre.tp pfet_03v3 ad=1.248p pd=5.32u as=1.248p ps=5.32u w=4.8u l=0.4u
X450 xl2.d2b VSS VSS VSS nfet_03v3 ad=1.1362p pd=4.89u as=1.9228p ps=9.62u w=4.37u l=0.5u
X451 xl0.xpre.tn xl0.gp xl0.oa VSS nfet_03v3 ad=1.235p pd=5.27u as=1.235p ps=5.27u w=4.75u l=0.5u
X452 xl0.xpre.tp xl0.gn xl0.xpre.fb xl0.xpre.tp pfet_03v3 ad=1.248p pd=5.32u as=1.248p ps=5.32u w=4.8u l=0.4u
X453 xl1.xpre.fa xl1.gp xl1.xpre.tp xl1.xpre.tp pfet_03v3 ad=1.248p pd=5.32u as=1.248p ps=5.32u w=4.8u l=0.4u
X454 xbias.nmid xbias.rdb_m3 VSS ppolyf_u_1k r_width=2u r_length=19.26u
X455 xl0.xhyst.sa xl0.oa xl0.d2a VSS nfet_03v3 ad=1.1362p pd=4.89u as=1.1362p ps=4.89u w=4.37u l=0.5u
X456 VSS VSS xl1.xhyst.ts VSS nfet_03v3 ad=1.1p pd=5.88u as=0.65p ps=3.02u w=2.5u l=1u
X457 VSS VSS VSS ppolyf_u_1k r_width=2u r_length=22.27u
X458 xl0.xout.n3a xl0.d2a VDD VDD pfet_03v3 ad=0.481p pd=2.37u as=0.481p ps=2.37u w=1.85u l=0.28u
X459 xl0.xpre.tn xl0.gp xl0.oa VSS nfet_03v3 ad=1.235p pd=5.27u as=1.235p ps=5.27u w=4.75u l=0.5u
X460 VDD EN xl1.d2b VDD pfet_03v3 ad=0.52p pd=2.52u as=0.52p ps=2.52u w=2u l=0.5u
X461 VDD xl1.d2a xl1.d2b VDD pfet_03v3 ad=0.481p pd=2.37u as=0.481p ps=2.37u w=1.85u l=0.28u
X462 VDD vbp xl2.xpre.tp VDD pfet_03v3 ad=1.3p pd=5.52u as=1.3p ps=5.52u w=5u l=1u
X463 xl0.xpre.fa xl0.gp xl0.xpre.tp xl0.xpre.tp pfet_03v3 ad=1.248p pd=5.32u as=1.248p ps=5.32u w=4.8u l=0.4u
X464 VSS VSS xl0.xpre.fa VSS nfet_03v3 ad=1.1p pd=5.88u as=0.65p ps=3.02u w=2.5u l=1u
X465 xl2.xpre.fb vb2 xl2.ob VSS nfet_03v3 ad=1.1752p pd=5.04u as=1.1752p ps=5.04u w=4.52u l=0.5u
X466 xl1.xout.i2 xl1.xout.i1 VDD VDD pfet_03v3 ad=0.975p pd=4.27u as=0.975p ps=4.27u w=3.75u l=0.28u
X467 xl1.xpre.tp vref xl1.xpre.fb xl1.xpre.tp pfet_03v3 ad=1.248p pd=5.32u as=1.248p ps=5.32u w=4.8u l=0.4u
X468 xl0.xpre.tn xl0.gn xl0.ob VSS nfet_03v3 ad=1.235p pd=5.27u as=1.235p ps=5.27u w=4.75u l=0.5u
X469 VDD vbp xl0.xpre.tp VDD pfet_03v3 ad=1.3p pd=5.52u as=1.3p ps=5.52u w=5u l=1u
X470 xl2.xpre.fa xl2.gp xl2.xpre.tp xl2.xpre.tp pfet_03v3 ad=1.248p pd=5.32u as=1.248p ps=5.32u w=4.8u l=0.4u
X471 xl0.oa vb2 xl0.xpre.fa VSS nfet_03v3 ad=1.1752p pd=5.04u as=1.1752p ps=5.04u w=4.52u l=0.5u
X472 VSS VSS xl0.xpre.fb VSS nfet_03v3 ad=1.9888p pd=9.92u as=1.1752p ps=5.04u w=4.52u l=0.5u
X473 VDD xl0.xout.d3 xl0.xout.nd VDD pfet_03v3 ad=0.78p pd=3.52u as=0.78p ps=3.52u w=3u l=0.28u
X474 xl2.xpre.tp vref xl2.xpre.fa xl2.xpre.tp pfet_03v3 ad=1.248p pd=5.32u as=1.248p ps=5.32u w=4.8u l=0.4u
X475 xl2.xout.d3 xl2.d2b VDD VDD pfet_03v3 ad=0.481p pd=2.37u as=0.481p ps=2.37u w=1.85u l=0.28u
X476 xl2.oa xl2.rla_m1 VSS ppolyf_u_1k r_width=2u r_length=9.11u
X477 xl2.xhyst.ts vbn VSS VSS nfet_03v3 ad=0.65p pd=3.02u as=0.65p ps=3.02u w=2.5u l=1u
X478 xl2.xpre.tn vref xl2.ob VSS nfet_03v3 ad=1.235p pd=5.27u as=2.09p ps=10.38u w=4.75u l=0.5u
X479 xl2.xpre.tn vref xl2.oa VSS nfet_03v3 ad=1.235p pd=5.27u as=1.235p ps=5.27u w=4.75u l=0.5u
X480 xl0.oa VSS VSS VSS nfet_03v3 ad=1.1752p pd=5.04u as=1.9888p ps=9.92u w=4.52u l=0.5u
X481 xbias.rb_m1 xbias.nrb VSS ppolyf_u_1k r_width=2u r_length=22.27u
X482 xl0.d2a xl0.d2b VDD VDD pfet_03v3 ad=0.481p pd=2.37u as=0.481p ps=2.37u w=1.85u l=0.28u
X483 xl2.xpre.tp vref xl2.xpre.fb xl2.xpre.tp pfet_03v3 ad=1.248p pd=5.32u as=1.248p ps=5.32u w=4.8u l=0.4u
X484 xl2.xpre.tp VDD VDD VDD pfet_03v3 ad=1.3p pd=5.52u as=2.2p ps=10.88u w=5u l=1u
X485 xl0.xhyst.ts vbn VSS VSS nfet_03v3 ad=0.65p pd=3.02u as=0.65p ps=3.02u w=2.5u l=1u
X486 xl0.xpre.tp xl0.gn xl0.xpre.fb xl0.xpre.tp pfet_03v3 ad=1.248p pd=5.32u as=1.248p ps=5.32u w=4.8u l=0.4u
X487 xl1.oa xl1.gp xl1.xpre.tn VSS nfet_03v3 ad=1.235p pd=5.27u as=1.235p ps=5.27u w=4.75u l=0.5u
X488 VSS VSS xl0.xout.d3 VSS nfet_03v3 ad=2.0504p pd=10.2u as=1.2116p ps=5.18u w=4.66u l=0.28u
X489 VDD vbp vbp VDD pfet_03v3 ad=1.3p pd=5.52u as=1.3p ps=5.52u w=5u l=1u
X490 xl2.xpre.fa vref xl2.xpre.tp xl2.xpre.tp pfet_03v3 ad=1.248p pd=5.32u as=1.248p ps=5.32u w=4.8u l=0.4u
X491 VSS xl1.xout.n3a xl1.xout.n3a VSS nfet_03v3 ad=1.2116p pd=5.18u as=1.2116p ps=5.18u w=4.66u l=0.28u
X492 VDD vbp xl1.xpre.tp VDD pfet_03v3 ad=1.3p pd=5.52u as=1.3p ps=5.52u w=5u l=1u
X493 xl1.xpre.fb vref xl1.xpre.tp xl1.xpre.tp pfet_03v3 ad=1.248p pd=5.32u as=1.248p ps=5.32u w=4.8u l=0.4u
X494 xl1.xpre.tp vref xl1.xpre.fb xl1.xpre.tp pfet_03v3 ad=1.248p pd=5.32u as=1.248p ps=5.32u w=4.8u l=0.4u
X495 xl1.ob vref xl1.xpre.tn VSS nfet_03v3 ad=1.235p pd=5.27u as=1.235p ps=5.27u w=4.75u l=0.5u
X496 VSS vbn vbn VSS nfet_03v3 ad=0.65p pd=3.02u as=0.65p ps=3.02u w=2.5u l=1u
X497 xl0.xpre.fa xl0.gp xl0.xpre.tp xl0.xpre.tp pfet_03v3 ad=1.248p pd=5.32u as=1.248p ps=5.32u w=4.8u l=0.4u
X498 xl2.xpre.tp xl2.gn xl2.xpre.fb xl2.xpre.tp pfet_03v3 ad=1.248p pd=5.32u as=1.248p ps=5.32u w=4.8u l=0.4u
X499 xl0.xpre.fa vbn VSS VSS nfet_03v3 ad=0.65p pd=3.02u as=0.65p ps=3.02u w=2.5u l=1u
X500 xl1.xout.nd VDD VDD VDD pfet_03v3 ad=0.78p pd=3.52u as=1.32p ps=6.88u w=3u l=0.28u
X501 VDD xl0.d2a xl0.d2a VDD pfet_03v3 ad=0.481p pd=2.37u as=0.481p ps=2.37u w=1.85u l=0.28u
X502 VSS VSS VSS VSS nfet_03v3 ad=0.39p pd=2.02u as=0 ps=0 w=1.5u l=0.28u
X503 VDD xl1.d2a xl1.xout.n3a VDD pfet_03v3 ad=0.481p pd=2.37u as=0.481p ps=2.37u w=1.85u l=0.28u
X504 xl0.xpre.tp vbp VDD VDD pfet_03v3 ad=1.3p pd=5.52u as=1.3p ps=5.52u w=5u l=1u
X505 xl1.xpre.fa vbn VSS VSS nfet_03v3 ad=0.65p pd=3.02u as=0.65p ps=3.02u w=2.5u l=1u
X506 xbias.nrb xbias.enb VDD VDD pfet_03v3 ad=1.3p pd=5.52u as=1.3p ps=5.52u w=5u l=0.5u
X507 VDD xl0.d2a xl0.d2b VDD pfet_03v3 ad=0.481p pd=2.37u as=0.481p ps=2.37u w=1.85u l=0.28u
X508 xl2.xpre.tn vref xl2.oa VSS nfet_03v3 ad=1.235p pd=5.27u as=1.235p ps=5.27u w=4.75u l=0.5u
X509 xl1.xpre.tp vbp VDD VDD pfet_03v3 ad=1.3p pd=5.52u as=1.3p ps=5.52u w=5u l=1u
X510 xl0.xpre.fa vref xl0.xpre.tp xl0.xpre.tp pfet_03v3 ad=1.248p pd=5.32u as=1.248p ps=5.32u w=4.8u l=0.4u
X511 xl1.xpre.fa vref xl1.xpre.tp xl1.xpre.tp pfet_03v3 ad=1.248p pd=5.32u as=1.248p ps=5.32u w=4.8u l=0.4u
X512 xl1.xpre.tp xl1.gp xl1.xpre.fa xl1.xpre.tp pfet_03v3 ad=1.248p pd=5.32u as=1.248p ps=5.32u w=4.8u l=0.4u
X513 xl1.xpre.fb vbn VSS VSS nfet_03v3 ad=0.65p pd=3.02u as=0.65p ps=3.02u w=2.5u l=1u
X514 VSS vbn xl0.xpre.tn VSS nfet_03v3 ad=0.65p pd=3.02u as=0.65p ps=3.02u w=2.5u l=1u
X515 xl2.xhyst.ts VSS VSS VSS nfet_03v3 ad=0.65p pd=3.02u as=1.1p ps=5.88u w=2.5u l=1u
X516 VDD vbp vbp VDD pfet_03v3 ad=1.3p pd=5.52u as=1.3p ps=5.52u w=5u l=1u
X517 xl0.ob vref xl0.xpre.tn VSS nfet_03v3 ad=2.09p pd=10.38u as=1.235p ps=5.27u w=4.75u l=0.5u
X518 xl1.xpre.tn xl1.gn xl1.ob VSS nfet_03v3 ad=1.235p pd=5.27u as=1.235p ps=5.27u w=4.75u l=0.5u
X519 VDD vbp xl2.xpre.tp VDD pfet_03v3 ad=1.3p pd=5.52u as=1.3p ps=5.52u w=5u l=1u
X520 VSS vbn xl0.xhyst.ts VSS nfet_03v3 ad=0.65p pd=3.02u as=0.65p ps=3.02u w=2.5u l=1u
X521 xl2.xout.n3a xl2.d2a VDD VDD pfet_03v3 ad=0.481p pd=2.37u as=0.481p ps=2.37u w=1.85u l=0.28u
X522 xbias.rb_m1 xbias.rb_m2 VSS ppolyf_u_1k r_width=2u r_length=22.27u
X523 xl1.xpre.fa vref xl1.xpre.tp xl1.xpre.tp pfet_03v3 ad=1.248p pd=5.32u as=1.248p ps=5.32u w=4.8u l=0.4u
X524 xl1.oa vb2 xl1.xpre.fa VSS nfet_03v3 ad=1.1752p pd=5.04u as=1.1752p ps=5.04u w=4.52u l=0.5u
X525 VDD xl2.d2a xl2.d2a VDD pfet_03v3 ad=0.481p pd=2.37u as=0.481p ps=2.37u w=1.85u l=0.28u
X526 xl0.xout.n3a VDD VDD VDD pfet_03v3 ad=0.481p pd=2.37u as=0.814p ps=4.58u w=1.85u l=0.28u
X527 VDD VDD xl1.xout.nd VDD pfet_03v3 ad=1.32p pd=6.88u as=0.78p ps=3.52u w=3u l=0.28u
X528 xl0.xpre.fb xl0.gn xl0.xpre.tp xl0.xpre.tp pfet_03v3 ad=1.248p pd=5.32u as=1.248p ps=5.32u w=4.8u l=0.4u
X529 xl2.xpre.tp xl2.gp xl2.xpre.fa xl2.xpre.tp pfet_03v3 ad=1.248p pd=5.32u as=1.248p ps=5.32u w=4.8u l=0.4u
X530 VSS vbn xl0.xpre.fa VSS nfet_03v3 ad=0.65p pd=3.02u as=0.65p ps=3.02u w=2.5u l=1u
X531 xl0.xhyst.ts vbn VSS VSS nfet_03v3 ad=0.65p pd=3.02u as=0.65p ps=3.02u w=2.5u l=1u
X532 xl2.d2a xl2.d2a VDD VDD pfet_03v3 ad=0.481p pd=2.37u as=0.481p ps=2.37u w=1.85u l=0.28u
X533 xl1.xhyst.ts xl1.xhyst.sa VSS ppolyf_u_1k r_width=5u r_length=1.64u
X534 VSS VSS VSS ppolyf_u_1k r_width=5u r_length=1.64u
X535 xl1.xpre.fa vref xl1.xpre.tp xl1.xpre.tp pfet_03v3 ad=1.248p pd=5.32u as=1.248p ps=5.32u w=4.8u l=0.4u
X536 xl2.xpre.fa xl2.gp xl2.xpre.tp xl2.xpre.tp pfet_03v3 ad=1.248p pd=5.32u as=1.248p ps=5.32u w=4.8u l=0.4u
X537 VSS vbn xl1.xpre.fb VSS nfet_03v3 ad=0.65p pd=3.02u as=0.65p ps=3.02u w=2.5u l=1u
X538 VDD xl0.d2a xl0.xout.n3a VDD pfet_03v3 ad=0.481p pd=2.37u as=0.481p ps=2.37u w=1.85u l=0.28u
X539 xl0.xpre.fb vref xl0.xpre.tp xl0.xpre.tp pfet_03v3 ad=2.112p pd=10.48u as=1.248p ps=5.32u w=4.8u l=0.4u
X540 xl2.xpre.fa xl2.gp xl2.xpre.tp xl2.xpre.tp pfet_03v3 ad=1.248p pd=5.32u as=1.248p ps=5.32u w=4.8u l=0.4u
X541 xl2.xpre.tp xl2.gn xl2.xpre.fb xl2.xpre.tp pfet_03v3 ad=1.248p pd=5.32u as=1.248p ps=5.32u w=4.8u l=0.4u
X542 xl0.oa xl0.gp xl0.xpre.tn VSS nfet_03v3 ad=1.235p pd=5.27u as=1.235p ps=5.27u w=4.75u l=0.5u
X543 xl1.xpre.tn vref xl1.oa VSS nfet_03v3 ad=1.235p pd=5.27u as=1.235p ps=5.27u w=4.75u l=0.5u
X544 VDD vbp xl1.xpre.tp VDD pfet_03v3 ad=1.3p pd=5.52u as=1.3p ps=5.52u w=5u l=1u
X545 xl0.xpre.fb vref xl0.xpre.tp xl0.xpre.tp pfet_03v3 ad=1.248p pd=5.32u as=1.248p ps=5.32u w=4.8u l=0.4u
X546 xl0.ob xl0.gn xl0.xpre.tn VSS nfet_03v3 ad=1.235p pd=5.27u as=1.235p ps=5.27u w=4.75u l=0.5u
X547 xl0.xpre.tn vbn VSS VSS nfet_03v3 ad=0.65p pd=3.02u as=0.65p ps=3.02u w=2.5u l=1u
X548 VSS VSS xl0.d2b VSS nfet_03v3 ad=1.9228p pd=9.62u as=1.1362p ps=4.89u w=4.37u l=0.5u
X549 VSS vbn xl2.xhyst.ts VSS nfet_03v3 ad=0.65p pd=3.02u as=0.65p ps=3.02u w=2.5u l=1u
X550 xl0.xpre.tp vbp VDD VDD pfet_03v3 ad=1.3p pd=5.52u as=1.3p ps=5.52u w=5u l=1u
X551 xl1.xpre.fa VSS VSS VSS nfet_03v3 ad=0.65p pd=3.02u as=1.1p ps=5.88u w=2.5u l=1u
X552 xl1.xpre.fb vb2 xl1.ob VSS nfet_03v3 ad=1.1752p pd=5.04u as=1.1752p ps=5.04u w=4.52u l=0.5u
X553 xl2.xout.nd EN VDD VDD pfet_03v3 ad=0.78p pd=3.52u as=0.78p ps=3.52u w=3u l=0.28u
X554 xl2.xpre.fa xl2.gp xl2.xpre.tp xl2.xpre.tp pfet_03v3 ad=1.248p pd=5.32u as=1.248p ps=5.32u w=4.8u l=0.4u
X555 xl1.xpre.tn vbn VSS VSS nfet_03v3 ad=0.65p pd=3.02u as=0.65p ps=3.02u w=2.5u l=1u
X556 VDD xl2.d2b xl2.xout.d3 VDD pfet_03v3 ad=0.481p pd=2.37u as=0.481p ps=2.37u w=1.85u l=0.28u
X557 xl1.gp RX1_P VDD ppolyf_u r_width=5u r_length=1.8u
X558 xl0.xpre.fb xl0.gn xl0.xpre.tp xl0.xpre.tp pfet_03v3 ad=1.248p pd=5.32u as=1.248p ps=5.32u w=4.8u l=0.4u
X559 xl0.ob vref xl0.xpre.tn VSS nfet_03v3 ad=1.235p pd=5.27u as=1.235p ps=5.27u w=4.75u l=0.5u
X560 VSS vbn xl0.xhyst.ts VSS nfet_03v3 ad=0.65p pd=3.02u as=0.65p ps=3.02u w=2.5u l=1u
X561 xl1.d2a VSS VSS VSS nfet_03v3 ad=1.1362p pd=4.89u as=1.9228p ps=9.62u w=4.37u l=0.5u
X562 xl2.ob xl2.gn xl2.xpre.tn VSS nfet_03v3 ad=1.235p pd=5.27u as=1.235p ps=5.27u w=4.75u l=0.5u
X563 xl2.xout.i1 VSS VSS VSS nfet_03v3 ad=0.39p pd=2.02u as=0.66p ps=3.88u w=1.5u l=0.28u
X564 xl1.xpre.tp vbp VDD VDD pfet_03v3 ad=1.3p pd=5.52u as=1.3p ps=5.52u w=5u l=1u
X565 VDD xl1.d2b xl1.d2a VDD pfet_03v3 ad=0.481p pd=2.37u as=0.481p ps=2.37u w=1.85u l=0.28u
X566 VDD VDD VDD VDD pfet_03v3 ad=0.52p pd=2.52u as=0 ps=0 w=2u l=0.5u
X567 xl0.xout.n3a VSS VSS VSS nfet_03v3 ad=1.2116p pd=5.18u as=2.0504p ps=10.2u w=4.66u l=0.28u
X568 xl2.ob xl2.gn xl2.xpre.tn VSS nfet_03v3 ad=1.235p pd=5.27u as=1.235p ps=5.27u w=4.75u l=0.5u
X569 VSS xbias.enb vbn VSS nfet_03v3 ad=0.52p pd=2.52u as=0.52p ps=2.52u w=2u l=0.5u
X570 VSS vbn xl0.xhyst.ts VSS nfet_03v3 ad=0.65p pd=3.02u as=0.65p ps=3.02u w=2.5u l=1u
X571 VSS VSS VSS ppolyf_u_1k r_width=2u r_length=9.11u
X572 xl0.xpre.fb vref xl0.xpre.tp xl0.xpre.tp pfet_03v3 ad=1.248p pd=5.32u as=1.248p ps=5.32u w=4.8u l=0.4u
X573 xl1.xpre.fb vref xl1.xpre.tp xl1.xpre.tp pfet_03v3 ad=1.248p pd=5.32u as=1.248p ps=5.32u w=4.8u l=0.4u
X574 xl0.xpre.tn xl0.gn xl0.ob VSS nfet_03v3 ad=1.235p pd=5.27u as=1.235p ps=5.27u w=4.75u l=0.5u
X575 VSS VSS VSS VSS nfet_03v3 ad=0.52p pd=2.52u as=0 ps=0 w=2u l=0.28u
X576 xl1.d2a VDD VDD VDD pfet_03v3 ad=0.52p pd=2.52u as=0.88p ps=4.88u w=2u l=0.5u
X577 xl1.xpre.fa vbn VSS VSS nfet_03v3 ad=0.65p pd=3.02u as=0.65p ps=3.02u w=2.5u l=1u
X578 xl2.xpre.fa vbn VSS VSS nfet_03v3 ad=0.65p pd=3.02u as=0.65p ps=3.02u w=2.5u l=1u
X579 xl0.xpre.fa vref xl0.xpre.tp xl0.xpre.tp pfet_03v3 ad=1.248p pd=5.32u as=1.248p ps=5.32u w=4.8u l=0.4u
X580 VSS vbn xl1.xhyst.ts VSS nfet_03v3 ad=0.65p pd=3.02u as=0.65p ps=3.02u w=2.5u l=1u
X581 xl2.oa xl2.gp xl2.xpre.tn VSS nfet_03v3 ad=1.235p pd=5.27u as=1.235p ps=5.27u w=4.75u l=0.5u
X582 xl1.xpre.tp xl1.gp xl1.xpre.fa xl1.xpre.tp pfet_03v3 ad=1.248p pd=5.32u as=1.248p ps=5.32u w=4.8u l=0.4u
X583 xl2.xpre.tp xl2.gp xl2.xpre.fa xl2.xpre.tp pfet_03v3 ad=1.248p pd=5.32u as=1.248p ps=5.32u w=4.8u l=0.4u
X584 xl0.xpre.tn xl0.gp xl0.oa VSS nfet_03v3 ad=1.235p pd=5.27u as=1.235p ps=5.27u w=4.75u l=0.5u
X585 xl1.xout.d3 xl1.d2b VDD VDD pfet_03v3 ad=0.481p pd=2.37u as=0.481p ps=2.37u w=1.85u l=0.28u
X586 VSS VSS xl0.xpre.fa VSS nfet_03v3 ad=1.9888p pd=9.92u as=1.1752p ps=5.04u w=4.52u l=0.5u
X587 VDD xl0.xout.nd xl0.xout.i1 VDD pfet_03v3 ad=0.962p pd=4.22u as=0.962p ps=4.22u w=3.7u l=0.28u
X588 xl2.d2b xl2.d2a VDD VDD pfet_03v3 ad=0.481p pd=2.37u as=0.481p ps=2.37u w=1.85u l=0.28u
X589 VDD vbp xl0.xpre.tp VDD pfet_03v3 ad=1.3p pd=5.52u as=1.3p ps=5.52u w=5u l=1u
D6 xl0.gn VDD diode_pd2nw_03v3 pj=26u area=40p
X590 xbias.rdt_m2 xbias.rdt_m1 VSS ppolyf_u_1k r_width=2u r_length=21.01u
X591 xl0.xpre.tp vref xl0.xpre.fb xl0.xpre.tp pfet_03v3 ad=1.248p pd=5.32u as=1.248p ps=5.32u w=4.8u l=0.4u
X592 VSS vbn xl1.xpre.fa VSS nfet_03v3 ad=0.65p pd=3.02u as=0.65p ps=3.02u w=2.5u l=1u
X593 xl2.xpre.fa vb2 xl2.oa VSS nfet_03v3 ad=1.1752p pd=5.04u as=1.1752p ps=5.04u w=4.52u l=0.5u
X594 VDD VDD xl2.xout.i2 VDD pfet_03v3 ad=1.65p pd=8.38u as=0.975p ps=4.27u w=3.75u l=0.28u
X595 xl0.xpre.fa xl0.gp xl0.xpre.tp xl0.xpre.tp pfet_03v3 ad=1.248p pd=5.32u as=1.248p ps=5.32u w=4.8u l=0.4u
X596 xl0.oa vb2 xl0.xpre.fa VSS nfet_03v3 ad=1.1752p pd=5.04u as=1.1752p ps=5.04u w=4.52u l=0.5u
X597 VSS VSS xl1.xpre.tn VSS nfet_03v3 ad=1.1p pd=5.88u as=0.65p ps=3.02u w=2.5u l=1u
X598 VDD xl2.rla_m1 VSS ppolyf_u_1k r_width=2u r_length=9.11u
X599 xl2.xpre.tp vref xl2.xpre.fa xl2.xpre.tp pfet_03v3 ad=1.248p pd=5.32u as=1.248p ps=5.32u w=4.8u l=0.4u
X600 VSS vbn xl2.xpre.fb VSS nfet_03v3 ad=0.65p pd=3.02u as=0.65p ps=3.02u w=2.5u l=1u
X601 xl1.xpre.tn vref xl1.ob VSS nfet_03v3 ad=1.235p pd=5.27u as=1.235p ps=5.27u w=4.75u l=0.5u
X602 xl1.xpre.tp xl1.gn xl1.xpre.fb xl1.xpre.tp pfet_03v3 ad=1.248p pd=5.32u as=1.248p ps=5.32u w=4.8u l=0.4u
X603 VSS vbn xl2.xpre.fa VSS nfet_03v3 ad=0.65p pd=3.02u as=0.65p ps=3.02u w=2.5u l=1u
X604 xl1.ob xl1.gn xl1.xpre.tn VSS nfet_03v3 ad=1.235p pd=5.27u as=1.235p ps=5.27u w=4.75u l=0.5u
X605 xl2.xpre.tn vref xl2.ob VSS nfet_03v3 ad=1.235p pd=5.27u as=1.235p ps=5.27u w=4.75u l=0.5u
X606 xl2.xout.nd VSS VSS VSS nfet_03v3 ad=0.52p pd=2.52u as=0.88p ps=4.88u w=2u l=0.28u
X607 xl2.xpre.fa vb2 xl2.oa VSS nfet_03v3 ad=1.1752p pd=5.04u as=1.1752p ps=5.04u w=4.52u l=0.5u
X608 VDD xl2.rlb_m1 VSS ppolyf_u_1k r_width=2u r_length=9.11u
X609 xl0.xpre.tp xl0.gp xl0.xpre.fa xl0.xpre.tp pfet_03v3 ad=1.248p pd=5.32u as=1.248p ps=5.32u w=4.8u l=0.4u
X610 xl2.xpre.fa xl2.gp xl2.xpre.tp xl2.xpre.tp pfet_03v3 ad=1.248p pd=5.32u as=1.248p ps=5.32u w=4.8u l=0.4u
X611 VDD xl2.d2a xl2.xout.n3a VDD pfet_03v3 ad=0.481p pd=2.37u as=0.481p ps=2.37u w=1.85u l=0.28u
X612 xl1.xout.i1 VDD VDD VDD pfet_03v3 ad=0.962p pd=4.22u as=1.628p ps=8.28u w=3.7u l=0.28u
D7 VSS xl0.gn diode_nd2ps_03v3 pj=26u area=40p
X613 VSS EN xl2.xout.nm VSS nfet_03v3 ad=0.52p pd=2.52u as=0.52p ps=2.52u w=2u l=0.28u
X614 VSS xl2.xout.nd xl2.xout.i1 VSS nfet_03v3 ad=0.39p pd=2.02u as=0.39p ps=2.02u w=1.5u l=0.28u
X615 xl1.xhyst.ts vbn VSS VSS nfet_03v3 ad=0.65p pd=3.02u as=0.65p ps=3.02u w=2.5u l=1u
X616 xl1.xpre.fb vbn VSS VSS nfet_03v3 ad=0.65p pd=3.02u as=0.65p ps=3.02u w=2.5u l=1u
X617 xl1.oa vref xl1.xpre.tn VSS nfet_03v3 ad=1.235p pd=5.27u as=1.235p ps=5.27u w=4.75u l=0.5u
X618 VSS VSS VSS ppolyf_u_1k r_width=5u r_length=1.64u
X619 VDD xl2.d2b xl2.d2a VDD pfet_03v3 ad=0.481p pd=2.37u as=0.481p ps=2.37u w=1.85u l=0.28u
X620 xl1.xpre.fb xl1.gn xl1.xpre.tp xl1.xpre.tp pfet_03v3 ad=1.248p pd=5.32u as=1.248p ps=5.32u w=4.8u l=0.4u
X621 VSS vbn xl0.xpre.fa VSS nfet_03v3 ad=0.65p pd=3.02u as=0.65p ps=3.02u w=2.5u l=1u
X622 xl1.d2b xl1.d2b VDD VDD pfet_03v3 ad=0.481p pd=2.37u as=0.481p ps=2.37u w=1.85u l=0.28u
X623 xl1.xpre.tp vref xl1.xpre.fb xl1.xpre.tp pfet_03v3 ad=1.248p pd=5.32u as=1.248p ps=5.32u w=4.8u l=0.4u
X624 xl2.xpre.tp vref xl2.xpre.fb xl2.xpre.tp pfet_03v3 ad=1.248p pd=5.32u as=1.248p ps=5.32u w=4.8u l=0.4u
X625 RX1_O VDD VDD VDD pfet_03v3 ad=1.3p pd=5.52u as=2.2p ps=10.88u w=5u l=0.28u
X626 xl1.xpre.tp vbp VDD VDD pfet_03v3 ad=1.3p pd=5.52u as=1.3p ps=5.52u w=5u l=1u
X627 xl0.xpre.fb xl0.gn xl0.xpre.tp xl0.xpre.tp pfet_03v3 ad=1.248p pd=5.32u as=1.248p ps=5.32u w=4.8u l=0.4u
X628 xl2.xpre.fa vbn VSS VSS nfet_03v3 ad=0.65p pd=3.02u as=0.65p ps=3.02u w=2.5u l=1u
X629 VSS vbn xl1.xpre.tn VSS nfet_03v3 ad=0.65p pd=3.02u as=0.65p ps=3.02u w=2.5u l=1u
X630 VDD xl2.d2b xl2.xout.d3 VDD pfet_03v3 ad=0.481p pd=2.37u as=0.481p ps=2.37u w=1.85u l=0.28u
X631 xl0.xpre.tp xl0.gp xl0.xpre.fa xl0.xpre.tp pfet_03v3 ad=1.248p pd=5.32u as=1.248p ps=5.32u w=4.8u l=0.4u
X632 xl0.xpre.tp xl0.gp xl0.xpre.fa xl0.xpre.tp pfet_03v3 ad=1.248p pd=5.32u as=1.248p ps=5.32u w=4.8u l=0.4u
X633 xl1.xpre.tp vref xl1.xpre.fa xl1.xpre.tp pfet_03v3 ad=1.248p pd=5.32u as=1.248p ps=5.32u w=4.8u l=0.4u
X634 xl2.xpre.fb vbn VSS VSS nfet_03v3 ad=0.65p pd=3.02u as=0.65p ps=3.02u w=2.5u l=1u
X635 xl0.xpre.fa xl0.gp xl0.xpre.tp xl0.xpre.tp pfet_03v3 ad=1.248p pd=5.32u as=1.248p ps=5.32u w=4.8u l=0.4u
X636 xl1.xpre.tp vref xl1.xpre.fa xl1.xpre.tp pfet_03v3 ad=1.248p pd=5.32u as=1.248p ps=5.32u w=4.8u l=0.4u
X637 VSS VSS xl0.xhyst.ts VSS nfet_03v3 ad=1.1p pd=5.88u as=0.65p ps=3.02u w=2.5u l=1u
X638 VDD xl0.d2a xl0.d2b VDD pfet_03v3 ad=0.481p pd=2.37u as=0.481p ps=2.37u w=1.85u l=0.28u
X639 VSS vbn xl2.xpre.tn VSS nfet_03v3 ad=0.65p pd=3.02u as=0.65p ps=3.02u w=2.5u l=1u
X640 VDD EN xl0.d2b VDD pfet_03v3 ad=0.52p pd=2.52u as=0.52p ps=2.52u w=2u l=0.5u
X641 VSS vbn xl2.xpre.fb VSS nfet_03v3 ad=0.65p pd=3.02u as=0.65p ps=3.02u w=2.5u l=1u
X642 xl1.xhyst.ts vbn VSS VSS nfet_03v3 ad=0.65p pd=3.02u as=0.65p ps=3.02u w=2.5u l=1u
X643 xl1.xout.i1 VSS VSS VSS nfet_03v3 ad=0.39p pd=2.02u as=0.66p ps=3.88u w=1.5u l=0.28u
X644 xl0.xout.i2 xl0.xout.i1 VDD VDD pfet_03v3 ad=0.975p pd=4.27u as=0.975p ps=4.27u w=3.75u l=0.28u
X645 xl0.xpre.tp vref xl0.xpre.fb xl0.xpre.tp pfet_03v3 ad=1.248p pd=5.32u as=1.248p ps=5.32u w=4.8u l=0.4u
X646 xl1.xpre.fa xl1.gp xl1.xpre.tp xl1.xpre.tp pfet_03v3 ad=1.248p pd=5.32u as=1.248p ps=5.32u w=4.8u l=0.4u
X647 xl1.d2b xl1.ob xl1.xhyst.sb VSS nfet_03v3 ad=1.1362p pd=4.89u as=1.1362p ps=4.89u w=4.37u l=0.5u
X648 xl1.xpre.tp vref xl1.xpre.fa xl1.xpre.tp pfet_03v3 ad=1.248p pd=5.32u as=1.248p ps=5.32u w=4.8u l=0.4u
X649 xbias.rb_m3 xbias.rb_m2 VSS ppolyf_u_1k r_width=2u r_length=22.27u
X650 xl1.xpre.fa vbn VSS VSS nfet_03v3 ad=0.65p pd=3.02u as=0.65p ps=3.02u w=2.5u l=1u
X651 VSS VSS VSS VSS nfet_03v3 ad=0.52p pd=2.52u as=0 ps=0 w=2u l=0.28u
X652 xl1.xout.d3 xl1.d2b VDD VDD pfet_03v3 ad=0.481p pd=2.37u as=0.481p ps=2.37u w=1.85u l=0.28u
X653 xl1.oa xl1.rla_m1 VSS ppolyf_u_1k r_width=2u r_length=9.11u
X654 xl2.xpre.tp xl2.gp xl2.xpre.fa xl2.xpre.tp pfet_03v3 ad=1.248p pd=5.32u as=1.248p ps=5.32u w=4.8u l=0.4u
X655 xl1.xpre.tn vref xl1.ob VSS nfet_03v3 ad=1.235p pd=5.27u as=2.09p ps=10.38u w=4.75u l=0.5u
X656 xl1.xpre.tn vref xl1.oa VSS nfet_03v3 ad=1.235p pd=5.27u as=1.235p ps=5.27u w=4.75u l=0.5u
X657 VDD VDD VDD VDD pfet_03v3 ad=0.962p pd=4.22u as=0 ps=0 w=3.7u l=0.28u
X658 xl1.xpre.fa vref xl1.xpre.tp xl1.xpre.tp pfet_03v3 ad=1.248p pd=5.32u as=1.248p ps=5.32u w=4.8u l=0.4u
X659 xl1.xpre.fb vb2 xl1.ob VSS nfet_03v3 ad=1.1752p pd=5.04u as=1.1752p ps=5.04u w=4.52u l=0.5u
X660 xl1.xpre.tp VDD VDD VDD pfet_03v3 ad=1.3p pd=5.52u as=2.2p ps=10.88u w=5u l=1u
X661 VDD vbp vb2 VDD pfet_03v3 ad=1.3p pd=5.52u as=1.3p ps=5.52u w=5u l=1u
X662 xl0.oa xl0.gp xl0.xpre.tn VSS nfet_03v3 ad=1.235p pd=5.27u as=1.235p ps=5.27u w=4.75u l=0.5u
X663 xl1.d2b xl1.d2a VDD VDD pfet_03v3 ad=0.481p pd=2.37u as=0.481p ps=2.37u w=1.85u l=0.28u
X664 xl1.xpre.fa vref xl1.xpre.tp xl1.xpre.tp pfet_03v3 ad=1.248p pd=5.32u as=1.248p ps=5.32u w=4.8u l=0.4u
X665 xl2.xpre.tn vbn VSS VSS nfet_03v3 ad=0.65p pd=3.02u as=0.65p ps=3.02u w=2.5u l=1u
X666 VDD vbp xl0.xpre.tp VDD pfet_03v3 ad=1.3p pd=5.52u as=1.3p ps=5.52u w=5u l=1u
X667 xl1.xpre.fb vb2 xl1.ob VSS nfet_03v3 ad=1.1752p pd=5.04u as=1.1752p ps=5.04u w=4.52u l=0.5u
D8 xl2.gp VDD diode_pd2nw_03v3 pj=26u area=40p
X668 xl2.xpre.tn xl2.gn xl2.ob VSS nfet_03v3 ad=1.235p pd=5.27u as=1.235p ps=5.27u w=4.75u l=0.5u
X669 VDD xl1.xout.i1 xl1.xout.i2 VDD pfet_03v3 ad=0.975p pd=4.27u as=0.975p ps=4.27u w=3.75u l=0.28u
X670 VSS EN xbias.enb VSS nfet_03v3 ad=0.44p pd=2.88u as=0.44p ps=2.88u w=1u l=0.28u
X671 xl0.xpre.fb vref xl0.xpre.tp xl0.xpre.tp pfet_03v3 ad=1.248p pd=5.32u as=1.248p ps=5.32u w=4.8u l=0.4u
X672 xl1.xpre.tp vref xl1.xpre.fb xl1.xpre.tp pfet_03v3 ad=1.248p pd=5.32u as=1.248p ps=5.32u w=4.8u l=0.4u
X673 xl0.ob vref xl0.xpre.tn VSS nfet_03v3 ad=1.235p pd=5.27u as=1.235p ps=5.27u w=4.75u l=0.5u
X674 xl0.xpre.tp vref xl0.xpre.fb xl0.xpre.tp pfet_03v3 ad=1.248p pd=5.32u as=1.248p ps=5.32u w=4.8u l=0.4u
X675 xl1.ob xl1.rlb_m1 VSS ppolyf_u_1k r_width=2u r_length=9.11u
X676 xl2.oa xl2.gp xl2.xpre.tn VSS nfet_03v3 ad=1.235p pd=5.27u as=1.235p ps=5.27u w=4.75u l=0.5u
X677 xl2.xpre.tp xl2.gn xl2.xpre.fb xl2.xpre.tp pfet_03v3 ad=1.248p pd=5.32u as=1.248p ps=5.32u w=4.8u l=0.4u
X678 VDD VDD RX1_O VDD pfet_03v3 ad=2.2p pd=10.88u as=1.3p ps=5.52u w=5u l=0.28u
X679 xl0.xout.nd VDD VDD VDD pfet_03v3 ad=0.78p pd=3.52u as=1.32p ps=6.88u w=3u l=0.28u
X680 VDD xl2.d2a xl2.xout.n3a VDD pfet_03v3 ad=0.481p pd=2.37u as=0.481p ps=2.37u w=1.85u l=0.28u
X681 xl2.xpre.tp vref xl2.xpre.fb xl2.xpre.tp pfet_03v3 ad=1.248p pd=5.32u as=1.248p ps=5.32u w=4.8u l=0.4u
X682 xl2.xpre.tn vref xl2.oa VSS nfet_03v3 ad=1.235p pd=5.27u as=1.235p ps=5.27u w=4.75u l=0.5u
X683 VDD xl0.d2a xl0.xout.n3a VDD pfet_03v3 ad=0.481p pd=2.37u as=0.481p ps=2.37u w=1.85u l=0.28u
X684 xl1.xout.nd VSS VSS VSS nfet_03v3 ad=0.52p pd=2.52u as=0.88p ps=4.88u w=2u l=0.28u
X685 xl2.d2b xl2.d2a VDD VDD pfet_03v3 ad=0.481p pd=2.37u as=0.481p ps=2.37u w=1.85u l=0.28u
X686 xl2.xpre.tp vbp VDD VDD pfet_03v3 ad=1.3p pd=5.52u as=1.3p ps=5.52u w=5u l=1u
X687 xl0.xpre.fa vbn VSS VSS nfet_03v3 ad=0.65p pd=3.02u as=0.65p ps=3.02u w=2.5u l=1u
X688 xl0.xout.d3 xl0.xout.n3a VSS VSS nfet_03v3 ad=1.2116p pd=5.18u as=1.2116p ps=5.18u w=4.66u l=0.28u
X689 xl0.xpre.tp vbp VDD VDD pfet_03v3 ad=1.3p pd=5.52u as=1.3p ps=5.52u w=5u l=1u
X690 xl0.xpre.fa vref xl0.xpre.tp xl0.xpre.tp pfet_03v3 ad=1.248p pd=5.32u as=1.248p ps=5.32u w=4.8u l=0.4u
X691 VSS VSS xbias.nmid VSS nfet_03v3 ad=2.2p pd=10.88u as=1.3p ps=5.52u w=5u l=0.5u
X692 xl0.xpre.tp xl0.gp xl0.xpre.fa xl0.xpre.tp pfet_03v3 ad=1.248p pd=5.32u as=1.248p ps=5.32u w=4.8u l=0.4u
X693 xl1.xpre.fb vref xl1.xpre.tp xl1.xpre.tp pfet_03v3 ad=1.248p pd=5.32u as=1.248p ps=5.32u w=4.8u l=0.4u
X694 xl0.xpre.fb vbn VSS VSS nfet_03v3 ad=0.65p pd=3.02u as=0.65p ps=3.02u w=2.5u l=1u
X695 xl1.xpre.fb vbn VSS VSS nfet_03v3 ad=0.65p pd=3.02u as=0.65p ps=3.02u w=2.5u l=1u
X696 VSS EN xl1.xout.nm VSS nfet_03v3 ad=0.52p pd=2.52u as=0.52p ps=2.52u w=2u l=0.28u
X697 VSS xl1.xout.nd xl1.xout.i1 VSS nfet_03v3 ad=0.39p pd=2.02u as=0.39p ps=2.02u w=1.5u l=0.28u
X698 xl2.xpre.fb vref xl2.xpre.tp xl2.xpre.tp pfet_03v3 ad=1.248p pd=5.32u as=1.248p ps=5.32u w=4.8u l=0.4u
X699 xl0.xpre.tn xl0.gn xl0.ob VSS nfet_03v3 ad=1.235p pd=5.27u as=1.235p ps=5.27u w=4.75u l=0.5u
X700 VDD xl1.d2a xl1.d2b VDD pfet_03v3 ad=0.481p pd=2.37u as=0.481p ps=2.37u w=1.85u l=0.28u
X701 xl2.d2a xl2.oa xl2.xhyst.sa VSS nfet_03v3 ad=1.1362p pd=4.89u as=1.1362p ps=4.89u w=4.37u l=0.5u
X702 VDD vbp xl1.xpre.tp VDD pfet_03v3 ad=1.3p pd=5.52u as=1.3p ps=5.52u w=5u l=1u
X703 xl2.xpre.tp xl2.gp xl2.xpre.fa xl2.xpre.tp pfet_03v3 ad=1.248p pd=5.32u as=1.248p ps=5.32u w=4.8u l=0.4u
X704 VSS EN xbias.nmid VSS nfet_03v3 ad=1.3p pd=5.52u as=1.3p ps=5.52u w=5u l=0.5u
X705 xl1.xpre.tn vref xl1.oa VSS nfet_03v3 ad=1.235p pd=5.27u as=1.235p ps=5.27u w=4.75u l=0.5u
X706 VSS vbn xl2.xpre.tn VSS nfet_03v3 ad=0.65p pd=3.02u as=0.65p ps=3.02u w=2.5u l=1u
X707 VDD vbp xl2.xpre.tp VDD pfet_03v3 ad=1.3p pd=5.52u as=1.3p ps=5.52u w=5u l=1u
X708 xl1.xout.n3a xl1.d2a VDD VDD pfet_03v3 ad=0.481p pd=2.37u as=0.481p ps=2.37u w=1.85u l=0.28u
X709 xl0.xpre.fa vref xl0.xpre.tp xl0.xpre.tp pfet_03v3 ad=1.248p pd=5.32u as=1.248p ps=5.32u w=4.8u l=0.4u
X710 xl0.oa vb2 xl0.xpre.fa VSS nfet_03v3 ad=1.1752p pd=5.04u as=1.1752p ps=5.04u w=4.52u l=0.5u
X711 VDD xl1.d2a xl1.d2a VDD pfet_03v3 ad=0.481p pd=2.37u as=0.481p ps=2.37u w=1.85u l=0.28u
X712 xl1.xpre.tp vbp VDD VDD pfet_03v3 ad=1.3p pd=5.52u as=1.3p ps=5.52u w=5u l=1u
X713 xbias.vf vb2 vb2 VSS nfet_03v3 ad=2.0566p pd=8.43u as=2.0566p ps=8.43u w=7.91u l=0.5u
X714 RX0_O VDD VDD VDD pfet_03v3 ad=1.3p pd=5.52u as=2.2p ps=10.88u w=5u l=0.28u
X715 VDD VDD xl0.xout.nd VDD pfet_03v3 ad=1.32p pd=6.88u as=0.78p ps=3.52u w=3u l=0.28u
X716 xl2.xout.n3a xl2.d2a VDD VDD pfet_03v3 ad=0.481p pd=2.37u as=0.481p ps=2.37u w=1.85u l=0.28u
X717 xl1.xpre.fb xl1.gn xl1.xpre.tp xl1.xpre.tp pfet_03v3 ad=1.248p pd=5.32u as=1.248p ps=5.32u w=4.8u l=0.4u
X718 xl2.ob vb2 xl2.xpre.fb VSS nfet_03v3 ad=1.1752p pd=5.04u as=1.1752p ps=5.04u w=4.52u l=0.5u
X719 xl1.xpre.tn vref xl1.ob VSS nfet_03v3 ad=1.235p pd=5.27u as=1.235p ps=5.27u w=4.75u l=0.5u
X720 xl0.xhyst.ts xl0.xhyst.sa VSS ppolyf_u_1k r_width=5u r_length=1.64u
X721 xl0.xpre.fa vref xl0.xpre.tp xl0.xpre.tp pfet_03v3 ad=1.248p pd=5.32u as=1.248p ps=5.32u w=4.8u l=0.4u
X722 xl1.xpre.fa xl1.gp xl1.xpre.tp xl1.xpre.tp pfet_03v3 ad=1.248p pd=5.32u as=1.248p ps=5.32u w=4.8u l=0.4u
X723 xl2.xpre.fa vb2 xl2.oa VSS nfet_03v3 ad=1.1752p pd=5.04u as=1.1752p ps=5.04u w=4.52u l=0.5u
X724 RX1_O xl1.xout.i2 VDD VDD pfet_03v3 ad=1.3p pd=5.52u as=1.3p ps=5.52u w=5u l=0.28u
X725 xl2.xpre.tp vref xl2.xpre.fa xl2.xpre.tp pfet_03v3 ad=1.248p pd=5.32u as=1.248p ps=5.32u w=4.8u l=0.4u
X726 VSS vbn xl0.xpre.fb VSS nfet_03v3 ad=0.65p pd=3.02u as=0.65p ps=3.02u w=2.5u l=1u
X727 xl2.xpre.tn vbn VSS VSS nfet_03v3 ad=0.65p pd=3.02u as=0.65p ps=3.02u w=2.5u l=1u
X728 xl1.xpre.tp xl1.gn xl1.xpre.fb xl1.xpre.tp pfet_03v3 ad=1.248p pd=5.32u as=1.248p ps=5.32u w=4.8u l=0.4u
X729 xl0.xpre.tn vref xl0.oa VSS nfet_03v3 ad=1.235p pd=5.27u as=1.235p ps=5.27u w=4.75u l=0.5u
X730 xl2.xpre.fa vb2 xl2.oa VSS nfet_03v3 ad=1.1752p pd=5.04u as=1.1752p ps=5.04u w=4.52u l=0.5u
X731 xl2.xpre.fa vref xl2.xpre.tp xl2.xpre.tp pfet_03v3 ad=1.248p pd=5.32u as=1.248p ps=5.32u w=4.8u l=0.4u
X732 RX2_O VDD VDD VDD pfet_03v3 ad=1.3p pd=5.52u as=2.2p ps=10.88u w=5u l=0.28u
X733 xbias.enb VDD VDD VDD pfet_03v3 ad=0.65p pd=3.02u as=1.1p ps=5.88u w=2.5u l=0.28u
X734 VDD vbp xl0.xpre.tp VDD pfet_03v3 ad=1.3p pd=5.52u as=1.3p ps=5.52u w=5u l=1u
X735 xl1.gn RX1_N VDD ppolyf_u r_width=5u r_length=1.8u
X736 VSS vbn xl1.xpre.fb VSS nfet_03v3 ad=0.65p pd=3.02u as=0.65p ps=3.02u w=2.5u l=1u
X737 VDD xl2.d2b xl2.xout.d3 VDD pfet_03v3 ad=0.481p pd=2.37u as=0.481p ps=2.37u w=1.85u l=0.28u
X738 xl0.xpre.fa VSS VSS VSS nfet_03v3 ad=0.65p pd=3.02u as=1.1p ps=5.88u w=2.5u l=1u
X739 xl0.xpre.fb vb2 xl0.ob VSS nfet_03v3 ad=1.1752p pd=5.04u as=1.1752p ps=5.04u w=4.52u l=0.5u
X740 xl1.xout.nd EN VDD VDD pfet_03v3 ad=0.78p pd=3.52u as=0.78p ps=3.52u w=3u l=0.28u
X741 xl2.d2a xl2.d2a VDD VDD pfet_03v3 ad=0.481p pd=2.37u as=0.481p ps=2.37u w=1.85u l=0.28u
X742 xl0.xpre.tn vbn VSS VSS nfet_03v3 ad=0.65p pd=3.02u as=0.65p ps=3.02u w=2.5u l=1u
X743 VSS vbn vbn VSS nfet_03v3 ad=0.65p pd=3.02u as=0.65p ps=3.02u w=2.5u l=1u
X744 xl0.xout.i1 VSS VSS VSS nfet_03v3 ad=0.39p pd=2.02u as=0.66p ps=3.88u w=1.5u l=0.28u
X745 VSS vbn xl2.xhyst.ts VSS nfet_03v3 ad=0.65p pd=3.02u as=0.65p ps=3.02u w=2.5u l=1u
X746 xl2.xpre.tp vref xl2.xpre.fb xl2.xpre.tp pfet_03v3 ad=1.248p pd=5.32u as=2.112p ps=10.48u w=4.8u l=0.4u
X747 vbp vbn VSS VSS nfet_03v3 ad=0.65p pd=3.02u as=0.65p ps=3.02u w=2.5u l=1u
X748 VDD xl1.d2b xl1.xout.d3 VDD pfet_03v3 ad=0.481p pd=2.37u as=0.481p ps=2.37u w=1.85u l=0.28u
X749 vb2 vbp VDD VDD pfet_03v3 ad=1.3p pd=5.52u as=1.3p ps=5.52u w=5u l=1u
X750 VDD xl2.d2b xl2.d2b VDD pfet_03v3 ad=0.481p pd=2.37u as=0.481p ps=2.37u w=1.85u l=0.28u
X751 xl2.xpre.tp vbp VDD VDD pfet_03v3 ad=1.3p pd=5.52u as=1.3p ps=5.52u w=5u l=1u
X752 xl0.d2a VSS VSS VSS nfet_03v3 ad=1.1362p pd=4.89u as=1.9228p ps=9.62u w=4.37u l=0.5u
X753 xl2.xpre.fa vref xl2.xpre.tp xl2.xpre.tp pfet_03v3 ad=1.248p pd=5.32u as=1.248p ps=5.32u w=4.8u l=0.4u
X754 xl0.xpre.tp vbp VDD VDD pfet_03v3 ad=1.3p pd=5.52u as=1.3p ps=5.52u w=5u l=1u
X755 VSS VSS VSS VSS nfet_03v3 ad=0.52p pd=2.52u as=0 ps=0 w=2u l=0.28u
X756 VDD VDD VDD VDD pfet_03v3 ad=0.52p pd=2.52u as=0 ps=0 w=2u l=0.5u
X757 VDD xl0.d2b xl0.d2a VDD pfet_03v3 ad=0.481p pd=2.37u as=0.481p ps=2.37u w=1.85u l=0.28u
X758 VSS VSS VSS ppolyf_u_1k r_width=2u r_length=21.01u
X759 xl1.xpre.tp vbp VDD VDD pfet_03v3 ad=1.3p pd=5.52u as=1.3p ps=5.52u w=5u l=1u
X760 xl2.xpre.tp vref xl2.xpre.fb xl2.xpre.tp pfet_03v3 ad=1.248p pd=5.32u as=1.248p ps=5.32u w=4.8u l=0.4u
X761 VDD VDD VDD VDD pfet_03v3 ad=0.52p pd=2.52u as=0 ps=0 w=2u l=0.5u
X762 xl0.xpre.fb vref xl0.xpre.tp xl0.xpre.tp pfet_03v3 ad=1.248p pd=5.32u as=1.248p ps=5.32u w=4.8u l=0.4u
X763 VDD xbias.enb xbias.nrb VDD pfet_03v3 ad=1.3p pd=5.52u as=1.3p ps=5.52u w=5u l=0.5u
X764 xl0.d2a VDD VDD VDD pfet_03v3 ad=0.52p pd=2.52u as=0.88p ps=4.88u w=2u l=0.5u
X765 vref xbias.rdb_m1 VSS ppolyf_u_1k r_width=2u r_length=19.26u
X766 xl2.xpre.tp vref xl2.xpre.fb xl2.xpre.tp pfet_03v3 ad=1.248p pd=5.32u as=1.248p ps=5.32u w=4.8u l=0.4u
X767 xl0.xpre.fa vbn VSS VSS nfet_03v3 ad=0.65p pd=3.02u as=0.65p ps=3.02u w=2.5u l=1u
X768 xl2.oa vref xl2.xpre.tn VSS nfet_03v3 ad=1.235p pd=5.27u as=1.235p ps=5.27u w=4.75u l=0.5u
X769 VSS vbn xl0.xhyst.ts VSS nfet_03v3 ad=0.65p pd=3.02u as=0.65p ps=3.02u w=2.5u l=1u
X770 xl0.xpre.tp xl0.gp xl0.xpre.fa xl0.xpre.tp pfet_03v3 ad=1.248p pd=5.32u as=1.248p ps=5.32u w=4.8u l=0.4u
X771 xl1.xpre.tp xl1.gp xl1.xpre.fa xl1.xpre.tp pfet_03v3 ad=1.248p pd=5.32u as=1.248p ps=5.32u w=4.8u l=0.4u
X772 xl2.xpre.fb vref xl2.xpre.tp xl2.xpre.tp pfet_03v3 ad=1.248p pd=5.32u as=1.248p ps=5.32u w=4.8u l=0.4u
X773 xl1.xpre.fb vref xl1.xpre.tp xl1.xpre.tp pfet_03v3 ad=1.248p pd=5.32u as=1.248p ps=5.32u w=4.8u l=0.4u
X774 xl1.ob xl1.gn xl1.xpre.tn VSS nfet_03v3 ad=1.235p pd=5.27u as=1.235p ps=5.27u w=4.75u l=0.5u
X775 xl2.xout.d3 xl2.d2b VDD VDD pfet_03v3 ad=0.481p pd=2.37u as=0.481p ps=2.37u w=1.85u l=0.28u
X776 VDD vbp xl2.xpre.tp VDD pfet_03v3 ad=1.3p pd=5.52u as=1.3p ps=5.52u w=5u l=1u
X777 xl2.xpre.fb xl2.gn xl2.xpre.tp xl2.xpre.tp pfet_03v3 ad=1.248p pd=5.32u as=1.248p ps=5.32u w=4.8u l=0.4u
X778 xl0.xout.d3 xl0.d2b VDD VDD pfet_03v3 ad=0.481p pd=2.37u as=0.481p ps=2.37u w=1.85u l=0.28u
X779 xl2.ob vref xl2.xpre.tn VSS nfet_03v3 ad=1.235p pd=5.27u as=1.235p ps=5.27u w=4.75u l=0.5u
X780 VDD xl2.d2b xl2.d2b VDD pfet_03v3 ad=0.481p pd=2.37u as=0.481p ps=2.37u w=1.85u l=0.28u
X781 VDD VDD RX0_O VDD pfet_03v3 ad=2.2p pd=10.88u as=1.3p ps=5.52u w=5u l=0.28u
D9 VSS xl2.gp diode_nd2ps_03v3 pj=26u area=40p
X782 xl1.oa xl1.gp xl1.xpre.tn VSS nfet_03v3 ad=1.235p pd=5.27u as=1.235p ps=5.27u w=4.75u l=0.5u
X783 VSS vbn xl0.xpre.fa VSS nfet_03v3 ad=0.65p pd=3.02u as=0.65p ps=3.02u w=2.5u l=1u
X784 xl1.xpre.fa vb2 xl1.oa VSS nfet_03v3 ad=1.1752p pd=5.04u as=1.1752p ps=5.04u w=4.52u l=0.5u
X785 VDD VDD VDD VDD pfet_03v3 ad=0.481p pd=2.37u as=0 ps=0 w=1.85u l=0.28u
X786 VSS VSS xl0.xpre.tn VSS nfet_03v3 ad=1.1p pd=5.88u as=0.65p ps=3.02u w=2.5u l=1u
X787 xl0.xout.nd VSS VSS VSS nfet_03v3 ad=0.52p pd=2.52u as=0.88p ps=4.88u w=2u l=0.28u
X788 xl1.d2b VSS VSS VSS nfet_03v3 ad=1.1362p pd=4.89u as=1.9228p ps=9.62u w=4.37u l=0.5u
X789 xl2.xhyst.ts vbn VSS VSS nfet_03v3 ad=0.65p pd=3.02u as=0.65p ps=3.02u w=2.5u l=1u
X790 xl1.xpre.tp vref xl1.xpre.fa xl1.xpre.tp pfet_03v3 ad=1.248p pd=5.32u as=1.248p ps=5.32u w=4.8u l=0.4u
X791 VSS vbn xl1.xpre.fb VSS nfet_03v3 ad=0.65p pd=3.02u as=0.65p ps=3.02u w=2.5u l=1u
X792 xl0.xpre.tn vref xl0.ob VSS nfet_03v3 ad=1.235p pd=5.27u as=1.235p ps=5.27u w=4.75u l=0.5u
X793 xl0.ob xl0.gn xl0.xpre.tn VSS nfet_03v3 ad=1.235p pd=5.27u as=1.235p ps=5.27u w=4.75u l=0.5u
X794 xl1.xpre.tn vref xl1.ob VSS nfet_03v3 ad=1.235p pd=5.27u as=1.235p ps=5.27u w=4.75u l=0.5u
X795 xl0.xpre.tp xl0.gn xl0.xpre.fb xl0.xpre.tp pfet_03v3 ad=1.248p pd=5.32u as=1.248p ps=5.32u w=4.8u l=0.4u
X796 xl1.xpre.fa vb2 xl1.oa VSS nfet_03v3 ad=1.1752p pd=5.04u as=1.1752p ps=5.04u w=4.52u l=0.5u
X797 xl2.xhyst.ts xl2.xhyst.sb VSS ppolyf_u_1k r_width=5u r_length=1.64u
X798 VDD VDD RX2_O VDD pfet_03v3 ad=2.2p pd=10.88u as=1.3p ps=5.52u w=5u l=0.28u
X799 VDD xl1.rlb_m1 VSS ppolyf_u_1k r_width=2u r_length=9.11u
X800 xl2.xpre.tp vref xl2.xpre.fa xl2.xpre.tp pfet_03v3 ad=1.248p pd=5.32u as=1.248p ps=5.32u w=4.8u l=0.4u
X801 xl2.xpre.tn xl2.gp xl2.oa VSS nfet_03v3 ad=1.235p pd=5.27u as=1.235p ps=5.27u w=4.75u l=0.5u
X802 VSS xl0.xout.nd xl0.xout.i1 VSS nfet_03v3 ad=0.39p pd=2.02u as=0.39p ps=2.02u w=1.5u l=0.28u
X803 VSS EN xl0.xout.nm VSS nfet_03v3 ad=0.52p pd=2.52u as=0.52p ps=2.52u w=2u l=0.28u
X804 VDD vbp xl1.xpre.tp VDD pfet_03v3 ad=1.3p pd=5.52u as=1.3p ps=5.52u w=5u l=1u
X805 VDD xl1.d2a xl1.xout.n3a VDD pfet_03v3 ad=0.481p pd=2.37u as=0.481p ps=2.37u w=1.85u l=0.28u
X806 xl0.xout.i1 VDD VDD VDD pfet_03v3 ad=0.962p pd=4.22u as=1.628p ps=8.28u w=3.7u l=0.28u
X807 xl1.xpre.fb vb2 xl1.ob VSS nfet_03v3 ad=1.1752p pd=5.04u as=1.1752p ps=5.04u w=4.52u l=0.5u
X808 xl0.xpre.fb vbn VSS VSS nfet_03v3 ad=0.65p pd=3.02u as=0.65p ps=3.02u w=2.5u l=1u
X809 xl0.oa vref xl0.xpre.tn VSS nfet_03v3 ad=1.235p pd=5.27u as=1.235p ps=5.27u w=4.75u l=0.5u
X810 xl0.xhyst.ts vbn VSS VSS nfet_03v3 ad=0.65p pd=3.02u as=0.65p ps=3.02u w=2.5u l=1u
X811 xl2.xpre.tn xl2.gn xl2.ob VSS nfet_03v3 ad=1.235p pd=5.27u as=1.235p ps=5.27u w=4.75u l=0.5u
X812 VSS VSS VSS ppolyf_u_1k r_width=5u r_length=1.64u
X813 VSS vbn xl2.xpre.fb VSS nfet_03v3 ad=0.65p pd=3.02u as=0.65p ps=3.02u w=2.5u l=1u
X814 xl1.xpre.tp vref xl1.xpre.fa xl1.xpre.tp pfet_03v3 ad=1.248p pd=5.32u as=1.248p ps=5.32u w=4.8u l=0.4u
X815 xl1.xhyst.ts vbn VSS VSS nfet_03v3 ad=0.65p pd=3.02u as=0.65p ps=3.02u w=2.5u l=1u
X816 xl0.xpre.fb xl0.gn xl0.xpre.tp xl0.xpre.tp pfet_03v3 ad=1.248p pd=5.32u as=1.248p ps=5.32u w=4.8u l=0.4u
X817 xl0.xpre.tp vref xl0.xpre.fb xl0.xpre.tp pfet_03v3 ad=1.248p pd=5.32u as=1.248p ps=5.32u w=4.8u l=0.4u
X818 xl1.xpre.tp vref xl1.xpre.fb xl1.xpre.tp pfet_03v3 ad=1.248p pd=5.32u as=1.248p ps=5.32u w=4.8u l=0.4u
X819 xl2.xpre.tp xl2.gp xl2.xpre.fa xl2.xpre.tp pfet_03v3 ad=1.248p pd=5.32u as=1.248p ps=5.32u w=4.8u l=0.4u
X820 xl2.xpre.tn vref xl2.ob VSS nfet_03v3 ad=1.235p pd=5.27u as=1.235p ps=5.27u w=4.75u l=0.5u
X821 xl0.d2b xl0.d2b VDD VDD pfet_03v3 ad=0.481p pd=2.37u as=0.481p ps=2.37u w=1.85u l=0.28u
X822 xl2.xpre.tp xl2.gn xl2.xpre.fb xl2.xpre.tp pfet_03v3 ad=1.248p pd=5.32u as=1.248p ps=5.32u w=4.8u l=0.4u
X823 RX0_O xl0.xout.i2 VDD VDD pfet_03v3 ad=1.3p pd=5.52u as=1.3p ps=5.52u w=5u l=0.28u
X824 xl2.xpre.fb xl2.gn xl2.xpre.tp xl2.xpre.tp pfet_03v3 ad=1.248p pd=5.32u as=1.248p ps=5.32u w=4.8u l=0.4u
X825 xl0.xpre.tp vbp VDD VDD pfet_03v3 ad=1.3p pd=5.52u as=1.3p ps=5.52u w=5u l=1u
X826 xl1.xpre.fa vbn VSS VSS nfet_03v3 ad=0.65p pd=3.02u as=0.65p ps=3.02u w=2.5u l=1u
X827 VSS vbn xl0.xpre.tn VSS nfet_03v3 ad=0.65p pd=3.02u as=0.65p ps=3.02u w=2.5u l=1u
X828 VDD xl1.d2b xl1.xout.d3 VDD pfet_03v3 ad=0.481p pd=2.37u as=0.481p ps=2.37u w=1.85u l=0.28u
X829 xl0.xpre.tp vref xl0.xpre.fa xl0.xpre.tp pfet_03v3 ad=1.248p pd=5.32u as=1.248p ps=5.32u w=4.8u l=0.4u
X830 xl2.xhyst.sb xl2.ob xl2.d2b VSS nfet_03v3 ad=1.1362p pd=4.89u as=1.1362p ps=4.89u w=4.37u l=0.5u
X831 xl1.xpre.tp xl1.gn xl1.xpre.fb xl1.xpre.tp pfet_03v3 ad=1.248p pd=5.32u as=1.248p ps=5.32u w=4.8u l=0.4u
X832 xl2.d2a xl2.d2b VDD VDD pfet_03v3 ad=0.481p pd=2.37u as=0.481p ps=2.37u w=1.85u l=0.28u
X833 RX2_O xl2.xout.i2 VDD VDD pfet_03v3 ad=1.3p pd=5.52u as=1.3p ps=5.52u w=5u l=0.28u
X834 xl0.xpre.tp vref xl0.xpre.fa xl0.xpre.tp pfet_03v3 ad=1.248p pd=5.32u as=1.248p ps=5.32u w=4.8u l=0.4u
X835 xl2.xpre.fb vref xl2.xpre.tp xl2.xpre.tp pfet_03v3 ad=1.248p pd=5.32u as=1.248p ps=5.32u w=4.8u l=0.4u
X836 VSS vbn xl1.xpre.tn VSS nfet_03v3 ad=0.65p pd=3.02u as=0.65p ps=3.02u w=2.5u l=1u
X837 vbp vbn VSS VSS nfet_03v3 ad=0.65p pd=3.02u as=0.65p ps=3.02u w=2.5u l=1u
X838 xl2.ob vb2 xl2.xpre.fb VSS nfet_03v3 ad=1.1752p pd=5.04u as=1.1752p ps=5.04u w=4.52u l=0.5u
X839 xl0.xhyst.ts vbn VSS VSS nfet_03v3 ad=0.65p pd=3.02u as=0.65p ps=3.02u w=2.5u l=1u
X840 xl1.xpre.tn vref xl1.oa VSS nfet_03v3 ad=1.235p pd=5.27u as=1.235p ps=5.27u w=4.75u l=0.5u
X841 xbias.rf_m1 xbias.vf VSS ppolyf_u_1k r_width=2u r_length=23.07u
X842 VSS vbn xl2.xpre.fa VSS nfet_03v3 ad=0.65p pd=3.02u as=0.65p ps=3.02u w=2.5u l=1u
X843 xl0.xpre.fa xl0.gp xl0.xpre.tp xl0.xpre.tp pfet_03v3 ad=1.248p pd=5.32u as=1.248p ps=5.32u w=4.8u l=0.4u
X844 xl1.xhyst.ts VSS VSS VSS nfet_03v3 ad=0.65p pd=3.02u as=1.1p ps=5.88u w=2.5u l=1u
X845 xl0.d2b xl0.ob xl0.xhyst.sb VSS nfet_03v3 ad=1.1362p pd=4.89u as=1.1362p ps=4.89u w=4.37u l=0.5u
X846 xl0.xpre.tp vref xl0.xpre.fa xl0.xpre.tp pfet_03v3 ad=1.248p pd=5.32u as=1.248p ps=5.32u w=4.8u l=0.4u
X847 xl2.xpre.tp xl2.gn xl2.xpre.fb xl2.xpre.tp pfet_03v3 ad=1.248p pd=5.32u as=1.248p ps=5.32u w=4.8u l=0.4u
X848 xl0.xpre.fa vbn VSS VSS nfet_03v3 ad=0.65p pd=3.02u as=0.65p ps=3.02u w=2.5u l=1u
X849 xl2.ob vb2 xl2.xpre.fb VSS nfet_03v3 ad=1.1752p pd=5.04u as=1.1752p ps=5.04u w=4.52u l=0.5u
X850 xl0.xout.d3 xl0.d2b VDD VDD pfet_03v3 ad=0.481p pd=2.37u as=0.481p ps=2.37u w=1.85u l=0.28u
X851 xl0.xpre.tn vref xl0.ob VSS nfet_03v3 ad=1.235p pd=5.27u as=2.09p ps=10.38u w=4.75u l=0.5u
X852 xl0.xpre.tn vref xl0.oa VSS nfet_03v3 ad=1.235p pd=5.27u as=1.235p ps=5.27u w=4.75u l=0.5u
X853 xl0.oa xl0.rla_m1 VSS ppolyf_u_1k r_width=2u r_length=9.11u
X854 xl0.xpre.fa vref xl0.xpre.tp xl0.xpre.tp pfet_03v3 ad=1.248p pd=5.32u as=1.248p ps=5.32u w=4.8u l=0.4u
X855 VDD VDD VDD VDD pfet_03v3 ad=0.962p pd=4.22u as=0 ps=0 w=3.7u l=0.28u
X856 xl2.xpre.tp xl2.gp xl2.xpre.fa xl2.xpre.tp pfet_03v3 ad=1.248p pd=5.32u as=1.248p ps=5.32u w=4.8u l=0.4u
X857 xl0.xpre.fb vb2 xl0.ob VSS nfet_03v3 ad=1.1752p pd=5.04u as=1.1752p ps=5.04u w=4.52u l=0.5u
X858 xl2.ob VSS VSS VSS nfet_03v3 ad=1.1752p pd=5.04u as=1.9888p ps=9.92u w=4.52u l=0.5u
X859 xl0.xpre.tp VDD VDD VDD pfet_03v3 ad=1.3p pd=5.52u as=2.2p ps=10.88u w=5u l=1u
X860 xl2.xpre.tp vref xl2.xpre.fa xl2.xpre.tp pfet_03v3 ad=1.248p pd=5.32u as=1.248p ps=5.32u w=4.8u l=0.4u
X861 xl0.d2b xl0.d2a VDD VDD pfet_03v3 ad=0.481p pd=2.37u as=0.481p ps=2.37u w=1.85u l=0.28u
X862 VSS vbn xl2.xpre.fb VSS nfet_03v3 ad=0.65p pd=3.02u as=0.65p ps=3.02u w=2.5u l=1u
X863 xl1.xpre.tn vbn VSS VSS nfet_03v3 ad=0.65p pd=3.02u as=0.65p ps=3.02u w=2.5u l=1u
X864 xl0.xpre.fa vref xl0.xpre.tp xl0.xpre.tp pfet_03v3 ad=1.248p pd=5.32u as=1.248p ps=5.32u w=4.8u l=0.4u
X865 xl1.xpre.tp xl1.gp xl1.xpre.fa xl1.xpre.tp pfet_03v3 ad=1.248p pd=5.32u as=1.248p ps=5.32u w=4.8u l=0.4u
X866 xl0.xpre.fb vb2 xl0.ob VSS nfet_03v3 ad=1.1752p pd=5.04u as=1.1752p ps=5.04u w=4.52u l=0.5u
D10 xl1.gp VDD diode_pd2nw_03v3 pj=26u area=40p
X867 VDD vbp vbp VDD pfet_03v3 ad=1.3p pd=5.52u as=1.3p ps=5.52u w=5u l=1u
X868 xl1.d2a xl1.d2a VDD VDD pfet_03v3 ad=0.481p pd=2.37u as=0.481p ps=2.37u w=1.85u l=0.28u
X869 xl1.xpre.tn xl1.gn xl1.ob VSS nfet_03v3 ad=1.235p pd=5.27u as=1.235p ps=5.27u w=4.75u l=0.5u
X870 VDD xl0.xout.i1 xl0.xout.i2 VDD pfet_03v3 ad=0.975p pd=4.27u as=0.975p ps=4.27u w=3.75u l=0.28u
X871 xl0.xpre.tp vref xl0.xpre.fb xl0.xpre.tp pfet_03v3 ad=1.248p pd=5.32u as=1.248p ps=5.32u w=4.8u l=0.4u
X872 xl1.xpre.fa xl1.gp xl1.xpre.tp xl1.xpre.tp pfet_03v3 ad=1.248p pd=5.32u as=1.248p ps=5.32u w=4.8u l=0.4u
X873 xl2.xpre.fa vref xl2.xpre.tp xl2.xpre.tp pfet_03v3 ad=1.248p pd=5.32u as=1.248p ps=5.32u w=4.8u l=0.4u
X874 xl0.ob xl0.rlb_m1 VSS ppolyf_u_1k r_width=2u r_length=9.11u
X875 VDD xl1.d2a xl1.xout.n3a VDD pfet_03v3 ad=0.481p pd=2.37u as=0.481p ps=2.37u w=1.85u l=0.28u
X876 xl1.xpre.tp vref xl1.xpre.fb xl1.xpre.tp pfet_03v3 ad=1.248p pd=5.32u as=1.248p ps=5.32u w=4.8u l=0.4u
X877 xl1.xpre.tn vref xl1.oa VSS nfet_03v3 ad=1.235p pd=5.27u as=1.235p ps=5.27u w=4.75u l=0.5u
X878 xl1.d2b xl1.d2a VDD VDD pfet_03v3 ad=0.481p pd=2.37u as=0.481p ps=2.37u w=1.85u l=0.28u
X879 VSS VSS VSS VSS nfet_03v3 ad=0.52p pd=2.52u as=0 ps=0 w=2u l=0.5u
X880 xl2.xpre.tn vbn VSS VSS nfet_03v3 ad=0.65p pd=3.02u as=0.65p ps=3.02u w=2.5u l=1u
X881 VDD VDD xl2.xout.n3a VDD pfet_03v3 ad=0.814p pd=4.58u as=0.481p ps=2.37u w=1.85u l=0.28u
X882 xl2.xpre.fb vbn VSS VSS nfet_03v3 ad=0.65p pd=3.02u as=0.65p ps=3.02u w=2.5u l=1u
X883 xl2.d2b VDD VDD VDD pfet_03v3 ad=0.52p pd=2.52u as=0.88p ps=4.88u w=2u l=0.5u
X884 VSS vbn xl1.xhyst.ts VSS nfet_03v3 ad=0.65p pd=3.02u as=0.65p ps=3.02u w=2.5u l=1u
X885 xl1.xpre.fa xl1.gp xl1.xpre.tp xl1.xpre.tp pfet_03v3 ad=1.248p pd=5.32u as=1.248p ps=5.32u w=4.8u l=0.4u
X886 VDD xbias.enb xbias.nrb VDD pfet_03v3 ad=1.3p pd=5.52u as=1.3p ps=5.52u w=5u l=0.5u
X887 VDD VDD xbias.nrb VDD pfet_03v3 ad=2.2p pd=10.88u as=1.3p ps=5.52u w=5u l=0.5u
X888 VSS VSS xl2.xout.d3 VSS nfet_03v3 ad=2.0504p pd=10.2u as=1.2116p ps=5.18u w=4.66u l=0.28u
X889 vb2 VSS VSS VSS nfet_03v3 ad=0.52p pd=2.52u as=0.88p ps=4.88u w=2u l=0.5u
X890 xl0.xpre.fb vbn VSS VSS nfet_03v3 ad=0.65p pd=3.02u as=0.65p ps=3.02u w=2.5u l=1u
X891 vref xbias.rdt_m3 VSS ppolyf_u_1k r_width=2u r_length=21.01u
X892 xl0.xpre.fb vref xl0.xpre.tp xl0.xpre.tp pfet_03v3 ad=1.248p pd=5.32u as=1.248p ps=5.32u w=4.8u l=0.4u
X893 xl1.xpre.fb vref xl1.xpre.tp xl1.xpre.tp pfet_03v3 ad=1.248p pd=5.32u as=1.248p ps=5.32u w=4.8u l=0.4u
X894 xl2.xpre.tp xl2.gn xl2.xpre.fb xl2.xpre.tp pfet_03v3 ad=1.248p pd=5.32u as=1.248p ps=5.32u w=4.8u l=0.4u
X895 xl1.ob xl1.gn xl1.xpre.tn VSS nfet_03v3 ad=1.235p pd=5.27u as=1.235p ps=5.27u w=4.75u l=0.5u
X896 VDD xl0.d2a xl0.d2b VDD pfet_03v3 ad=0.481p pd=2.37u as=0.481p ps=2.37u w=1.85u l=0.28u
X897 VDD xbias.enb xbias.nrb VDD pfet_03v3 ad=1.3p pd=5.52u as=1.3p ps=5.52u w=5u l=0.5u
X898 xl2.oa vref xl2.xpre.tn VSS nfet_03v3 ad=1.235p pd=5.27u as=1.235p ps=5.27u w=4.75u l=0.5u
X899 xl1.d2a xl1.oa xl1.xhyst.sa VSS nfet_03v3 ad=1.1362p pd=4.89u as=1.1362p ps=4.89u w=4.37u l=0.5u
X900 VDD vbp xl0.xpre.tp VDD pfet_03v3 ad=1.3p pd=5.52u as=1.3p ps=5.52u w=5u l=1u
X901 xl1.xpre.tp xl1.gp xl1.xpre.fa xl1.xpre.tp pfet_03v3 ad=1.248p pd=5.32u as=1.248p ps=5.32u w=4.8u l=0.4u
X902 xl0.xpre.tn vref xl0.oa VSS nfet_03v3 ad=1.235p pd=5.27u as=1.235p ps=5.27u w=4.75u l=0.5u
X903 VSS vbn xl1.xpre.tn VSS nfet_03v3 ad=0.65p pd=3.02u as=0.65p ps=3.02u w=2.5u l=1u
X904 xl1.ob xl1.gn xl1.xpre.tn VSS nfet_03v3 ad=1.235p pd=5.27u as=1.235p ps=5.27u w=4.75u l=0.5u
X905 vbn VSS VSS VSS nfet_03v3 ad=0.65p pd=3.02u as=1.1p ps=5.88u w=2.5u l=1u
X906 VDD vbp xl1.xpre.tp VDD pfet_03v3 ad=1.3p pd=5.52u as=1.3p ps=5.52u w=5u l=1u
X907 xl2.xpre.fb vref xl2.xpre.tp xl2.xpre.tp pfet_03v3 ad=1.248p pd=5.32u as=1.248p ps=5.32u w=4.8u l=0.4u
X908 VSS vbn xl2.xpre.fa VSS nfet_03v3 ad=0.65p pd=3.02u as=0.65p ps=3.02u w=2.5u l=1u
X909 VDD xl2.d2b xl2.d2a VDD pfet_03v3 ad=0.481p pd=2.37u as=0.481p ps=2.37u w=1.85u l=0.28u
X910 xl0.xout.n3a xl0.d2a VDD VDD pfet_03v3 ad=0.481p pd=2.37u as=0.481p ps=2.37u w=1.85u l=0.28u
X911 VSS VSS VSS ppolyf_u_1k r_width=2u r_length=9.11u
X912 vbp vbp VDD VDD pfet_03v3 ad=1.3p pd=5.52u as=1.3p ps=5.52u w=5u l=1u
X913 xl2.xout.nm xl2.xout.d3 xl2.xout.nd VSS nfet_03v3 ad=0.52p pd=2.52u as=0.52p ps=2.52u w=2u l=0.28u
X914 xl2.xout.i2 VDD VDD VDD pfet_03v3 ad=0.975p pd=4.27u as=1.65p ps=8.38u w=3.75u l=0.28u
X915 xl0.xpre.tp vbp VDD VDD pfet_03v3 ad=1.3p pd=5.52u as=1.3p ps=5.52u w=5u l=1u
X916 xl1.xout.n3a xl1.d2a VDD VDD pfet_03v3 ad=0.481p pd=2.37u as=0.481p ps=2.37u w=1.85u l=0.28u
X917 VDD xl0.d2a xl0.d2a VDD pfet_03v3 ad=0.481p pd=2.37u as=0.481p ps=2.37u w=1.85u l=0.28u
X918 xl0.xpre.fb xl0.gn xl0.xpre.tp xl0.xpre.tp pfet_03v3 ad=1.248p pd=5.32u as=1.248p ps=5.32u w=4.8u l=0.4u
X919 xl1.xpre.fa vbn VSS VSS nfet_03v3 ad=0.65p pd=3.02u as=0.65p ps=3.02u w=2.5u l=1u
X920 xl0.xpre.tn vref xl0.ob VSS nfet_03v3 ad=1.235p pd=5.27u as=1.235p ps=5.27u w=4.75u l=0.5u
X921 xl1.oa xl1.gp xl1.xpre.tn VSS nfet_03v3 ad=1.235p pd=5.27u as=1.235p ps=5.27u w=4.75u l=0.5u
X922 VSS xl0.xout.n3a xl0.xout.n3a VSS nfet_03v3 ad=1.2116p pd=5.18u as=1.2116p ps=5.18u w=4.66u l=0.28u
X923 xl1.xpre.fa vb2 xl1.oa VSS nfet_03v3 ad=1.1752p pd=5.04u as=1.1752p ps=5.04u w=4.52u l=0.5u
X924 xl0.xpre.fa xl0.gp xl0.xpre.tp xl0.xpre.tp pfet_03v3 ad=1.248p pd=5.32u as=1.248p ps=5.32u w=4.8u l=0.4u
X925 xl1.xpre.tp vref xl1.xpre.fa xl1.xpre.tp pfet_03v3 ad=1.248p pd=5.32u as=1.248p ps=5.32u w=4.8u l=0.4u
X926 xl2.xpre.tp vref xl2.xpre.fa xl2.xpre.tp pfet_03v3 ad=1.248p pd=5.32u as=1.248p ps=5.32u w=4.8u l=0.4u
X927 xl1.xpre.tn vbn VSS VSS nfet_03v3 ad=0.65p pd=3.02u as=0.65p ps=3.02u w=2.5u l=1u
X928 xl0.xpre.tp xl0.gn xl0.xpre.fb xl0.xpre.tp pfet_03v3 ad=1.248p pd=5.32u as=1.248p ps=5.32u w=4.8u l=0.4u
X929 xl1.d2b xl1.d2a VDD VDD pfet_03v3 ad=0.481p pd=2.37u as=0.481p ps=2.37u w=1.85u l=0.28u
X930 VDD vbp xl2.xpre.tp VDD pfet_03v3 ad=1.3p pd=5.52u as=1.3p ps=5.52u w=5u l=1u
X931 xl2.xpre.fb xl2.gn xl2.xpre.tp xl2.xpre.tp pfet_03v3 ad=1.248p pd=5.32u as=1.248p ps=5.32u w=4.8u l=0.4u
X932 xl1.xpre.fa vb2 xl1.oa VSS nfet_03v3 ad=1.1752p pd=5.04u as=1.1752p ps=5.04u w=4.52u l=0.5u
X933 xl2.xpre.tn VSS VSS VSS nfet_03v3 ad=0.65p pd=3.02u as=1.1p ps=5.88u w=2.5u l=1u
X934 VDD VDD xl2.xpre.tp VDD pfet_03v3 ad=2.2p pd=10.88u as=1.3p ps=5.52u w=5u l=1u
X935 xl2.xpre.tp vref xl2.xpre.fa xl2.xpre.tp pfet_03v3 ad=1.248p pd=5.32u as=1.248p ps=5.32u w=4.8u l=0.4u
X936 VDD VDD xl1.xout.i2 VDD pfet_03v3 ad=1.65p pd=8.38u as=0.975p ps=4.27u w=3.75u l=0.28u
X937 xl0.gn RX0_N VDD ppolyf_u r_width=5u r_length=1.8u
X938 xl2.xpre.tn xl2.gp xl2.oa VSS nfet_03v3 ad=1.235p pd=5.27u as=1.235p ps=5.27u w=4.75u l=0.5u
X939 VDD xl1.d2b xl1.xout.d3 VDD pfet_03v3 ad=0.481p pd=2.37u as=0.481p ps=2.37u w=1.85u l=0.28u
X940 VDD xl1.rla_m1 VSS ppolyf_u_1k r_width=2u r_length=9.11u
X941 VSS vbn xl0.xpre.fb VSS nfet_03v3 ad=0.65p pd=3.02u as=0.65p ps=3.02u w=2.5u l=1u
X942 xl0.xout.nd EN VDD VDD pfet_03v3 ad=0.78p pd=3.52u as=0.78p ps=3.52u w=3u l=0.28u
X943 xl1.d2a xl1.d2a VDD VDD pfet_03v3 ad=0.481p pd=2.37u as=0.481p ps=2.37u w=1.85u l=0.28u
X944 VSS vbn xl1.xpre.fa VSS nfet_03v3 ad=0.65p pd=3.02u as=0.65p ps=3.02u w=2.5u l=1u
X945 VDD xl2.d2b xl2.xout.d3 VDD pfet_03v3 ad=0.481p pd=2.37u as=0.481p ps=2.37u w=1.85u l=0.28u
X946 vbn vbn VSS VSS nfet_03v3 ad=0.65p pd=3.02u as=0.65p ps=3.02u w=2.5u l=1u
X947 xl2.d2a xl2.d2b VDD VDD pfet_03v3 ad=0.481p pd=2.37u as=0.481p ps=2.37u w=1.85u l=0.28u
X948 VDD xl0.d2b xl0.xout.d3 VDD pfet_03v3 ad=0.481p pd=2.37u as=0.481p ps=2.37u w=1.85u l=0.28u
X949 xl1.xpre.tp vref xl1.xpre.fb xl1.xpre.tp pfet_03v3 ad=1.248p pd=5.32u as=2.112p ps=10.48u w=4.8u l=0.4u
X950 xl1.xpre.fa xl1.gp xl1.xpre.tp xl1.xpre.tp pfet_03v3 ad=1.248p pd=5.32u as=1.248p ps=5.32u w=4.8u l=0.4u
X951 xl1.xpre.tp vbp VDD VDD pfet_03v3 ad=1.3p pd=5.52u as=1.3p ps=5.52u w=5u l=1u
X952 vbp vbp VDD VDD pfet_03v3 ad=1.3p pd=5.52u as=1.3p ps=5.52u w=5u l=1u
X953 xl2.xpre.fa vref xl2.xpre.tp xl2.xpre.tp pfet_03v3 ad=1.248p pd=5.32u as=1.248p ps=5.32u w=4.8u l=0.4u
X954 xl2.xpre.fb vbn VSS VSS nfet_03v3 ad=0.65p pd=3.02u as=0.65p ps=3.02u w=2.5u l=1u
X955 xl2.xpre.tp vbp VDD VDD pfet_03v3 ad=1.3p pd=5.52u as=1.3p ps=5.52u w=5u l=1u
X956 xl2.xpre.fa xl2.gp xl2.xpre.tp xl2.xpre.tp pfet_03v3 ad=1.248p pd=5.32u as=1.248p ps=5.32u w=4.8u l=0.4u
X957 xl2.xpre.tn xl2.gp xl2.oa VSS nfet_03v3 ad=1.235p pd=5.27u as=1.235p ps=5.27u w=4.75u l=0.5u
X958 xl0.xpre.tp vbp VDD VDD pfet_03v3 ad=1.3p pd=5.52u as=1.3p ps=5.52u w=5u l=1u
X959 VDD VDD VDD VDD pfet_03v3 ad=0.52p pd=2.52u as=0 ps=0 w=2u l=0.5u
X960 VDD xl1.d2b xl1.d2a VDD pfet_03v3 ad=0.481p pd=2.37u as=0.481p ps=2.37u w=1.85u l=0.28u
X961 xl1.xpre.tp vref xl1.xpre.fb xl1.xpre.tp pfet_03v3 ad=1.248p pd=5.32u as=1.248p ps=5.32u w=4.8u l=0.4u
X962 xl2.xpre.tn xl2.gp xl2.oa VSS nfet_03v3 ad=1.235p pd=5.27u as=1.235p ps=5.27u w=4.75u l=0.5u
X963 VDD VDD VDD VDD pfet_03v3 ad=0.814p pd=4.58u as=0 ps=0 w=1.85u l=0.28u
X964 vbp vbp VDD VDD pfet_03v3 ad=1.3p pd=5.52u as=1.3p ps=5.52u w=5u l=1u
X965 xl0.xpre.tp xl0.gp xl0.xpre.fa xl0.xpre.tp pfet_03v3 ad=1.248p pd=5.32u as=1.248p ps=5.32u w=4.8u l=0.4u
X966 xl2.xpre.fa xl2.gp xl2.xpre.tp xl2.xpre.tp pfet_03v3 ad=1.248p pd=5.32u as=1.248p ps=5.32u w=4.8u l=0.4u
X967 VSS VSS xl2.xpre.fa VSS nfet_03v3 ad=1.1p pd=5.88u as=0.65p ps=3.02u w=2.5u l=1u
X968 xl0.xpre.fb vref xl0.xpre.tp xl0.xpre.tp pfet_03v3 ad=1.248p pd=5.32u as=1.248p ps=5.32u w=4.8u l=0.4u
X969 xl1.xpre.fb vref xl1.xpre.tp xl1.xpre.tp pfet_03v3 ad=1.248p pd=5.32u as=1.248p ps=5.32u w=4.8u l=0.4u
X970 xl0.ob xl0.gn xl0.xpre.tn VSS nfet_03v3 ad=1.235p pd=5.27u as=1.235p ps=5.27u w=4.75u l=0.5u
X971 VSS vbn xl2.xpre.tn VSS nfet_03v3 ad=0.65p pd=3.02u as=0.65p ps=3.02u w=2.5u l=1u
X972 xl1.xout.d3 xl1.d2b VDD VDD pfet_03v3 ad=0.481p pd=2.37u as=0.481p ps=2.37u w=1.85u l=0.28u
X973 xl1.xpre.tp vref xl1.xpre.fb xl1.xpre.tp pfet_03v3 ad=1.248p pd=5.32u as=1.248p ps=5.32u w=4.8u l=0.4u
X974 xl2.xpre.tp xl2.gn xl2.xpre.fb xl2.xpre.tp pfet_03v3 ad=1.248p pd=5.32u as=1.248p ps=5.32u w=4.8u l=0.4u
X975 vbp VDD VDD VDD pfet_03v3 ad=0.52p pd=2.52u as=0.88p ps=4.88u w=2u l=0.5u
X976 xl2.xpre.tn xl2.gn xl2.ob VSS nfet_03v3 ad=1.235p pd=5.27u as=1.235p ps=5.27u w=4.75u l=0.5u
X977 VDD xl1.d2b xl1.d2b VDD pfet_03v3 ad=0.481p pd=2.37u as=0.481p ps=2.37u w=1.85u l=0.28u
X978 VDD vbp xl2.xpre.tp VDD pfet_03v3 ad=1.3p pd=5.52u as=1.3p ps=5.52u w=5u l=1u
X979 xl2.xout.d3 xl2.d2b VDD VDD pfet_03v3 ad=0.481p pd=2.37u as=0.481p ps=2.37u w=1.85u l=0.28u
D11 VSS xl1.gp diode_nd2ps_03v3 pj=26u area=40p
X980 xl2.xpre.fb xl2.gn xl2.xpre.tp xl2.xpre.tp pfet_03v3 ad=1.248p pd=5.32u as=1.248p ps=5.32u w=4.8u l=0.4u
X981 VSS VSS xl2.xpre.fb VSS nfet_03v3 ad=1.9888p pd=9.92u as=1.1752p ps=5.04u w=4.52u l=0.5u
X982 xl0.oa xl0.gp xl0.xpre.tn VSS nfet_03v3 ad=1.235p pd=5.27u as=1.235p ps=5.27u w=4.75u l=0.5u
X983 xl2.xout.n3a VSS VSS VSS nfet_03v3 ad=1.2116p pd=5.18u as=2.0504p ps=10.2u w=4.66u l=0.28u
X984 VSS VSS xl2.d2a VSS nfet_03v3 ad=1.9228p pd=9.62u as=1.1362p ps=4.89u w=4.37u l=0.5u
X985 xl0.xpre.fa vb2 xl0.oa VSS nfet_03v3 ad=1.1752p pd=5.04u as=1.1752p ps=5.04u w=4.52u l=0.5u
X986 xl1.xpre.fb vbn VSS VSS nfet_03v3 ad=0.65p pd=3.02u as=0.65p ps=3.02u w=2.5u l=1u
X987 xl0.d2b VSS VSS VSS nfet_03v3 ad=1.1362p pd=4.89u as=1.9228p ps=9.62u w=4.37u l=0.5u
X988 xl0.xpre.tp vref xl0.xpre.fa xl0.xpre.tp pfet_03v3 ad=1.248p pd=5.32u as=1.248p ps=5.32u w=4.8u l=0.4u
X989 VSS vbn xl0.xpre.fb VSS nfet_03v3 ad=0.65p pd=3.02u as=0.65p ps=3.02u w=2.5u l=1u
X990 xl2.oa vref xl2.xpre.tn VSS nfet_03v3 ad=1.235p pd=5.27u as=1.235p ps=5.27u w=4.75u l=0.5u
X991 xl0.xpre.tn vref xl0.ob VSS nfet_03v3 ad=1.235p pd=5.27u as=1.235p ps=5.27u w=4.75u l=0.5u
X992 xl2.xhyst.ts vbn VSS VSS nfet_03v3 ad=0.65p pd=3.02u as=0.65p ps=3.02u w=2.5u l=1u
X993 VDD vbp vbp VDD pfet_03v3 ad=1.3p pd=5.52u as=1.3p ps=5.52u w=5u l=1u
X994 xl2.xpre.tp xl2.gn xl2.xpre.fb xl2.xpre.tp pfet_03v3 ad=1.248p pd=5.32u as=1.248p ps=5.32u w=4.8u l=0.4u
X995 xl0.xpre.fa vb2 xl0.oa VSS nfet_03v3 ad=1.1752p pd=5.04u as=1.1752p ps=5.04u w=4.52u l=0.5u
X996 VDD VDD VDD VDD pfet_03v3 ad=0.65p pd=3.02u as=0 ps=0 w=2.5u l=0.28u
X997 VDD xl0.rlb_m1 VSS ppolyf_u_1k r_width=2u r_length=9.11u
X998 xl0.gp RX0_P VDD ppolyf_u r_width=5u r_length=1.8u
X999 VDD vbp xl2.xpre.tp VDD pfet_03v3 ad=1.3p pd=5.52u as=1.3p ps=5.52u w=5u l=1u
X1000 xl2.xpre.fb xl2.gn xl2.xpre.tp xl2.xpre.tp pfet_03v3 ad=1.248p pd=5.32u as=1.248p ps=5.32u w=4.8u l=0.4u
X1001 xl1.xpre.tn xl1.gp xl1.oa VSS nfet_03v3 ad=1.235p pd=5.27u as=1.235p ps=5.27u w=4.75u l=0.5u
X1002 VDD vbp xl0.xpre.tp VDD pfet_03v3 ad=1.3p pd=5.52u as=1.3p ps=5.52u w=5u l=1u
X1003 xl2.ob vref xl2.xpre.tn VSS nfet_03v3 ad=1.235p pd=5.27u as=1.235p ps=5.27u w=4.75u l=0.5u
X1004 VSS vbn xl1.xpre.fb VSS nfet_03v3 ad=0.65p pd=3.02u as=0.65p ps=3.02u w=2.5u l=1u
X1005 xl2.d2b xl2.d2b VDD VDD pfet_03v3 ad=0.481p pd=2.37u as=0.481p ps=2.37u w=1.85u l=0.28u
X1006 VDD xl0.d2a xl0.xout.n3a VDD pfet_03v3 ad=0.481p pd=2.37u as=0.481p ps=2.37u w=1.85u l=0.28u
X1007 xl0.xpre.fb vb2 xl0.ob VSS nfet_03v3 ad=1.1752p pd=5.04u as=1.1752p ps=5.04u w=4.52u l=0.5u
X1008 xl1.xpre.tn xl1.gn xl1.ob VSS nfet_03v3 ad=1.235p pd=5.27u as=1.235p ps=5.27u w=4.75u l=0.5u
X1009 xl2.oa vref xl2.xpre.tn VSS nfet_03v3 ad=1.235p pd=5.27u as=1.235p ps=5.27u w=4.75u l=0.5u
X1010 VDD xl2.d2a xl2.d2a VDD pfet_03v3 ad=0.481p pd=2.37u as=0.481p ps=2.37u w=1.85u l=0.28u
X1011 vbn vbn VSS VSS nfet_03v3 ad=0.65p pd=3.02u as=0.65p ps=3.02u w=2.5u l=1u
X1012 xl0.xpre.tp vref xl0.xpre.fa xl0.xpre.tp pfet_03v3 ad=1.248p pd=5.32u as=1.248p ps=5.32u w=4.8u l=0.4u
X1013 xl1.xpre.tp xl1.gp xl1.xpre.fa xl1.xpre.tp pfet_03v3 ad=1.248p pd=5.32u as=1.248p ps=5.32u w=4.8u l=0.4u
X1014 xl0.xhyst.ts vbn VSS VSS nfet_03v3 ad=0.65p pd=3.02u as=0.65p ps=3.02u w=2.5u l=1u
X1015 xl1.xout.nm xl1.xout.d3 xl1.xout.nd VSS nfet_03v3 ad=0.52p pd=2.52u as=0.52p ps=2.52u w=2u l=0.28u
X1016 xl2.xpre.tp vbp VDD VDD pfet_03v3 ad=1.3p pd=5.52u as=1.3p ps=5.52u w=5u l=1u
X1017 RX1_O xl1.xout.i2 VSS VSS nfet_03v3 ad=1.04p pd=4.52u as=1.04p ps=4.52u w=4u l=0.28u
X1018 xl1.xpre.tn vref xl1.ob VSS nfet_03v3 ad=1.235p pd=5.27u as=1.235p ps=5.27u w=4.75u l=0.5u
X1019 xl2.xpre.tp vbp VDD VDD pfet_03v3 ad=1.3p pd=5.52u as=1.3p ps=5.52u w=5u l=1u
X1020 xl0.xpre.tp vref xl0.xpre.fb xl0.xpre.tp pfet_03v3 ad=1.248p pd=5.32u as=1.248p ps=5.32u w=4.8u l=0.4u
X1021 xl2.xpre.fa xl2.gp xl2.xpre.tp xl2.xpre.tp pfet_03v3 ad=1.248p pd=5.32u as=1.248p ps=5.32u w=4.8u l=0.4u
X1022 xl1.xpre.fb xl1.gn xl1.xpre.tp xl1.xpre.tp pfet_03v3 ad=1.248p pd=5.32u as=1.248p ps=5.32u w=4.8u l=0.4u
X1023 xl0.xpre.fa vbn VSS VSS nfet_03v3 ad=0.65p pd=3.02u as=0.65p ps=3.02u w=2.5u l=1u
X1024 VDD xbias.enb xbias.nrb VDD pfet_03v3 ad=1.3p pd=5.52u as=1.3p ps=5.52u w=5u l=0.5u
X1025 xl2.ob vref xl2.xpre.tn VSS nfet_03v3 ad=2.09p pd=10.38u as=1.235p ps=5.27u w=4.75u l=0.5u
X1026 xl2.xout.n3a xl2.d2a VDD VDD pfet_03v3 ad=0.481p pd=2.37u as=0.481p ps=2.37u w=1.85u l=0.28u
X1027 VDD xl0.d2b xl0.xout.d3 VDD pfet_03v3 ad=0.481p pd=2.37u as=0.481p ps=2.37u w=1.85u l=0.28u
X1028 VSS vbn xl2.xhyst.ts VSS nfet_03v3 ad=0.65p pd=3.02u as=0.65p ps=3.02u w=2.5u l=1u
X1029 xl1.oa xl1.gp xl1.xpre.tn VSS nfet_03v3 ad=1.235p pd=5.27u as=1.235p ps=5.27u w=4.75u l=0.5u
X1030 VDD EN xl2.d2a VDD pfet_03v3 ad=0.52p pd=2.52u as=0.52p ps=2.52u w=2u l=0.5u
X1031 xl0.xpre.tp xl0.gn xl0.xpre.fb xl0.xpre.tp pfet_03v3 ad=1.248p pd=5.32u as=1.248p ps=5.32u w=4.8u l=0.4u
X1032 xl1.xpre.tp xl1.gn xl1.xpre.fb xl1.xpre.tp pfet_03v3 ad=1.248p pd=5.32u as=1.248p ps=5.32u w=4.8u l=0.4u
X1033 VDD xl1.xout.i2 RX1_O VDD pfet_03v3 ad=1.3p pd=5.52u as=1.3p ps=5.52u w=5u l=0.28u
X1034 VDD vbp xl2.xpre.tp VDD pfet_03v3 ad=1.3p pd=5.52u as=1.3p ps=5.52u w=5u l=1u
X1035 vbp vbp VDD VDD pfet_03v3 ad=1.3p pd=5.52u as=1.3p ps=5.52u w=5u l=1u
X1036 xl1.xpre.fb vref xl1.xpre.tp xl1.xpre.tp pfet_03v3 ad=1.248p pd=5.32u as=1.248p ps=5.32u w=4.8u l=0.4u
X1037 xl2.xpre.tp xl2.gn xl2.xpre.fb xl2.xpre.tp pfet_03v3 ad=1.248p pd=5.32u as=1.248p ps=5.32u w=4.8u l=0.4u
X1038 xl1.xpre.tp vbp VDD VDD pfet_03v3 ad=1.3p pd=5.52u as=1.3p ps=5.52u w=5u l=1u
X1039 VSS vbn xl0.xpre.tn VSS nfet_03v3 ad=0.65p pd=3.02u as=0.65p ps=3.02u w=2.5u l=1u
X1040 VSS VSS VSS ppolyf_u_1k r_width=5u r_length=1.64u
X1041 xl2.xhyst.ts vbn VSS VSS nfet_03v3 ad=0.65p pd=3.02u as=0.65p ps=3.02u w=2.5u l=1u
X1042 xl0.xpre.tn vref xl0.oa VSS nfet_03v3 ad=1.235p pd=5.27u as=1.235p ps=5.27u w=4.75u l=0.5u
X1043 xl2.xpre.fb vref xl2.xpre.tp xl2.xpre.tp pfet_03v3 ad=2.112p pd=10.48u as=1.248p ps=5.32u w=4.8u l=0.4u
X1044 xl0.xhyst.ts VSS VSS VSS nfet_03v3 ad=0.65p pd=3.02u as=1.1p ps=5.88u w=2.5u l=1u
X1045 xl2.xpre.fb xl2.gn xl2.xpre.tp xl2.xpre.tp pfet_03v3 ad=1.248p pd=5.32u as=1.248p ps=5.32u w=4.8u l=0.4u
X1046 VDD VDD VDD VDD pfet_03v3 ad=0.962p pd=4.22u as=0 ps=0 w=3.7u l=0.28u
C0 VDD xl0.gp 4.52291f
C1 vb2 vbp 5.49406f
C2 EN xl1.d2b 0.31138f
C3 xl2.d2a xl2.xout.d3 0.63055f
C4 EN xl1.xout.nm 0.02238f
C5 xl2.oa xl2.xpre.fa 2.94526f
C6 vbp RX1_P 0.03967f
C7 xbias.vf xbias.rb_m2 0.08519f
C8 xl0.xhyst.sa xl0.d2a 1.67001f
C9 xl1.ob vb2 0.58885f
C10 xl0.xpre.tp vref 14.9051f
C11 xl1.ob xl1.xpre.fb 2.91705f
C12 xl1.xhyst.sa xl1.rlb_m1 0
C13 xl1.xpre.tn xl1.gp 1.20295f
C14 xl2.xpre.tn xl2.oa 9.87791f
C15 vbn xl0.gn 0.27781f
C16 VDD RX0_O 3.99882f
C17 xl0.xout.nm xl0.xout.nd 0.2193f
C18 xl0.ob xl0.oa 0.59251f
C19 VDD RX2_N 2.56543f
C20 xl2.xout.nm EN 0.02238f
C21 vb2 xl1.xpre.fb 2.09462f
C22 xl0.oa xl0.xpre.tn 9.87791f
C23 EN vbp 0.30881f
C24 RX0_N VDD 2.56543f
C25 xl0.ob xl0.xpre.fb 2.91705f
C26 xl2.ob VDD 1.95948f
C27 xl0.xhyst.sb xl0.xhyst.ts 0.20041f
C28 vbn xl0.gp 0.57567f
C29 xl1.gn xl1.gp 2.07546f
C30 xl1.xpre.fa xl1.xpre.tp 25.37f
C31 EN xl2.d2b 0.31138f
C32 xl2.xout.i1 xl2.xout.nd 0.21598f
C33 xl0.gn vref 2.83689f
C34 xl1.rla_m1 xl1.rlb_m1 0.39394f
C35 RX0_P VDD 2.27023f
C36 xl0.xhyst.sa xl0.ob 0.00738f
C37 EN vb2 2.209f
C38 vbn xbias.rb_m2 0.03909f
C39 VDD xl0.oa 1.56447f
C40 xl2.d2a xl2.xhyst.sa 1.67001f
C41 xl2.xout.n3a xl2.xout.d3 0.46613f
C42 xl0.gp vref 2.30895f
C43 xl1.xpre.tn xl1.oa 9.87791f
C44 xl1.xout.i1 RX1_O 0
C45 xl0.xpre.tp xl0.xpre.fa 25.37f
C46 xl1.xout.i1 xl1.xout.nd 0.21598f
C47 xl2.ob xl2.gp 0.36334f
C48 xl0.d2b xl0.xout.d3 0.22886f
C49 xbias.rdt_m1 xbias.rdb_m3 0.41833f
C50 VDD xl1.d2b 10.8442f
C51 vbn xl1.xpre.fa 2.18465f
C52 vbn xl2.ob 0.17663f
C53 xl1.xout.n3a xl1.d2b 0.17133f
C54 xbias.rdt_m1 xbias.rdt_m3 0.08167f
C55 RX1_N VDD 2.56543f
C56 xl2.gn RX2_N 0.14621f
C57 xl1.gn xl1.oa 0.30476f
C58 EN RX2_O 0.005f
C59 xl2.ob xl2.gn 1.01627f
C60 xl0.d2a EN 0.19588f
C61 xl0.d2b xl0.xhyst.sb 0.68313f
C62 xl0.ob vb2 0.58885f
C63 vbn xl0.oa 0.31902f
C64 xl0.gn xl0.xpre.fa 0.66886f
C65 xbias.vf vbp 0.19894f
C66 xl1.xpre.fa vref 2.48886f
C67 xl2.ob vref 2.70252f
C68 vbn xl0.xpre.fb 1.50358f
C69 vbp VDD 0.11403p
C70 vbp xl1.xpre.tp 3.37779f
C71 xbias.nrb xbias.rb_m2 0.03837f
C72 xl0.xpre.fa xl0.gp 2.42263f
C73 xbias.rb_m1 vbp 0
C74 VDD xl2.d2b 10.8442f
C75 xl1.ob VDD 1.95948f
C76 vref xl0.oa 2.14744f
C77 xbias.vf vb2 0.92426f
C78 xl1.d2a xl1.oa 0.16422f
C79 vb2 VDD 6.74394f
C80 xl0.xpre.fb vref 2.62815f
C81 xl1.gp xl1.oa 1.26032f
C82 RX0_O xl0.xout.i1 0
C83 xl2.d2a xl2.d2b 4.0714f
C84 xl0.xout.n3a xl0.d2b 0.17133f
C85 xl2.gp vbp 0.26446f
C86 vb2 xl1.xpre.tp 0.05309f
C87 VDD RX1_P 2.27847f
C88 xl1.xpre.tp xl1.xpre.fb 25.7432f
C89 vbn vbp 7.55653f
C90 xl1.d2a xl1.xout.d3 0.63055f
C91 vbp xbias.nmid 0.03404f
C92 EN xl0.xout.nd 0.90578f
C93 xl2.ob xl2.xpre.fa 0
C94 xl2.ob xl2.xpre.fb 2.91705f
C95 vbp xl2.gn 0.26446f
C96 xbias.vf EN 0.02265f
C97 RX2_O VDD 4.00067f
C98 xl1.xout.i2 xl1.xout.i1 0.28557f
C99 xl1.ob vbn 0.17663f
C100 EN VDD 63.801f
C101 xl1.xout.d3 xl1.xout.nd 0.22426f
C102 vb2 xl2.gp 0.04355f
C103 xl0.d2a VDD 12.736f
C104 EN xl1.xout.n3a 0.00401f
C105 vbn vb2 0.60206f
C106 xl2.xpre.tn xl2.ob 9.55392f
C107 vbp vref 0.06866f
C108 xl2.xhyst.ts VDD 0.60574f
C109 xl0.xpre.fa xl0.oa 2.94526f
C110 xl0.ob xl0.xpre.tn 9.55392f
C111 vbn xl1.xpre.fb 1.50358f
C112 xbias.rb_m1 EN 0.00905f
C113 vb2 xbias.nmid 0.91956f
C114 EN xl2.d2a 0.19588f
C115 xl0.xpre.fb xl0.xpre.fa 0.8011f
C116 xl0.xout.n3a xl0.xout.d3 0.46613f
C117 vb2 xl2.gn 0.04523f
C118 xl1.ob vref 2.70252f
C119 vbp xl2.xpre.tp 3.37779f
C120 xl1.xpre.fa xl1.gn 0.66886f
C121 xbias.rb_m3 xbias.rb_m1 0.06955f
C122 xl2.d2b xl2.xout.n3a 0.17133f
C123 vb2 vref 24.575f
C124 xl1.xout.i2 RX1_O 0.50509f
C125 xbias.nrb vbp 0.36239f
C126 xl0.xhyst.sa xl0.xhyst.ts 0.13628f
C127 RX0_O xl0.xout.i2 0.50501f
C128 vref xl1.xpre.fb 2.62815f
C129 vbn EN 0.42317f
C130 xl0.ob VDD 1.95948f
C131 VDD xl0.xpre.tn 0.2078f
C132 EN xbias.nmid 0.59891f
C133 vbn xl2.xhyst.ts 1.02135f
C134 vb2 xl2.xpre.tp 0.05309f
C135 xbias.nrb vb2 0.03524f
C136 xl2.xout.i2 RX2_O 0.50509f
C137 VDD xl0.xout.nd 2.7235f
C138 xl2.xout.i2 EN 0.31277f
C139 xl1.xhyst.ts xl1.xhyst.sa 0.13628f
C140 xl1.xhyst.sa xl1.d2a 1.67001f
C141 xbias.vf VDD 0.00294f
C142 RX1_N xl1.gn 0.14621f
C143 EN xl2.xout.n3a 0.00401f
C144 xl2.xhyst.ts vref 0.00271f
C145 VDD xl1.xout.n3a 4.03663f
C146 xl1.xpre.fa xl1.gp 2.42263f
C147 xl0.rla_m1 xl0.d2b 0.00423f
C148 xl2.xout.i1 RX2_O 0
C149 xl2.oa xl2.ob 0.59251f
C150 xl0.ob vbn 0.17663f
C151 xl1.xpre.tp VDD 11.3411f
C152 vb2 xl0.xpre.fa 1.71129f
C153 xl2.xout.i1 EN 0.26447f
C154 vbn xl0.xpre.tn 0.82513f
C155 xl2.xpre.fa vb2 1.71129f
C156 vb2 xl2.xpre.fb 2.09462f
C157 VDD xl2.d2a 12.736f
C158 xl0.xpre.tp xl0.gn 13.4751f
C159 xl2.oa xl2.xhyst.sa 0.14911f
C160 xl0.xout.d3 xl0.xout.nm 0.01765f
C161 xbias.enb vbp 1.14704f
C162 xl1.ob xl1.xpre.tn 9.55392f
C163 xbias.nrb EN 0.24322f
C164 xl0.xhyst.sa xl0.d2b 0.20987f
C165 vbp xl1.gn 0.26446f
C166 xl2.rla_m1 xl2.rlb_m1 0.39394f
C167 xl1.d2a xl1.rla_m1 0
C168 xl1.xhyst.ts xl1.xhyst.sb 0.20041f
C169 xl0.xpre.tp xl0.gp 12.8915f
C170 xl0.ob vref 2.70252f
C171 xl2.gp VDD 4.52291f
C172 xl1.d2a xl1.d2b 4.0714f
C173 xl2.xout.nd xl2.xout.d3 0.22426f
C174 vbn xbias.vf 1.55879f
C175 vref xl0.xpre.tn 1.62411f
C176 EN xl0.xout.i1 0.26447f
C177 xl1.ob xl1.gn 1.01627f
C178 vbn VDD 3.79441f
C179 xbias.enb vb2 2.1266f
C180 xl1.xpre.fa xl1.oa 2.94526f
C181 xl1.xhyst.sa xl1.oa 0.14911f
C182 VDD xbias.nmid 0.17518f
C183 vb2 xl1.gn 0.04523f
C184 vbp RX2_P 0.03967f
C185 VDD xl2.gn 4.52025f
C186 xl1.gn xl1.xpre.fb 2.60941f
C187 xl1.xout.nd xl1.xout.nm 0.2193f
C188 xbias.enb xbias.rdt_m1 0.0052f
C189 xl0.gn xl0.gp 2.07546f
C190 VDD vref 3.50102f
C191 xl2.xout.i2 VDD 4.28491f
C192 vbn xl2.gp 0.57567f
C193 vbp xl1.gp 0.26446f
C194 xl1.xpre.tp vref 14.9051f
C195 VDD xl2.xout.n3a 4.03663f
C196 xbias.enb EN 4.07467f
C197 VDD xbias.rdb_m2 0.00594f
C198 xl2.xpre.tp VDD 11.3411f
C199 xl0.ob xl0.xpre.fa 0
C200 xl2.xout.i1 VDD 2.62233f
C201 xl2.rla_m1 xl2.xhyst.sa 0.30587f
C202 xl2.gp xl2.gn 2.07546f
C203 vbn xbias.nmid 0.11617f
C204 xl1.ob xl1.gp 0.36334f
C205 xl2.d2a xl2.xout.n3a 0.2367f
C206 xbias.vf xbias.nrb 0.61512f
C207 vbn xl2.gn 0.27781f
C208 xl0.xhyst.sa xl0.xhyst.sb 1.08061f
C209 xbias.nrb VDD 5.10108f
C210 RX0_N xl0.gn 0.14621f
C211 xl0.d2b EN 0.31138f
C212 xl0.xpre.tp xl0.xpre.fb 25.7432f
C213 xl1.xout.i1 EN 0.26447f
C214 xl0.d2a xl0.d2b 4.0714f
C215 vb2 xl1.gp 0.04355f
C216 xl2.gp vref 2.30895f
C217 xl2.oa vb2 0.59315f
C218 xl0.xout.i1 xl0.xout.nd 0.21598f
C219 EN xl0.xout.i2 0.31277f
C220 xl1.gp xl1.xpre.fb 0.89735f
C221 vbn vref 2.80537f
C222 xl1.xout.d3 xl1.d2b 0.22886f
C223 xl1.xout.d3 xl1.xout.nm 0.01765f
C224 RX1_P xl1.gp 0.14621f
C225 VDD xl0.xout.i1 2.62233f
C226 vref xbias.nmid 0.97574f
C227 VDD xl0.xhyst.ts 0.60574f
C228 xl2.rlb_m1 xl2.xhyst.sa 0
C229 xl2.gp xl2.xpre.tp 12.8915f
C230 xl2.gn vref 2.83689f
C231 xl1.d2a EN 0.19588f
C232 xbias.rdb_m2 xbias.nmid 0.04228f
C233 xl0.gn xl0.oa 0.30476f
C234 xl2.xhyst.sb xl2.ob 0.20964f
C235 xl0.xpre.fb xl0.gn 2.60941f
C236 xl1.ob xl1.oa 0.59251f
C237 vbn xbias.nrb 0.04433f
C238 RX0_P xl0.gp 0.14621f
C239 xl2.xpre.tp xl2.gn 13.4751f
C240 xl2.xpre.tn VDD 0.2078f
C241 xl1.xpre.tn VDD 0.2078f
C242 xl2.xhyst.sb xl2.xhyst.sa 1.08061f
C243 EN RX1_O 0.00492f
C244 xl0.xpre.tp vbp 3.37779f
C245 EN xl1.xout.nd 0.90578f
C246 xl0.ob xl0.d2b 0.16374f
C247 xl0.gp xl0.oa 1.26032f
C248 vb2 xl1.oa 0.59315f
C249 EN xl0.xout.d3 0.4675f
C250 xl0.xpre.fb xl0.gp 0.89735f
C251 xl0.d2a xl0.xout.d3 0.63055f
C252 xbias.enb xbias.vf 1.18587f
C253 vref xbias.rdb_m2 0.32236f
C254 xl2.xpre.tp vref 14.9051f
C255 xbias.enb VDD 6.07982f
C256 xl2.xpre.fa xl2.gp 2.42263f
C257 xl2.gp xl2.xpre.fb 0.89735f
C258 xl2.xout.nm xl2.xout.nd 0.2193f
C259 xl2.xout.i2 xl2.xout.i1 0.28557f
C260 vbn xl0.xhyst.ts 1.02135f
C261 xl1.gn VDD 4.52025f
C262 vbn xl0.xpre.fa 2.18465f
C263 vbn xl2.xpre.fa 2.18465f
C264 vbn xl2.xpre.fb 1.50358f
C265 xl2.rla_m1 xl2.d2b 0.00423f
C266 xl1.xpre.tp xl1.gn 13.4751f
C267 xbias.enb xbias.rb_m1 0
C268 xl0.xpre.tp vb2 0.05309f
C269 xl2.ob xl2.xhyst.sa 0.00738f
C270 xl2.xpre.tn xl2.gp 1.20295f
C271 xl2.xpre.fa xl2.gn 0.66886f
C272 xl2.xpre.fb xl2.gn 2.60941f
C273 vbp xl0.gn 0.26446f
C274 xl0.d2b VDD 10.8442f
C275 xl1.xout.i1 VDD 2.62233f
C276 xl2.xout.nm xl2.xout.d3 0.01765f
C277 vbn xl2.xpre.tn 0.82513f
C278 vbn xl1.xpre.tn 0.82513f
C279 VDD xl0.xout.i2 4.28491f
C280 RX2_P VDD 2.27847f
C281 vref xl0.xhyst.ts 0.00271f
C282 xl0.xpre.fa vref 2.48886f
C283 xl2.xpre.fa vref 2.48886f
C284 xl2.xpre.fb vref 2.62815f
C285 xl1.xhyst.sa xl1.rla_m1 0.30587f
C286 vbp xl0.gp 0.26446f
C287 xl1.xhyst.sb xl1.xhyst.sa 1.08061f
C288 xl2.xpre.tn xl2.gn 0.99696f
C289 vbn xbias.enb 0.30834f
C290 xl2.d2b xl2.xout.d3 0.22886f
C291 xl1.xhyst.sa xl1.d2b 0.20987f
C292 vbn xl1.gn 0.27781f
C293 EN xl1.xout.d3 0.4675f
C294 xbias.enb xbias.nmid 0.71708f
C295 vb2 xl0.gn 0.04523f
C296 xl1.xhyst.ts VDD 0.60574f
C297 VDD xbias.rdt_m2 0.00209f
C298 xl1.d2a VDD 12.736f
C299 xl2.xpre.fa xl2.xpre.tp 25.37f
C300 xl2.xpre.tp xl2.xpre.fb 25.7432f
C301 xl1.d2a xl1.xout.n3a 0.2367f
C302 xl2.xpre.tn vref 1.62411f
C303 xl1.xpre.tn vref 1.62411f
C304 VDD xl1.gp 4.52291f
C305 xl2.oa VDD 1.56447f
C306 xl0.xout.n3a EN 0.00401f
C307 xl0.xout.d3 xl0.xout.nd 0.22426f
C308 xl0.d2a xl0.xout.n3a 0.2367f
C309 xl2.xout.nd EN 0.90578f
C310 xl0.ob xl0.xhyst.sb 0.20964f
C311 vb2 xl0.gp 0.04355f
C312 xl2.xhyst.sb xl2.d2b 0.68313f
C313 VDD RX1_O 4.00061f
C314 xl1.xpre.tp xl1.gp 12.8915f
C315 xl2.gp RX2_P 0.14621f
C316 VDD xl1.xout.nd 2.7235f
C317 vbp RX2_N 0.03712f
C318 xbias.enb vref 0.19826f
C319 vbp RX0_N 0.03712f
C320 VDD xl0.xout.d3 4.26183f
C321 xl1.gn vref 2.83689f
C322 xl2.oa xl2.d2a 0.16422f
C323 xl1.rla_m1 xl1.d2b 0.00423f
C324 xl1.xhyst.sb xl1.d2b 0.68313f
C325 xl0.xhyst.sa xl0.oa 0.14911f
C326 EN xl2.xout.d3 0.4675f
C327 xl1.xout.i2 EN 0.31277f
C328 xl2.xpre.fa xl2.xpre.fb 0.8011f
C329 vbn xl1.xhyst.ts 1.02135f
C330 xl1.ob xl1.xpre.fa 0
C331 xl1.ob xl1.xhyst.sa 0.00738f
C332 xl2.ob xl2.d2b 0.16374f
C333 xl0.xhyst.sa xl0.rla_m1 0.30587f
C334 xl2.oa xl2.gp 1.26032f
C335 RX0_P vbp 0.03875f
C336 xbias.enb xbias.nrb 0.83214f
C337 xbias.rdt_m2 xbias.nmid 0.00432f
C338 vbn xl1.gp 0.57567f
C339 vbn xl2.oa 0.31902f
C340 xl1.xpre.fa vb2 1.71129f
C341 VDD xl1.oa 1.56447f
C342 xl2.d2b xl2.xhyst.sa 0.20987f
C343 xl2.ob vb2 0.58885f
C344 xl1.xpre.fa xl1.xpre.fb 0.8011f
C345 xl2.oa xl2.gn 0.30476f
C346 xbias.rdb_m1 xbias.rdt_m3 0.22342f
C347 xl2.xhyst.sb xl2.xhyst.ts 0.20041f
C348 xl1.xhyst.ts vref 0.00271f
C349 vref xbias.rdt_m2 0.00293f
C350 RX1_N vbp 0.03712f
C351 EN RX0_O 1.94682f
C352 VDD xl1.xout.d3 4.26183f
C353 xl0.xpre.tp VDD 11.3411f
C354 xl0.ob xl0.gn 1.01627f
C355 vref xl1.gp 2.30895f
C356 xl1.xout.n3a xl1.xout.d3 0.46613f
C357 xl1.ob xl1.xhyst.sb 0.20964f
C358 vb2 xl0.oa 0.59315f
C359 xl0.gn xl0.xpre.tn 0.99696f
C360 xl2.oa vref 2.14744f
C361 xl1.ob xl1.d2b 0.16374f
C362 xbias.rdt_m2 xbias.rdb_m2 0.37f
C363 xl0.xpre.fb vb2 2.09462f
C364 EN xl0.xout.nm 0.02238f
C365 xl0.rla_m1 xl0.rlb_m1 0.39394f
C366 xl0.xout.n3a VDD 4.03663f
C367 xl0.ob xl0.gp 0.36334f
C368 xl2.xout.nd VDD 2.7235f
C369 xl0.gp xl0.xpre.tn 1.20295f
C370 vbn xl1.oa 0.31902f
C371 xl1.xpre.tn xl1.gn 0.99696f
C372 xl2.rla_m1 xl2.d2a 0
C373 xl0.xout.i1 xl0.xout.i2 0.28557f
C374 xl0.xhyst.sa xl0.rlb_m1 0
C375 xl2.xhyst.ts xl2.xhyst.sa 0.13628f
C376 xl0.gn VDD 4.52025f
C377 xl0.d2a xl0.oa 0.16422f
C378 VDD xl2.xout.d3 4.26183f
C379 xl1.xout.i2 VDD 4.28491f
C380 xbias.rb_m3 xbias.rf_m1 0.04347f
C381 vref xl1.oa 2.14744f
C382 xl0.rla_m1 xl0.d2a 0
C383 RX2_O VSS 18.8961f
C384 RX1_O VSS 11.8271f
C385 RX0_O VSS 11.1616f
C386 EN VSS 37.639f
C387 RX2_N VSS 3.34389f
C388 RX2_P VSS 3.63059f
C389 RX1_N VSS 3.34389f
C390 RX1_P VSS 3.63059f
C391 RX0_N VSS 3.34389f
C392 RX0_P VSS 3.63059f
C393 VDD VSS 0.73679p
C394 xbias.vf VSS 3.00974f
C395 xbias.rb_m3 VSS 1.32997f
C396 xbias.rb_m2 VSS 1.18202f
C397 xbias.rb_m1 VSS 1.29823f
C398 xbias.rf_m1 VSS 1.40226f
C399 xbias.nrb VSS 1.8844f
C400 xl2.xout.i2 VSS 4.24421f
C401 xl2.xout.i1 VSS 3.72118f
C402 xl2.xout.nm VSS 0.31567f
C403 xl2.xout.nd VSS 3.35368f
C404 xl1.xout.i2 VSS 4.24421f
C405 xl1.xout.i1 VSS 3.72118f
C406 xl1.xout.nm VSS 0.31567f
C407 xl1.xout.nd VSS 3.35368f
C408 xl0.xout.i2 VSS 4.24421f
C409 xl0.xout.i1 VSS 3.72118f
C410 xl0.xout.nm VSS 0.31567f
C411 xl0.xout.nd VSS 3.35368f
C412 xl2.xout.d3 VSS 4.52287f
C413 xl2.xout.n3a VSS 3.27138f
C414 xl1.xout.d3 VSS 4.52287f
C415 xl1.xout.n3a VSS 3.27138f
C416 xl0.xout.d3 VSS 4.52287f
C417 xl0.xout.n3a VSS 3.27138f
C418 xbias.rdb_m1 VSS 1.12023f
C419 xbias.rdt_m3 VSS 1.81265f
C420 xbias.rdb_m2 VSS 1.69441f
C421 xbias.rdb_m3 VSS 1.13703f
C422 xbias.rdt_m1 VSS 1.66241f
C423 xbias.rdt_m2 VSS 1.18196f
C424 xbias.nmid VSS 4.17509f
C425 xl2.xhyst.sb VSS 3.38771f
C426 xl2.d2b VSS 4.93292f
C427 xl2.rlb_m1 VSS 1.11225f
C428 xl2.rla_m1 VSS 1.48222f
C429 xl2.xhyst.sa VSS 5.03563f
C430 xl2.d2a VSS 4.01425f
C431 xl1.xhyst.sb VSS 3.38771f
C432 xl1.d2b VSS 4.93292f
C433 xl1.rlb_m1 VSS 1.11225f
C434 xl1.rla_m1 VSS 1.48222f
C435 xl1.xhyst.sa VSS 5.03563f
C436 xl1.d2a VSS 4.01425f
C437 xl0.xhyst.sb VSS 3.38771f
C438 xl0.d2b VSS 4.93292f
C439 xl0.rlb_m1 VSS 1.11225f
C440 xl0.rla_m1 VSS 1.48222f
C441 xl0.xhyst.sa VSS 5.03563f
C442 xl0.d2a VSS 4.01425f
C443 xl2.xhyst.ts VSS 8.96904f
C444 xl2.xpre.tn VSS 4.38184f
C445 xl1.xhyst.ts VSS 8.96904f
C446 xl1.xpre.tn VSS 4.38184f
C447 xl0.xhyst.ts VSS 8.96904f
C448 xl0.xpre.tn VSS 4.38184f
C449 xbias.enb VSS 8.45551f
C450 xl2.ob VSS 6.96006f
C451 xl2.oa VSS 7.17837f
C452 xl1.ob VSS 6.96006f
C453 xl1.oa VSS 7.17837f
C454 xl0.ob VSS 6.96006f
C455 vbn VSS 0.17612p
C456 xl0.oa VSS 7.17837f
C457 xl2.xpre.fa VSS 9.29453f
C458 xl2.xpre.fb VSS 8.10808f
C459 xl1.xpre.fa VSS 9.29453f
C460 xl1.xpre.fb VSS 8.10808f
C461 xl0.xpre.fa VSS 9.29453f
C462 xl0.xpre.fb VSS 8.10808f
C463 vref VSS 58.372f
C464 vb2 VSS 40.4227f
C465 xl2.gn VSS 13.2934f
C466 xl2.gp VSS 13.3739f
C467 xl1.gn VSS 13.2934f
C468 xl1.gp VSS 13.3739f
C469 xl0.gn VSS 13.2934f
C470 vbp VSS 20.9164f
C471 xl0.gp VSS 13.3739f
C472 xl2.xpre.tp VSS 0.1029p
C473 xl1.xpre.tp VSS 0.1029p
C474 xl0.xpre.tp VSS 0.1029p
.ends lvds_rx_x3
