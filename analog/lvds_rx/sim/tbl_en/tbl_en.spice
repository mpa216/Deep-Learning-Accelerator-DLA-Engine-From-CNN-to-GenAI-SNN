* tbl_en: post-layout variant of sim/tb8_en/tb8_en.spice (T11, gate TBL), GENERATED by sim/tbl/make_benches.py: the core include is a variable and a .save line keeps only the vectors the control section reads.
* tb8_en: EN and supply-ramp behaviour of two three-lane copies of the macro, one bias per copy (task T4, PLAN_V2 TB8).
* The body (supplies, EN, pin drivers, copies, .param tstop_run tmax_run) is generated by hooks.py:prep into body.inc for the grid value `case`.
* rshunt is set in body.inc: 1e13 in case 0 (the EN = 0 supply current must not be the shunt current), 1e11 elsewhere (1e13 hung ngspice in the powered cases).
{header}
{seed_line}
.include {deck_dir}/../../sizing/sizes.spice
.include {deck_dir}/../../{core}
.include {run_dir}/body.inc
.tran 50p {tstop_run} 0 {tmax_run}
.save v(rx0_o_a) v(rx1_o_a) v(rx2_o_a) v(rx0_o_b) v(rx1_o_b) v(rx2_o_b) i(Vsa) i(Vsb) v(vdda)
.control
run
wrdata tb8.txt v(rx0_o_a) v(rx1_o_a) v(rx2_o_a) v(rx0_o_b) v(rx1_o_b) v(rx2_o_b) i(Vsa) i(Vsb) v(vdda)
.endc
.end
