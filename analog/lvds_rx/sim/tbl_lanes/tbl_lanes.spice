* tbl_lanes: post-layout variant of sim/tb10_lanes/tb10_lanes.spice (T11, gate TBL), GENERATED by sim/tbl/make_benches.py: the core include is a variable and a .save line keeps only the vectors the control section reads.
* tb10_lanes: the full three-lane macro with CLK / D0 / D1 patterns: lane-to-lane skew, crosstalk jitter (shared bias and supply), mismatch spread of the lane delay (task T4, PLAN_V2 TB10).
* The body (supplies, drivers, input networks, macro copies, the mismatch wrapper for mc3s = 1) is generated by hooks.py:prep into body.inc.
{header}
{seed_line}
.option rshunt=1e11
.include {deck_dir}/../../sizing/sizes.spice
.include {deck_dir}/../../{core}
.include {deck_dir}/../../netlist/pad_asig_5p0.spice
.include {deck_dir}/../../netlist/input_network.spice
.include {run_dir}/body.inc
.save v(rx0_o_a) v(rx1_o_a) v(rx2_o_a) v(rx0_o_b0) v(rx1_o_b0) v(rx2_o_b0) v(rx0_o_b1) v(rx1_o_b1) v(rx2_o_b1) v(rx0_o_b2) v(rx1_o_b2) v(rx2_o_b2) v(rx0_o_m0) v(rx1_o_m0) v(rx2_o_m0) v(rx0_o_m1) v(rx1_o_m1) v(rx2_o_m1) v(rx0_o_m2) v(rx1_o_m2) v(rx2_o_m2) v(rx0_o_m3) v(rx1_o_m3) v(rx2_o_m3)
.control
tran 25p {tstop} 0 50p
wrdata tb10.txt v(rx0_o_a) v(rx1_o_a) v(rx2_o_a) v(rx0_o_b0) v(rx1_o_b0) v(rx2_o_b0) v(rx0_o_b1) v(rx1_o_b1) v(rx2_o_b1) v(rx0_o_b2) v(rx1_o_b2) v(rx2_o_b2) v(rx0_o_m0) v(rx1_o_m0) v(rx2_o_m0) v(rx0_o_m1) v(rx1_o_m1) v(rx2_o_m1) v(rx0_o_m2) v(rx1_o_m2) v(rx2_o_m2) v(rx0_o_m3) v(rx1_o_m3) v(rx2_o_m3)
.endc
.end
