* C: 200 Mb/s alternating, VOD 0.35 V, lvds_input_network_esd, 300 fF differential load, tt 27C
* ---- GF180 corner header: tt (generated by sim/env/gf180_corners.py) ----
.param sw_stat_global=0 sw_stat_mismatch=0 mc_skew=3 res_mc_skew=3 cap_mc_skew=3 fnoicor=0
.lib /foss/pdks/gf180mcuD/libs.tech/ngspice/sm141064.ngspice typical
.lib /foss/pdks/gf180mcuD/libs.tech/ngspice/sm141064.ngspice res_typical
.lib /foss/pdks/gf180mcuD/libs.tech/ngspice/sm141064.ngspice moscap_typical
.lib /foss/pdks/gf180mcuD/libs.tech/ngspice/sm141064.ngspice diode_typical
* ---- end header (add .temp and the supply yourself) ----
.temp 27
.include netlist/pad_asig_5p0.spice
.include netlist/input_network.spice
vdd dvdd 0 dc 3.3
xd srcp srcn lvds_drv_pulse VOS=1.2 VOD=0.35 TR=0.5n TD=1n HALF=5e-09
xn srcp srcn rxp rxn dvdd 0 lvds_input_network_esd LPKG=3e-09 CPKG=7e-13
cl rxp rxn 3e-13
.control
tran 5p 8.6e-08
wrdata work/C_tran_tt_27_200M_350mV_esd.txt v(rxp) v(rxn) v(xn.xf.bp) v(xn.xf.bn) v(xn.padp) v(xn.padn)
.endc
.end
