* TB0 pad deck tt 27C DVDD=3.3
* ---- GF180 corner header: tt (generated by sim/env/gf180_corners.py) ----
.param sw_stat_global=0 sw_stat_mismatch=0 mc_skew=3 res_mc_skew=3 cap_mc_skew=3 fnoicor=0
.lib /foss/pdks/gf180mcuD/libs.tech/ngspice/sm141064.ngspice typical
.lib /foss/pdks/gf180mcuD/libs.tech/ngspice/sm141064.ngspice res_typical
.lib /foss/pdks/gf180mcuD/libs.tech/ngspice/sm141064.ngspice moscap_typical
.lib /foss/pdks/gf180mcuD/libs.tech/ngspice/sm141064.ngspice diode_typical
* ---- end header (add .temp and the supply yourself) ----
.temp 27
.option abstol=1e-15 gmin=1e-15 reltol=1e-4
.include netlist/pad_asig_5p0.spice
vdd dvdd 0 dc 3.3
vp pin 0 dc 1.2 ac 1
xpad pin dvdd 0 dvdd 0 gf180mcu_fd_io__asig_5p0
.control
op
echo RESULT idc $&i(vp)
ac dec 10 1e6 1e10
wrdata work/ac_tt_27_1.20.txt i(vp)
.endc
.end
