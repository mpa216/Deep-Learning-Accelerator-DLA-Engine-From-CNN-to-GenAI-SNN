* t2_ac: stage-1 gain (oa - ob) per unit differential input at VID = 0, and its -3 dB frequency.  GENERATED by sim/t2_op/make_deck.py -- do not edit.
{header}
{seed_line}
.option rshunt=1e11
.include {deck_dir}/../../sizing/sizes.spice
.include {deck_dir}/../../netlist/lvds_rx_core.spice
Vsup vdd 0 {vdd}
Ben en 0 V=1*v(vdd)
Bcm cm 0 V={vic}*v(vdd)/{vdd}
Vp0 rx0_p cm dc 0 ac 0.5
Vn0 rx0_n cm dc 0 ac -0.5
Vp1 rx1_p cm dc 0
Vn1 rx1_n cm dc 0
Vp2 rx2_p cm dc 0
Vn2 rx2_n cm dc 0
Xdut vdd 0 rx0_p rx0_n rx1_p rx1_n rx2_p rx2_n en rx0_o rx1_o rx2_o lvds_rx_x3
.control
dc Vsup 0.3 {vdd} 0.1
ac dec 20 1e6 3e9
let g = mag(v(xdut.xl0.ob) - v(xdut.xl0.oa))
let a1 = g[0]
let thr = a1 / 1.41421356
let n = length(g)
let fr = frequency
let k = 0
let f3 = 3e9
let found = 0
while k < n - 1
  if found = 0
    if g[k+1] < thr
      let f3 = fr[k] * exp(ln(fr[k+1] / fr[k]) * (g[k] - thr) / (g[k] - g[k+1]))
      let found = 1
    end
  end
  let k = k + 1
end
echo RESULT a1 $&a1
echo RESULT f3db $&f3
echo RESULT f3db_found $&found
.endc
.end
