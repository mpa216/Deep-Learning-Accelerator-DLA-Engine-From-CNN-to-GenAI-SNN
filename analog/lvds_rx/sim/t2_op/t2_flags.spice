* t2_flags: does the netlist run with the build flags switched?  GENERATED by sim/t2_op/make_deck.py -- do not edit.
{header}
{seed_line}
.option rshunt=1e11
.param vicv = {vic}
.param vidv = {vid}
.include {deck_dir}/../../sizing/sizes.spice
.param flag_nmos_pair = {nmos}
.param flag_dump_devices = {dump}
.include {deck_dir}/../../netlist/lvds_rx_core.spice
Vsup vdd 0 {vdd}
Ben en 0 V=1*v(vdd)
Bcm cm 0 V={vic}*v(vdd)/{vdd}
Vp0 rx0_p cm dc {vidv/2}
Vn0 rx0_n cm dc {-vidv/2}
Vp1 rx1_p cm dc 0
Vn1 rx1_n cm dc 0
Vp2 rx2_p cm dc 0
Vn2 rx2_n cm dc 0
Xdut vdd 0 rx0_p rx0_n rx1_p rx1_n rx2_p rx2_n en rx0_o rx1_o rx2_o lvds_rx_x3
.control
dc Vsup 0.3 {vdd} 0.1
let n = length(v(vdd)) - 1
let ivv = -i(Vsup)
let idd = ivv[n]
echo RESULT idd $&idd
let vv = v(rx0_o)[n]
echo RESULT v_rx0_o $&vv
let vv = v(xdut.xl0.oa)[n]
echo RESULT v_oa $&vv
let vv = v(xdut.xl0.ob)[n]
echo RESULT v_ob $&vv
let vv = v(xdut.xl0.d2a)[n]
echo RESULT v_d2a $&vv
let vv = v(xdut.xl0.d2b)[n]
echo RESULT v_d2b $&vv
.endc
.end
