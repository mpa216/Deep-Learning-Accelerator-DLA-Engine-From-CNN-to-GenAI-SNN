* tbl_trip: post-layout variant of sim/tb3_trip/tb3_trip.spice (T11, gate TBL), GENERATED by sim/tbl/make_benches.py: the core include is a variable and a .save line keeps only the vectors the control section reads.
* tb3_trip: trip points and hysteresis of lane 0 by DC sweeps, hysteresis ON (task T3, PLAN_V2 TB3, finding C5).
* Method: ONE `dc` sweep of a dummy variable Vs does everything, because plain `op` does not converge on this circuit (log/T2_report.md):
*   phase 1 (Vs 0 -> sr, at most 16.5 mV): the supply ramps 0.3 V -> final VDD (200 V per V of Vs), EN and the common mode follow it; VID rests at its start value
*   phase 2: VID goes start -> opposite end -> back to start (triangle, steps of 0.1 mV of VID inside +-40 mV), so BOTH trip points come out of one
*            continuous sweep with no delay error.  sweep = 0: starts at -150 mV (up first); sweep = 1: starts at +150 mV (down first).
* The sweep is repeated at the final supply 3.0 V and 3.6 V (same process/temperature) for the supply sensitivity (dvh_dvdd, dvtrip_dvdd).
* Grid: vic, sweep.  Hooks: hooks.py:post_tb3 (trip points from the wrdata files).
{header}
{seed_line}
.option rshunt=1e11
.include {deck_dir}/../../sizing/sizes.spice
.include {deck_dir}/../../{core}
Vs r 0 0
Vcl vcl 0 {vdd}
* supply ramp then clamp; EN and the common mode follow the (clamped) supply
Bv vdd 0 V=min(0.3+200*v(r), v(vcl))
Ben en 0 V=1*v(vdd)
Bcm cm 0 V={vic}*min(1, v(vdd)/3.0)
* u = Vs minus the end of the supply ramp.  w(u) is a triangle -W -> +W -> -W (W = 51 mV); vid = w stretched x10 beyond |w| = 40 mV, so the sweep
* covers +-150 mV but moves in 0.1 mV steps inside +-40 mV where the trip points are.  sweep = 1 mirrors the sign.
Bw w 0 V=-{wmax}*((v(r)-(v(vcl)-0.3)/200) < 0 ? 1 : ((v(r)-(v(vcl)-0.3)/200) < 2*{wmax} ? (1 - (v(r)-(v(vcl)-0.3)/200)/{wmax}) : (-3 + (v(r)-(v(vcl)-0.3)/200)/{wmax})))
Bvid vid 0 V=(1-2*{sweep})*(v(w)+9*(max(v(w)-0.04,0)-max(-v(w)-0.04,0)))
Bp0 rx0_p cm V=v(vid)/2
Bn0 rx0_n cm V=-v(vid)/2
Vp1 rx1_p cm dc 0
Vn1 rx1_n cm dc 0
Vp2 rx2_p cm dc 0
Vn2 rx2_n cm dc 0
Xdut vdd 0 rx0_p rx0_n rx1_p rx1_n rx2_p rx2_n en rx0_o rx1_o rx2_o lvds_rx_x3
cl rx0_o 0 30f
.save v(vid) v(rx0_o) v(vdd)
.control
set wr_singlescale
dc Vs 0 0.222 0.0001
wrdata trip_nom.txt v(vid) v(rx0_o) v(vdd)
alter Vcl dc = 3.0
dc Vs 0 0.222 0.0001
wrdata trip_v30.txt v(vid) v(rx0_o) v(vdd)
alter Vcl dc = 3.6
dc Vs 0 0.222 0.0001
wrdata trip_v36.txt v(vid) v(rx0_o) v(vdd)
.endc
.end
