* HASH sizing_script=e5f91f6fb1a22094e8ad08afecbdbcacdbab025f05c651d9ea8b1eda2ed1c2a8 luts=6974093a0dba8868
* tb_spike_H1: stage-1 spike, variant H1 (hybrid + dump devices (candidate)).  GENERATED by sizing/spike_stage1.py -- do not edit.
* one run = one (corner, VIC) point: op (currents, saturation margins) + ac (differential gain, -3 dB frequency)
{header}
{seed_line}
.include {run_dir}/ibs.inc
.param vddv = {vdd}
Vsup vdd 0 {vdd}
Vcm cm 0 dc {vic}
Vip inp cm dc 0 ac 0.5
Vin inn cm dc 0 ac -0.5
* ---- load resistors (ppolyf_u_1k, body VSS), W=2u L=16.5u -> 8442 ohm at tt/27C
XRLa vdd oa 0 ppolyf_u_1k r_width=2u r_length=16.5u
XRLb vdd ob 0 ppolyf_u_1k r_width=2u r_length=16.5u
* ---- PMOS path: tail, pair (own n-well = tail node), fold nodes fa/fb, NMOS cascodes M5 into oa/ob, sinks M3
XMpt tp vbp vdd vdd pfet_03v3 L=1u W=90u nf=18 ad='int((nf+1)/2) * W/nf * 0.18u' as='int((nf+2)/2) * W/nf * 0.18u' pd='2*int((nf+1)/2) * (W/nf + 0.18u)' ps='2*int((nf+2)/2) * (W/nf + 0.18u)' nrd='0.18u / W' nrs='0.18u / W' sa=0 sb=0 sd=0
XMp1 fa inp tp tp pfet_03v3 L=0.4u W=99.58u nf=20 ad='int((nf+1)/2) * W/nf * 0.18u' as='int((nf+2)/2) * W/nf * 0.18u' pd='2*int((nf+1)/2) * (W/nf + 0.18u)' ps='2*int((nf+2)/2) * (W/nf + 0.18u)' nrd='0.18u / W' nrs='0.18u / W' sa=0 sb=0 sd=0
XMp2 fb inn tp tp pfet_03v3 L=0.4u W=99.58u nf=20 ad='int((nf+1)/2) * W/nf * 0.18u' as='int((nf+2)/2) * W/nf * 0.18u' pd='2*int((nf+1)/2) * (W/nf + 0.18u)' ps='2*int((nf+2)/2) * (W/nf + 0.18u)' nrd='0.18u / W' nrs='0.18u / W' sa=0 sb=0 sd=0
XMpd1 fa vref tp tp pfet_03v3 L=0.4u W=99.58u nf=20 ad='int((nf+1)/2) * W/nf * 0.18u' as='int((nf+2)/2) * W/nf * 0.18u' pd='2*int((nf+1)/2) * (W/nf + 0.18u)' ps='2*int((nf+2)/2) * (W/nf + 0.18u)' nrd='0.18u / W' nrs='0.18u / W' sa=0 sb=0 sd=0
XMpd2 fb vref tp tp pfet_03v3 L=0.4u W=99.58u nf=20 ad='int((nf+1)/2) * W/nf * 0.18u' as='int((nf+2)/2) * W/nf * 0.18u' pd='2*int((nf+1)/2) * (W/nf + 0.18u)' ps='2*int((nf+2)/2) * (W/nf + 0.18u)' nrd='0.18u / W' nrs='0.18u / W' sa=0 sb=0 sd=0
XM3a fa vbn 0 0 nfet_03v3 L=1u W=25u nf=10 ad='int((nf+1)/2) * W/nf * 0.18u' as='int((nf+2)/2) * W/nf * 0.18u' pd='2*int((nf+1)/2) * (W/nf + 0.18u)' ps='2*int((nf+2)/2) * (W/nf + 0.18u)' nrd='0.18u / W' nrs='0.18u / W' sa=0 sb=0 sd=0
XM3b fb vbn 0 0 nfet_03v3 L=1u W=25u nf=10 ad='int((nf+1)/2) * W/nf * 0.18u' as='int((nf+2)/2) * W/nf * 0.18u' pd='2*int((nf+1)/2) * (W/nf + 0.18u)' ps='2*int((nf+2)/2) * (W/nf + 0.18u)' nrd='0.18u / W' nrs='0.18u / W' sa=0 sb=0 sd=0
XM5a oa vb2 fa 0 nfet_03v3 L=0.5u W=15.36u nf=4 ad='int((nf+1)/2) * W/nf * 0.18u' as='int((nf+2)/2) * W/nf * 0.18u' pd='2*int((nf+1)/2) * (W/nf + 0.18u)' ps='2*int((nf+2)/2) * (W/nf + 0.18u)' nrd='0.18u / W' nrs='0.18u / W' sa=0 sb=0 sd=0
XM5b ob vb2 fb 0 nfet_03v3 L=0.5u W=15.36u nf=4 ad='int((nf+1)/2) * W/nf * 0.18u' as='int((nf+2)/2) * W/nf * 0.18u' pd='2*int((nf+1)/2) * (W/nf + 0.18u)' ps='2*int((nf+2)/2) * (W/nf + 0.18u)' nrd='0.18u / W' nrs='0.18u / W' sa=0 sb=0 sd=0
* ---- NMOS path: tail, pair drains straight into the RL nodes, dump twins gated by Vref
XMnt tn vbn 0 0 nfet_03v3 L=1u W=20u nf=8 ad='int((nf+1)/2) * W/nf * 0.18u' as='int((nf+2)/2) * W/nf * 0.18u' pd='2*int((nf+1)/2) * (W/nf + 0.18u)' ps='2*int((nf+2)/2) * (W/nf + 0.18u)' nrd='0.18u / W' nrs='0.18u / W' sa=0 sb=0 sd=0
XMn1 oa inp tn 0 nfet_03v3 L=0.5u W=34.35u nf=7 ad='int((nf+1)/2) * W/nf * 0.18u' as='int((nf+2)/2) * W/nf * 0.18u' pd='2*int((nf+1)/2) * (W/nf + 0.18u)' ps='2*int((nf+2)/2) * (W/nf + 0.18u)' nrd='0.18u / W' nrs='0.18u / W' sa=0 sb=0 sd=0
XMn2 ob inn tn 0 nfet_03v3 L=0.5u W=34.35u nf=7 ad='int((nf+1)/2) * W/nf * 0.18u' as='int((nf+2)/2) * W/nf * 0.18u' pd='2*int((nf+1)/2) * (W/nf + 0.18u)' ps='2*int((nf+2)/2) * (W/nf + 0.18u)' nrd='0.18u / W' nrs='0.18u / W' sa=0 sb=0 sd=0
XMnd1 oa vref tn 0 nfet_03v3 L=0.5u W=34.35u nf=7 ad='int((nf+1)/2) * W/nf * 0.18u' as='int((nf+2)/2) * W/nf * 0.18u' pd='2*int((nf+1)/2) * (W/nf + 0.18u)' ps='2*int((nf+2)/2) * (W/nf + 0.18u)' nrd='0.18u / W' nrs='0.18u / W' sa=0 sb=0 sd=0
XMnd2 ob vref tn 0 nfet_03v3 L=0.5u W=34.35u nf=7 ad='int((nf+1)/2) * W/nf * 0.18u' as='int((nf+2)/2) * W/nf * 0.18u' pd='2*int((nf+1)/2) * (W/nf + 0.18u)' ps='2*int((nf+2)/2) * (W/nf + 0.18u)' nrd='0.18u / W' nrs='0.18u / W' sa=0 sb=0 sd=0
* ---- ideal bias: reference currents into diode-connected replicas (mirror ratios are real); ibs = corner scale
Ibn vdd vbn dc {1.20815e-05*ibs}
XMbn vbn vbn 0 0 nfet_03v3 L=1u W=2.5u nf=1 ad='int((nf+1)/2) * W/nf * 0.18u' as='int((nf+2)/2) * W/nf * 0.18u' pd='2*int((nf+1)/2) * (W/nf + 0.18u)' ps='2*int((nf+2)/2) * (W/nf + 0.18u)' nrd='0.18u / W' nrs='0.18u / W' sa=0 sb=0 sd=0
Ibp vbp 0 dc {5.6323e-06*ibs}
XMbp vbp vbp vdd vdd pfet_03v3 L=1u W=5u nf=1 ad='int((nf+1)/2) * W/nf * 0.18u' as='int((nf+2)/2) * W/nf * 0.18u' pd='2*int((nf+1)/2) * (W/nf + 0.18u)' ps='2*int((nf+2)/2) * (W/nf + 0.18u)' nrd='0.18u / W' nrs='0.18u / W' sa=0 sb=0 sd=0
Ib2 vdd vb2 dc {7.01245e-05*ibs}
XMb2 vb2 vb2 vf 0 nfet_03v3 L=0.5u W=15.36u nf=4 ad='int((nf+1)/2) * W/nf * 0.18u' as='int((nf+2)/2) * W/nf * 0.18u' pd='2*int((nf+1)/2) * (W/nf + 0.18u)' ps='2*int((nf+2)/2) * (W/nf + 0.18u)' nrd='0.18u / W' nrs='0.18u / W' sa=0 sb=0 sd=0
Vf vf 0 dc 0.45
Vref vref 0 dc {0.48*vddv}
Cla oa 0 3e-14
Clb ob 0 3e-14
.control
op
let cm = (v(oa)+v(ob))/2
let vod = v(ob)-v(oa)
let idd = -i(Vsup)
echo RESULT cm $&cm
echo RESULT vod_dc $&vod
echo RESULT idd $&idd
echo RESULT vfa $&v(fa)
echo RESULT vfb $&v(fb)
echo RESULT vtp $&v(tp)
echo RESULT vtn $&v(tn)
echo RESULT vbn $&v(vbn)
echo RESULT vbp $&v(vbp)
echo RESULT vb2 $&v(vb2)
let vds_mpt = abs(v(tp)-v(vdd))
let mg_mpt = vds_mpt - abs(@m.xmpt.m0[vdsat])
let id_mpt = abs(@m.xmpt.m0[id])
let gm_mpt = abs(@m.xmpt.m0[gm])
let vgs_mpt = abs(v(vbp)-v(vdd))
echo RESULT mg_mpt $&mg_mpt
echo RESULT id_mpt $&id_mpt
echo RESULT gm_mpt $&gm_mpt
echo RESULT vgs_mpt $&vgs_mpt
let vds_mp1 = abs(v(fa)-v(tp))
let mg_mp1 = vds_mp1 - abs(@m.xmp1.m0[vdsat])
let id_mp1 = abs(@m.xmp1.m0[id])
let gm_mp1 = abs(@m.xmp1.m0[gm])
let vgs_mp1 = abs(v(inp)-v(tp))
echo RESULT mg_mp1 $&mg_mp1
echo RESULT id_mp1 $&id_mp1
echo RESULT gm_mp1 $&gm_mp1
echo RESULT vgs_mp1 $&vgs_mp1
let vds_mp2 = abs(v(fb)-v(tp))
let mg_mp2 = vds_mp2 - abs(@m.xmp2.m0[vdsat])
let id_mp2 = abs(@m.xmp2.m0[id])
let gm_mp2 = abs(@m.xmp2.m0[gm])
let vgs_mp2 = abs(v(inn)-v(tp))
echo RESULT mg_mp2 $&mg_mp2
echo RESULT id_mp2 $&id_mp2
echo RESULT gm_mp2 $&gm_mp2
echo RESULT vgs_mp2 $&vgs_mp2
let vds_mpd1 = abs(v(fa)-v(tp))
let mg_mpd1 = vds_mpd1 - abs(@m.xmpd1.m0[vdsat])
let id_mpd1 = abs(@m.xmpd1.m0[id])
let gm_mpd1 = abs(@m.xmpd1.m0[gm])
let vgs_mpd1 = abs(v(vref)-v(tp))
echo RESULT mg_mpd1 $&mg_mpd1
echo RESULT id_mpd1 $&id_mpd1
echo RESULT gm_mpd1 $&gm_mpd1
echo RESULT vgs_mpd1 $&vgs_mpd1
let vds_mpd2 = abs(v(fb)-v(tp))
let mg_mpd2 = vds_mpd2 - abs(@m.xmpd2.m0[vdsat])
let id_mpd2 = abs(@m.xmpd2.m0[id])
let gm_mpd2 = abs(@m.xmpd2.m0[gm])
let vgs_mpd2 = abs(v(vref)-v(tp))
echo RESULT mg_mpd2 $&mg_mpd2
echo RESULT id_mpd2 $&id_mpd2
echo RESULT gm_mpd2 $&gm_mpd2
echo RESULT vgs_mpd2 $&vgs_mpd2
let vds_m3a = abs(v(fa)-0)
let mg_m3a = vds_m3a - abs(@m.xm3a.m0[vdsat])
let id_m3a = abs(@m.xm3a.m0[id])
let gm_m3a = abs(@m.xm3a.m0[gm])
let vgs_m3a = abs(v(vbn)-0)
echo RESULT mg_m3a $&mg_m3a
echo RESULT id_m3a $&id_m3a
echo RESULT gm_m3a $&gm_m3a
echo RESULT vgs_m3a $&vgs_m3a
let vds_m3b = abs(v(fb)-0)
let mg_m3b = vds_m3b - abs(@m.xm3b.m0[vdsat])
let id_m3b = abs(@m.xm3b.m0[id])
let gm_m3b = abs(@m.xm3b.m0[gm])
let vgs_m3b = abs(v(vbn)-0)
echo RESULT mg_m3b $&mg_m3b
echo RESULT id_m3b $&id_m3b
echo RESULT gm_m3b $&gm_m3b
echo RESULT vgs_m3b $&vgs_m3b
let vds_m5a = abs(v(oa)-v(fa))
let mg_m5a = vds_m5a - abs(@m.xm5a.m0[vdsat])
let id_m5a = abs(@m.xm5a.m0[id])
let gm_m5a = abs(@m.xm5a.m0[gm])
let vgs_m5a = abs(v(vb2)-v(fa))
echo RESULT mg_m5a $&mg_m5a
echo RESULT id_m5a $&id_m5a
echo RESULT gm_m5a $&gm_m5a
echo RESULT vgs_m5a $&vgs_m5a
let vds_m5b = abs(v(ob)-v(fb))
let mg_m5b = vds_m5b - abs(@m.xm5b.m0[vdsat])
let id_m5b = abs(@m.xm5b.m0[id])
let gm_m5b = abs(@m.xm5b.m0[gm])
let vgs_m5b = abs(v(vb2)-v(fb))
echo RESULT mg_m5b $&mg_m5b
echo RESULT id_m5b $&id_m5b
echo RESULT gm_m5b $&gm_m5b
echo RESULT vgs_m5b $&vgs_m5b
let vds_mnt = abs(v(tn)-0)
let mg_mnt = vds_mnt - abs(@m.xmnt.m0[vdsat])
let id_mnt = abs(@m.xmnt.m0[id])
let gm_mnt = abs(@m.xmnt.m0[gm])
let vgs_mnt = abs(v(vbn)-0)
echo RESULT mg_mnt $&mg_mnt
echo RESULT id_mnt $&id_mnt
echo RESULT gm_mnt $&gm_mnt
echo RESULT vgs_mnt $&vgs_mnt
let vds_mn1 = abs(v(oa)-v(tn))
let mg_mn1 = vds_mn1 - abs(@m.xmn1.m0[vdsat])
let id_mn1 = abs(@m.xmn1.m0[id])
let gm_mn1 = abs(@m.xmn1.m0[gm])
let vgs_mn1 = abs(v(inp)-v(tn))
echo RESULT mg_mn1 $&mg_mn1
echo RESULT id_mn1 $&id_mn1
echo RESULT gm_mn1 $&gm_mn1
echo RESULT vgs_mn1 $&vgs_mn1
let vds_mn2 = abs(v(ob)-v(tn))
let mg_mn2 = vds_mn2 - abs(@m.xmn2.m0[vdsat])
let id_mn2 = abs(@m.xmn2.m0[id])
let gm_mn2 = abs(@m.xmn2.m0[gm])
let vgs_mn2 = abs(v(inn)-v(tn))
echo RESULT mg_mn2 $&mg_mn2
echo RESULT id_mn2 $&id_mn2
echo RESULT gm_mn2 $&gm_mn2
echo RESULT vgs_mn2 $&vgs_mn2
let vds_mnd1 = abs(v(oa)-v(tn))
let mg_mnd1 = vds_mnd1 - abs(@m.xmnd1.m0[vdsat])
let id_mnd1 = abs(@m.xmnd1.m0[id])
let gm_mnd1 = abs(@m.xmnd1.m0[gm])
let vgs_mnd1 = abs(v(vref)-v(tn))
echo RESULT mg_mnd1 $&mg_mnd1
echo RESULT id_mnd1 $&id_mnd1
echo RESULT gm_mnd1 $&gm_mnd1
echo RESULT vgs_mnd1 $&vgs_mnd1
let vds_mnd2 = abs(v(ob)-v(tn))
let mg_mnd2 = vds_mnd2 - abs(@m.xmnd2.m0[vdsat])
let id_mnd2 = abs(@m.xmnd2.m0[id])
let gm_mnd2 = abs(@m.xmnd2.m0[gm])
let vgs_mnd2 = abs(v(vref)-v(tn))
echo RESULT mg_mnd2 $&mg_mnd2
echo RESULT id_mnd2 $&id_mnd2
echo RESULT gm_mnd2 $&gm_mnd2
echo RESULT vgs_mnd2 $&vgs_mnd2
ac dec 20 1e5 1e10
let vac = v(ob)-v(oa)
let g = mag(vac)
let a1 = g[0]
let thr = a1/1.41421356
let n = length(g)
let fr = frequency
let k = 0
let f3 = 1e10
let found = 0
while k < n-1
  if found = 0
    if g[k+1] < thr
      let f3 = fr[k]*exp(ln(fr[k+1]/fr[k])*(g[k]-thr)/(g[k]-g[k+1]))
      let found = 1
    end
  end
  let k = k+1
end
let gpk = vecmax(g)
echo RESULT a1 $&a1
echo RESULT f3db $&f3
echo RESULT f3db_found $&found
let gpr = gpk/a1
echo RESULT gpeak_ratio $&gpr
.endc
.end
