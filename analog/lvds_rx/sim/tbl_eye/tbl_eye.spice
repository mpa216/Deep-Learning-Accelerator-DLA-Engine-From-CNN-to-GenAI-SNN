* tbl_eye: post-layout variant of sim/tb5_eye/tb5_eye.spice (T11, gate TBL), GENERATED by sim/tbl/make_benches.py: the core include is a variable and a .save line keeps only the vectors the control section reads.
* tb5_eye: PRBS7 eye, BER and toggle count of lane 0 through the FULL input network (task T3, PLAN_V2 TB5).
* Chain: ideal driver (50 ohm per side, complementary PWL) -> board 100 ohm termination -> package pi-model (L, C) -> asig_5p0 pad -> RX pin ->
*        lane 0 (secondary ESD is inside the core: lvds_esd2) -> output with 30 fF.
* The stimulus (stim.inc: Vsp / Vsn, and pkg.inc: .param lpk cpk) is written by hooks.py:prep_eye.  Power-up: the supply ramps 0 -> VDD over 50 ns and the
* driver common mode ramps with it (so the pad diodes never see the input above the supply), data starts at 100 ns.
* Grid: vic, vid, rate.  Hooks: hooks.py:prep_eye, hooks.py:post_eye.
{header}
{seed_line}
.option rshunt=1e11
.include {deck_dir}/../../sizing/sizes.spice
.include {deck_dir}/../../{core}
.include {deck_dir}/../../netlist/pad_asig_5p0.spice
.include {deck_dir}/../../netlist/input_network.spice
.include {run_dir}/pkg.inc
Vdd vdd 0 PWL(0 0 50n {vdd})
Ben en 0 V=1*v(vdd)
Bcm cm 0 V={vic}*v(vdd)/{vdd}
.include {run_dir}/stim.inc
Xnet srcp srcn rx0_p rx0_n vdd 0 lvds_input_network LPKG={lpk} CPKG={cpk}
Vp1 rx1_p cm dc 0
Vn1 rx1_n cm dc 0
Vp2 rx2_p cm dc 0
Vn2 rx2_n cm dc 0
Xdut vdd 0 rx0_p rx0_n rx1_p rx1_n rx2_p rx2_n en rx0_o rx1_o rx2_o lvds_rx_x3
cl rx0_o 0 30f
.save v(rx0_o) v(rx0_p) v(rx0_n)
.control
let tstop = 100e-9 + 138/{rate}
tran 25p $&tstop 0 50p
wrdata eye.txt v(rx0_o) v(rx0_p) v(rx0_n)
.endc
.end
