* tbl_idle: post-layout variant of sim/tb7_idle/tb7_idle.spice (T11, gate TBL), GENERATED by sim/tbl/make_benches.py: the core include is a variable and a .save line keeps only the vectors the control section reads.
* tb7_idle: idle inputs (open / terminated / shorted) on all three lanes, optional slow +-100 mV drift of the terminated source (task T4, PLAN_V2 TB7).
* The body (supply, EN, three input networks, macro, .param tstop_run) is generated by hooks.py:prep into body.inc.
{header}
{seed_line}
.option rshunt=1e11
.include {deck_dir}/../../sizing/sizes.spice
.include {deck_dir}/../../{core}
.include {deck_dir}/../../netlist/pad_asig_5p0.spice
.include {deck_dir}/../../netlist/input_network.spice
.include {run_dir}/body.inc
.tran 50p {tstop_run} 0 200p
.save v(rx0_o) v(rx1_o) v(rx2_o)
.control
run
wrdata tb7.txt v(rx0_o) v(rx1_o) v(rx2_o)
.endc
.end
