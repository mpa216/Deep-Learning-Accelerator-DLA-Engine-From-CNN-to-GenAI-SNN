* tb1_op: operating point of lane 0 + bias of lvds_rx_x3 (task T2 part 2, PLAN_V2 TB1).  GENERATED by sim/tb1_op/make_deck.py -- do not edit.
* grid: vic (common mode), vid (differential input of lane 0).  EN = 1.  Lanes 1 and 2 sit at VIC with VID = 0.
* Hooks (hooks.py:post_tb1) compare every device with the sizing script / LUT and write the pass/fail metrics.
{header}
{seed_line}
* rshunt: 100 Gohm from every node to ground (7 nA at 3.6 V): without it floating nodes break ngspice's gmin/source stepping
.option rshunt=1e11
.param vidv = {vid}
.include {deck_dir}/../../sizing/sizes.spice
.include {deck_dir}/../../netlist/lvds_rx_core.spice
Vsup vdd 0 {vdd}
Ben en 0 V=1*v(vdd)
Bcm cm 0 V={vic}*v(vdd)/{vdd}
Vp0 rx0_p cm dc {vidv/2}
Vn0 rx0_n cm dc {-vidv/2}
Vp1 rx1_p cm dc 0
Vn1 rx1_n cm dc 0
Vp2 rx2_p cm dc 0
Vn2 rx2_n cm dc 0
Xdut vdd 0 rx0_p rx0_n rx1_p rx1_n rx2_p rx2_n en rx0_o rx1_o rx2_o lvds_rx_x3
.control
* DC convergence: ramp the supply (EN and VIC scale with it) from 0.3 V to VDD; the last point is the operating point (plain `op` fails, see log/T2_report.md)
dc Vsup 0.3 {vdd} 0.1
let n = length(v(vdd)) - 1
let ivv = -i(Vsup)
let idd = ivv[n]
echo RESULT idd $&idd
let vds_xbias_xmen_p = abs(v(xdut.xbias.enb)[n] - v(vdd)[n])
let vgs_xbias_xmen_p = abs(v(en)[n] - v(vdd)[n])
let vsb_xbias_xmen_p = abs(v(vdd)[n] - v(vdd)[n])
let mg_xbias_xmen_p = vds_xbias_xmen_p - abs(@m.xdut.xbias.xmen_p.m0[vdsat])
let id_xbias_xmen_p = abs(@m.xdut.xbias.xmen_p.m0[id])
let gm_xbias_xmen_p = abs(@m.xdut.xbias.xmen_p.m0[gm])
echo RESULT mg_xbias_xmen_p $&mg_xbias_xmen_p
echo RESULT id_xbias_xmen_p $&id_xbias_xmen_p
echo RESULT gm_xbias_xmen_p $&gm_xbias_xmen_p
echo RESULT vgs_xbias_xmen_p $&vgs_xbias_xmen_p
echo RESULT vds_xbias_xmen_p $&vds_xbias_xmen_p
echo RESULT vsb_xbias_xmen_p $&vsb_xbias_xmen_p
let vds_xbias_xmen_n = abs(v(xdut.xbias.enb)[n] - 0)
let vgs_xbias_xmen_n = abs(v(en)[n] - 0)
let vsb_xbias_xmen_n = abs(0 - 0)
let mg_xbias_xmen_n = vds_xbias_xmen_n - abs(@m.xdut.xbias.xmen_n.m0[vdsat])
let id_xbias_xmen_n = abs(@m.xdut.xbias.xmen_n.m0[id])
let gm_xbias_xmen_n = abs(@m.xdut.xbias.xmen_n.m0[gm])
echo RESULT mg_xbias_xmen_n $&mg_xbias_xmen_n
echo RESULT id_xbias_xmen_n $&id_xbias_xmen_n
echo RESULT gm_xbias_xmen_n $&gm_xbias_xmen_n
echo RESULT vgs_xbias_xmen_n $&vgs_xbias_xmen_n
echo RESULT vds_xbias_xmen_n $&vds_xbias_xmen_n
echo RESULT vsb_xbias_xmen_n $&vsb_xbias_xmen_n
let vds_xbias_xmsw = abs(v(xdut.xbias.nrb)[n] - v(vdd)[n])
let vgs_xbias_xmsw = abs(v(xdut.xbias.enb)[n] - v(vdd)[n])
let vsb_xbias_xmsw = abs(v(vdd)[n] - v(vdd)[n])
let mg_xbias_xmsw = vds_xbias_xmsw - abs(@m.xdut.xbias.xmsw.m0[vdsat])
let id_xbias_xmsw = abs(@m.xdut.xbias.xmsw.m0[id])
let gm_xbias_xmsw = abs(@m.xdut.xbias.xmsw.m0[gm])
echo RESULT mg_xbias_xmsw $&mg_xbias_xmsw
echo RESULT id_xbias_xmsw $&id_xbias_xmsw
echo RESULT gm_xbias_xmsw $&gm_xbias_xmsw
echo RESULT vgs_xbias_xmsw $&vgs_xbias_xmsw
echo RESULT vds_xbias_xmsw $&vds_xbias_xmsw
echo RESULT vsb_xbias_xmsw $&vsb_xbias_xmsw
let vds_xbias_xmbn = abs(v(xdut.vbn)[n] - 0)
let vgs_xbias_xmbn = abs(v(xdut.vbn)[n] - 0)
let vsb_xbias_xmbn = abs(0 - 0)
let mg_xbias_xmbn = vds_xbias_xmbn - abs(@m.xdut.xbias.xmbn.m0[vdsat])
let id_xbias_xmbn = abs(@m.xdut.xbias.xmbn.m0[id])
let gm_xbias_xmbn = abs(@m.xdut.xbias.xmbn.m0[gm])
echo RESULT mg_xbias_xmbn $&mg_xbias_xmbn
echo RESULT id_xbias_xmbn $&id_xbias_xmbn
echo RESULT gm_xbias_xmbn $&gm_xbias_xmbn
echo RESULT vgs_xbias_xmbn $&vgs_xbias_xmbn
echo RESULT vds_xbias_xmbn $&vds_xbias_xmbn
echo RESULT vsb_xbias_xmbn $&vsb_xbias_xmbn
let vds_xbias_xmpd_n = abs(v(xdut.vbn)[n] - 0)
let vgs_xbias_xmpd_n = abs(v(xdut.xbias.enb)[n] - 0)
let vsb_xbias_xmpd_n = abs(0 - 0)
let mg_xbias_xmpd_n = vds_xbias_xmpd_n - abs(@m.xdut.xbias.xmpd_n.m0[vdsat])
let id_xbias_xmpd_n = abs(@m.xdut.xbias.xmpd_n.m0[id])
let gm_xbias_xmpd_n = abs(@m.xdut.xbias.xmpd_n.m0[gm])
echo RESULT mg_xbias_xmpd_n $&mg_xbias_xmpd_n
echo RESULT id_xbias_xmpd_n $&id_xbias_xmpd_n
echo RESULT gm_xbias_xmpd_n $&gm_xbias_xmpd_n
echo RESULT vgs_xbias_xmpd_n $&vgs_xbias_xmpd_n
echo RESULT vds_xbias_xmpd_n $&vds_xbias_xmpd_n
echo RESULT vsb_xbias_xmpd_n $&vsb_xbias_xmpd_n
let vds_xbias_xmbs = abs(v(xdut.vbp)[n] - 0)
let vgs_xbias_xmbs = abs(v(xdut.vbn)[n] - 0)
let vsb_xbias_xmbs = abs(0 - 0)
let mg_xbias_xmbs = vds_xbias_xmbs - abs(@m.xdut.xbias.xmbs.m0[vdsat])
let id_xbias_xmbs = abs(@m.xdut.xbias.xmbs.m0[id])
let gm_xbias_xmbs = abs(@m.xdut.xbias.xmbs.m0[gm])
echo RESULT mg_xbias_xmbs $&mg_xbias_xmbs
echo RESULT id_xbias_xmbs $&id_xbias_xmbs
echo RESULT gm_xbias_xmbs $&gm_xbias_xmbs
echo RESULT vgs_xbias_xmbs $&vgs_xbias_xmbs
echo RESULT vds_xbias_xmbs $&vds_xbias_xmbs
echo RESULT vsb_xbias_xmbs $&vsb_xbias_xmbs
let vds_xbias_xmbp = abs(v(xdut.vbp)[n] - v(vdd)[n])
let vgs_xbias_xmbp = abs(v(xdut.vbp)[n] - v(vdd)[n])
let vsb_xbias_xmbp = abs(v(vdd)[n] - v(vdd)[n])
let mg_xbias_xmbp = vds_xbias_xmbp - abs(@m.xdut.xbias.xmbp.m0[vdsat])
let id_xbias_xmbp = abs(@m.xdut.xbias.xmbp.m0[id])
let gm_xbias_xmbp = abs(@m.xdut.xbias.xmbp.m0[gm])
echo RESULT mg_xbias_xmbp $&mg_xbias_xmbp
echo RESULT id_xbias_xmbp $&id_xbias_xmbp
echo RESULT gm_xbias_xmbp $&gm_xbias_xmbp
echo RESULT vgs_xbias_xmbp $&vgs_xbias_xmbp
echo RESULT vds_xbias_xmbp $&vds_xbias_xmbp
echo RESULT vsb_xbias_xmbp $&vsb_xbias_xmbp
let vds_xbias_xmpu_p = abs(v(xdut.vbp)[n] - v(vdd)[n])
let vgs_xbias_xmpu_p = abs(v(en)[n] - v(vdd)[n])
let vsb_xbias_xmpu_p = abs(v(vdd)[n] - v(vdd)[n])
let mg_xbias_xmpu_p = vds_xbias_xmpu_p - abs(@m.xdut.xbias.xmpu_p.m0[vdsat])
let id_xbias_xmpu_p = abs(@m.xdut.xbias.xmpu_p.m0[id])
let gm_xbias_xmpu_p = abs(@m.xdut.xbias.xmpu_p.m0[gm])
echo RESULT mg_xbias_xmpu_p $&mg_xbias_xmpu_p
echo RESULT id_xbias_xmpu_p $&id_xbias_xmpu_p
echo RESULT gm_xbias_xmpu_p $&gm_xbias_xmpu_p
echo RESULT vgs_xbias_xmpu_p $&vgs_xbias_xmpu_p
echo RESULT vds_xbias_xmpu_p $&vds_xbias_xmpu_p
echo RESULT vsb_xbias_xmpu_p $&vsb_xbias_xmpu_p
let vds_xbias_xmb2p = abs(v(xdut.vb2)[n] - v(vdd)[n])
let vgs_xbias_xmb2p = abs(v(xdut.vbp)[n] - v(vdd)[n])
let vsb_xbias_xmb2p = abs(v(vdd)[n] - v(vdd)[n])
let mg_xbias_xmb2p = vds_xbias_xmb2p - abs(@m.xdut.xbias.xmb2p.m0[vdsat])
let id_xbias_xmb2p = abs(@m.xdut.xbias.xmb2p.m0[id])
let gm_xbias_xmb2p = abs(@m.xdut.xbias.xmb2p.m0[gm])
echo RESULT mg_xbias_xmb2p $&mg_xbias_xmb2p
echo RESULT id_xbias_xmb2p $&id_xbias_xmb2p
echo RESULT gm_xbias_xmb2p $&gm_xbias_xmb2p
echo RESULT vgs_xbias_xmb2p $&vgs_xbias_xmb2p
echo RESULT vds_xbias_xmb2p $&vds_xbias_xmb2p
echo RESULT vsb_xbias_xmb2p $&vsb_xbias_xmb2p
let vds_xbias_xmb2 = abs(v(xdut.vb2)[n] - v(xdut.xbias.vf)[n])
let vgs_xbias_xmb2 = abs(v(xdut.vb2)[n] - v(xdut.xbias.vf)[n])
let vsb_xbias_xmb2 = abs(v(xdut.xbias.vf)[n] - 0)
let mg_xbias_xmb2 = vds_xbias_xmb2 - abs(@m.xdut.xbias.xmb2.m0[vdsat])
let id_xbias_xmb2 = abs(@m.xdut.xbias.xmb2.m0[id])
let gm_xbias_xmb2 = abs(@m.xdut.xbias.xmb2.m0[gm])
echo RESULT mg_xbias_xmb2 $&mg_xbias_xmb2
echo RESULT id_xbias_xmb2 $&id_xbias_xmb2
echo RESULT gm_xbias_xmb2 $&gm_xbias_xmb2
echo RESULT vgs_xbias_xmb2 $&vgs_xbias_xmb2
echo RESULT vds_xbias_xmb2 $&vds_xbias_xmb2
echo RESULT vsb_xbias_xmb2 $&vsb_xbias_xmb2
let vds_xbias_xmpd_2 = abs(v(xdut.vb2)[n] - 0)
let vgs_xbias_xmpd_2 = abs(v(xdut.xbias.enb)[n] - 0)
let vsb_xbias_xmpd_2 = abs(0 - 0)
let mg_xbias_xmpd_2 = vds_xbias_xmpd_2 - abs(@m.xdut.xbias.xmpd_2.m0[vdsat])
let id_xbias_xmpd_2 = abs(@m.xdut.xbias.xmpd_2.m0[id])
let gm_xbias_xmpd_2 = abs(@m.xdut.xbias.xmpd_2.m0[gm])
echo RESULT mg_xbias_xmpd_2 $&mg_xbias_xmpd_2
echo RESULT id_xbias_xmpd_2 $&id_xbias_xmpd_2
echo RESULT gm_xbias_xmpd_2 $&gm_xbias_xmpd_2
echo RESULT vgs_xbias_xmpd_2 $&vgs_xbias_xmpd_2
echo RESULT vds_xbias_xmpd_2 $&vds_xbias_xmpd_2
echo RESULT vsb_xbias_xmpd_2 $&vsb_xbias_xmpd_2
let vds_xbias_xmvs = abs(v(xdut.xbias.nmid)[n] - 0)
let vgs_xbias_xmvs = abs(v(en)[n] - 0)
let vsb_xbias_xmvs = abs(0 - 0)
let mg_xbias_xmvs = vds_xbias_xmvs - abs(@m.xdut.xbias.xmvs.m0[vdsat])
let id_xbias_xmvs = abs(@m.xdut.xbias.xmvs.m0[id])
let gm_xbias_xmvs = abs(@m.xdut.xbias.xmvs.m0[gm])
echo RESULT mg_xbias_xmvs $&mg_xbias_xmvs
echo RESULT id_xbias_xmvs $&id_xbias_xmvs
echo RESULT gm_xbias_xmvs $&gm_xbias_xmvs
echo RESULT vgs_xbias_xmvs $&vgs_xbias_xmvs
echo RESULT vds_xbias_xmvs $&vds_xbias_xmvs
echo RESULT vsb_xbias_xmvs $&vsb_xbias_xmvs
let vds_xl0_xpre_xmpt = abs(v(xdut.xl0.xpre.tp)[n] - v(vdd)[n])
let vgs_xl0_xpre_xmpt = abs(v(xdut.vbp)[n] - v(vdd)[n])
let vsb_xl0_xpre_xmpt = abs(v(vdd)[n] - v(vdd)[n])
let mg_xl0_xpre_xmpt = vds_xl0_xpre_xmpt - abs(@m.xdut.xl0.xpre.xmpt.m0[vdsat])
let id_xl0_xpre_xmpt = abs(@m.xdut.xl0.xpre.xmpt.m0[id])
let gm_xl0_xpre_xmpt = abs(@m.xdut.xl0.xpre.xmpt.m0[gm])
echo RESULT mg_xl0_xpre_xmpt $&mg_xl0_xpre_xmpt
echo RESULT id_xl0_xpre_xmpt $&id_xl0_xpre_xmpt
echo RESULT gm_xl0_xpre_xmpt $&gm_xl0_xpre_xmpt
echo RESULT vgs_xl0_xpre_xmpt $&vgs_xl0_xpre_xmpt
echo RESULT vds_xl0_xpre_xmpt $&vds_xl0_xpre_xmpt
echo RESULT vsb_xl0_xpre_xmpt $&vsb_xl0_xpre_xmpt
let vds_xl0_xpre_xmp1a = abs(v(xdut.xl0.xpre.fa)[n] - v(xdut.xl0.xpre.tp)[n])
let vgs_xl0_xpre_xmp1a = abs(v(xdut.xl0.gp)[n] - v(xdut.xl0.xpre.tp)[n])
let vsb_xl0_xpre_xmp1a = abs(v(xdut.xl0.xpre.tp)[n] - v(xdut.xl0.xpre.tp)[n])
let mg_xl0_xpre_xmp1a = vds_xl0_xpre_xmp1a - abs(@m.xdut.xl0.xpre.xmp1a.m0[vdsat])
let id_xl0_xpre_xmp1a = abs(@m.xdut.xl0.xpre.xmp1a.m0[id])
let gm_xl0_xpre_xmp1a = abs(@m.xdut.xl0.xpre.xmp1a.m0[gm])
echo RESULT mg_xl0_xpre_xmp1a $&mg_xl0_xpre_xmp1a
echo RESULT id_xl0_xpre_xmp1a $&id_xl0_xpre_xmp1a
echo RESULT gm_xl0_xpre_xmp1a $&gm_xl0_xpre_xmp1a
echo RESULT vgs_xl0_xpre_xmp1a $&vgs_xl0_xpre_xmp1a
echo RESULT vds_xl0_xpre_xmp1a $&vds_xl0_xpre_xmp1a
echo RESULT vsb_xl0_xpre_xmp1a $&vsb_xl0_xpre_xmp1a
let vds_xl0_xpre_xmp1b = abs(v(xdut.xl0.xpre.fb)[n] - v(xdut.xl0.xpre.tp)[n])
let vgs_xl0_xpre_xmp1b = abs(v(xdut.xl0.gn)[n] - v(xdut.xl0.xpre.tp)[n])
let vsb_xl0_xpre_xmp1b = abs(v(xdut.xl0.xpre.tp)[n] - v(xdut.xl0.xpre.tp)[n])
let mg_xl0_xpre_xmp1b = vds_xl0_xpre_xmp1b - abs(@m.xdut.xl0.xpre.xmp1b.m0[vdsat])
let id_xl0_xpre_xmp1b = abs(@m.xdut.xl0.xpre.xmp1b.m0[id])
let gm_xl0_xpre_xmp1b = abs(@m.xdut.xl0.xpre.xmp1b.m0[gm])
echo RESULT mg_xl0_xpre_xmp1b $&mg_xl0_xpre_xmp1b
echo RESULT id_xl0_xpre_xmp1b $&id_xl0_xpre_xmp1b
echo RESULT gm_xl0_xpre_xmp1b $&gm_xl0_xpre_xmp1b
echo RESULT vgs_xl0_xpre_xmp1b $&vgs_xl0_xpre_xmp1b
echo RESULT vds_xl0_xpre_xmp1b $&vds_xl0_xpre_xmp1b
echo RESULT vsb_xl0_xpre_xmp1b $&vsb_xl0_xpre_xmp1b
let vds_xl0_xpre_xmpda = abs(v(xdut.xl0.xpre.fa)[n] - v(xdut.xl0.xpre.tp)[n])
let vgs_xl0_xpre_xmpda = abs(v(xdut.vref)[n] - v(xdut.xl0.xpre.tp)[n])
let vsb_xl0_xpre_xmpda = abs(v(xdut.xl0.xpre.tp)[n] - v(xdut.xl0.xpre.tp)[n])
let mg_xl0_xpre_xmpda = vds_xl0_xpre_xmpda - abs(@m.xdut.xl0.xpre.xmpda.m0[vdsat])
let id_xl0_xpre_xmpda = abs(@m.xdut.xl0.xpre.xmpda.m0[id])
let gm_xl0_xpre_xmpda = abs(@m.xdut.xl0.xpre.xmpda.m0[gm])
echo RESULT mg_xl0_xpre_xmpda $&mg_xl0_xpre_xmpda
echo RESULT id_xl0_xpre_xmpda $&id_xl0_xpre_xmpda
echo RESULT gm_xl0_xpre_xmpda $&gm_xl0_xpre_xmpda
echo RESULT vgs_xl0_xpre_xmpda $&vgs_xl0_xpre_xmpda
echo RESULT vds_xl0_xpre_xmpda $&vds_xl0_xpre_xmpda
echo RESULT vsb_xl0_xpre_xmpda $&vsb_xl0_xpre_xmpda
let vds_xl0_xpre_xmpdb = abs(v(xdut.xl0.xpre.fb)[n] - v(xdut.xl0.xpre.tp)[n])
let vgs_xl0_xpre_xmpdb = abs(v(xdut.vref)[n] - v(xdut.xl0.xpre.tp)[n])
let vsb_xl0_xpre_xmpdb = abs(v(xdut.xl0.xpre.tp)[n] - v(xdut.xl0.xpre.tp)[n])
let mg_xl0_xpre_xmpdb = vds_xl0_xpre_xmpdb - abs(@m.xdut.xl0.xpre.xmpdb.m0[vdsat])
let id_xl0_xpre_xmpdb = abs(@m.xdut.xl0.xpre.xmpdb.m0[id])
let gm_xl0_xpre_xmpdb = abs(@m.xdut.xl0.xpre.xmpdb.m0[gm])
echo RESULT mg_xl0_xpre_xmpdb $&mg_xl0_xpre_xmpdb
echo RESULT id_xl0_xpre_xmpdb $&id_xl0_xpre_xmpdb
echo RESULT gm_xl0_xpre_xmpdb $&gm_xl0_xpre_xmpdb
echo RESULT vgs_xl0_xpre_xmpdb $&vgs_xl0_xpre_xmpdb
echo RESULT vds_xl0_xpre_xmpdb $&vds_xl0_xpre_xmpdb
echo RESULT vsb_xl0_xpre_xmpdb $&vsb_xl0_xpre_xmpdb
let vds_xl0_xpre_xm3a = abs(v(xdut.xl0.xpre.fa)[n] - 0)
let vgs_xl0_xpre_xm3a = abs(v(xdut.vbn)[n] - 0)
let vsb_xl0_xpre_xm3a = abs(0 - 0)
let mg_xl0_xpre_xm3a = vds_xl0_xpre_xm3a - abs(@m.xdut.xl0.xpre.xm3a.m0[vdsat])
let id_xl0_xpre_xm3a = abs(@m.xdut.xl0.xpre.xm3a.m0[id])
let gm_xl0_xpre_xm3a = abs(@m.xdut.xl0.xpre.xm3a.m0[gm])
echo RESULT mg_xl0_xpre_xm3a $&mg_xl0_xpre_xm3a
echo RESULT id_xl0_xpre_xm3a $&id_xl0_xpre_xm3a
echo RESULT gm_xl0_xpre_xm3a $&gm_xl0_xpre_xm3a
echo RESULT vgs_xl0_xpre_xm3a $&vgs_xl0_xpre_xm3a
echo RESULT vds_xl0_xpre_xm3a $&vds_xl0_xpre_xm3a
echo RESULT vsb_xl0_xpre_xm3a $&vsb_xl0_xpre_xm3a
let vds_xl0_xpre_xm3b = abs(v(xdut.xl0.xpre.fb)[n] - 0)
let vgs_xl0_xpre_xm3b = abs(v(xdut.vbn)[n] - 0)
let vsb_xl0_xpre_xm3b = abs(0 - 0)
let mg_xl0_xpre_xm3b = vds_xl0_xpre_xm3b - abs(@m.xdut.xl0.xpre.xm3b.m0[vdsat])
let id_xl0_xpre_xm3b = abs(@m.xdut.xl0.xpre.xm3b.m0[id])
let gm_xl0_xpre_xm3b = abs(@m.xdut.xl0.xpre.xm3b.m0[gm])
echo RESULT mg_xl0_xpre_xm3b $&mg_xl0_xpre_xm3b
echo RESULT id_xl0_xpre_xm3b $&id_xl0_xpre_xm3b
echo RESULT gm_xl0_xpre_xm3b $&gm_xl0_xpre_xm3b
echo RESULT vgs_xl0_xpre_xm3b $&vgs_xl0_xpre_xm3b
echo RESULT vds_xl0_xpre_xm3b $&vds_xl0_xpre_xm3b
echo RESULT vsb_xl0_xpre_xm3b $&vsb_xl0_xpre_xm3b
let vds_xl0_xpre_xm5a = abs(v(xdut.xl0.oa)[n] - v(xdut.xl0.xpre.fa)[n])
let vgs_xl0_xpre_xm5a = abs(v(xdut.vb2)[n] - v(xdut.xl0.xpre.fa)[n])
let vsb_xl0_xpre_xm5a = abs(v(xdut.xl0.xpre.fa)[n] - 0)
let mg_xl0_xpre_xm5a = vds_xl0_xpre_xm5a - abs(@m.xdut.xl0.xpre.xm5a.m0[vdsat])
let id_xl0_xpre_xm5a = abs(@m.xdut.xl0.xpre.xm5a.m0[id])
let gm_xl0_xpre_xm5a = abs(@m.xdut.xl0.xpre.xm5a.m0[gm])
echo RESULT mg_xl0_xpre_xm5a $&mg_xl0_xpre_xm5a
echo RESULT id_xl0_xpre_xm5a $&id_xl0_xpre_xm5a
echo RESULT gm_xl0_xpre_xm5a $&gm_xl0_xpre_xm5a
echo RESULT vgs_xl0_xpre_xm5a $&vgs_xl0_xpre_xm5a
echo RESULT vds_xl0_xpre_xm5a $&vds_xl0_xpre_xm5a
echo RESULT vsb_xl0_xpre_xm5a $&vsb_xl0_xpre_xm5a
let vds_xl0_xpre_xm5b = abs(v(xdut.xl0.ob)[n] - v(xdut.xl0.xpre.fb)[n])
let vgs_xl0_xpre_xm5b = abs(v(xdut.vb2)[n] - v(xdut.xl0.xpre.fb)[n])
let vsb_xl0_xpre_xm5b = abs(v(xdut.xl0.xpre.fb)[n] - 0)
let mg_xl0_xpre_xm5b = vds_xl0_xpre_xm5b - abs(@m.xdut.xl0.xpre.xm5b.m0[vdsat])
let id_xl0_xpre_xm5b = abs(@m.xdut.xl0.xpre.xm5b.m0[id])
let gm_xl0_xpre_xm5b = abs(@m.xdut.xl0.xpre.xm5b.m0[gm])
echo RESULT mg_xl0_xpre_xm5b $&mg_xl0_xpre_xm5b
echo RESULT id_xl0_xpre_xm5b $&id_xl0_xpre_xm5b
echo RESULT gm_xl0_xpre_xm5b $&gm_xl0_xpre_xm5b
echo RESULT vgs_xl0_xpre_xm5b $&vgs_xl0_xpre_xm5b
echo RESULT vds_xl0_xpre_xm5b $&vds_xl0_xpre_xm5b
echo RESULT vsb_xl0_xpre_xm5b $&vsb_xl0_xpre_xm5b
let vds_xl0_xpre_xmnt = abs(v(xdut.xl0.xpre.tn)[n] - 0)
let vgs_xl0_xpre_xmnt = abs(v(xdut.vbn)[n] - 0)
let vsb_xl0_xpre_xmnt = abs(0 - 0)
let mg_xl0_xpre_xmnt = vds_xl0_xpre_xmnt - abs(@m.xdut.xl0.xpre.xmnt.m0[vdsat])
let id_xl0_xpre_xmnt = abs(@m.xdut.xl0.xpre.xmnt.m0[id])
let gm_xl0_xpre_xmnt = abs(@m.xdut.xl0.xpre.xmnt.m0[gm])
echo RESULT mg_xl0_xpre_xmnt $&mg_xl0_xpre_xmnt
echo RESULT id_xl0_xpre_xmnt $&id_xl0_xpre_xmnt
echo RESULT gm_xl0_xpre_xmnt $&gm_xl0_xpre_xmnt
echo RESULT vgs_xl0_xpre_xmnt $&vgs_xl0_xpre_xmnt
echo RESULT vds_xl0_xpre_xmnt $&vds_xl0_xpre_xmnt
echo RESULT vsb_xl0_xpre_xmnt $&vsb_xl0_xpre_xmnt
let vds_xl0_xpre_xmn1a = abs(v(xdut.xl0.oa)[n] - v(xdut.xl0.xpre.tn)[n])
let vgs_xl0_xpre_xmn1a = abs(v(xdut.xl0.gp)[n] - v(xdut.xl0.xpre.tn)[n])
let vsb_xl0_xpre_xmn1a = abs(v(xdut.xl0.xpre.tn)[n] - 0)
let mg_xl0_xpre_xmn1a = vds_xl0_xpre_xmn1a - abs(@m.xdut.xl0.xpre.xmn1a.m0[vdsat])
let id_xl0_xpre_xmn1a = abs(@m.xdut.xl0.xpre.xmn1a.m0[id])
let gm_xl0_xpre_xmn1a = abs(@m.xdut.xl0.xpre.xmn1a.m0[gm])
echo RESULT mg_xl0_xpre_xmn1a $&mg_xl0_xpre_xmn1a
echo RESULT id_xl0_xpre_xmn1a $&id_xl0_xpre_xmn1a
echo RESULT gm_xl0_xpre_xmn1a $&gm_xl0_xpre_xmn1a
echo RESULT vgs_xl0_xpre_xmn1a $&vgs_xl0_xpre_xmn1a
echo RESULT vds_xl0_xpre_xmn1a $&vds_xl0_xpre_xmn1a
echo RESULT vsb_xl0_xpre_xmn1a $&vsb_xl0_xpre_xmn1a
let vds_xl0_xpre_xmn1b = abs(v(xdut.xl0.ob)[n] - v(xdut.xl0.xpre.tn)[n])
let vgs_xl0_xpre_xmn1b = abs(v(xdut.xl0.gn)[n] - v(xdut.xl0.xpre.tn)[n])
let vsb_xl0_xpre_xmn1b = abs(v(xdut.xl0.xpre.tn)[n] - 0)
let mg_xl0_xpre_xmn1b = vds_xl0_xpre_xmn1b - abs(@m.xdut.xl0.xpre.xmn1b.m0[vdsat])
let id_xl0_xpre_xmn1b = abs(@m.xdut.xl0.xpre.xmn1b.m0[id])
let gm_xl0_xpre_xmn1b = abs(@m.xdut.xl0.xpre.xmn1b.m0[gm])
echo RESULT mg_xl0_xpre_xmn1b $&mg_xl0_xpre_xmn1b
echo RESULT id_xl0_xpre_xmn1b $&id_xl0_xpre_xmn1b
echo RESULT gm_xl0_xpre_xmn1b $&gm_xl0_xpre_xmn1b
echo RESULT vgs_xl0_xpre_xmn1b $&vgs_xl0_xpre_xmn1b
echo RESULT vds_xl0_xpre_xmn1b $&vds_xl0_xpre_xmn1b
echo RESULT vsb_xl0_xpre_xmn1b $&vsb_xl0_xpre_xmn1b
let vds_xl0_xpre_xmnda = abs(v(xdut.xl0.oa)[n] - v(xdut.xl0.xpre.tn)[n])
let vgs_xl0_xpre_xmnda = abs(v(xdut.vref)[n] - v(xdut.xl0.xpre.tn)[n])
let vsb_xl0_xpre_xmnda = abs(v(xdut.xl0.xpre.tn)[n] - 0)
let mg_xl0_xpre_xmnda = vds_xl0_xpre_xmnda - abs(@m.xdut.xl0.xpre.xmnda.m0[vdsat])
let id_xl0_xpre_xmnda = abs(@m.xdut.xl0.xpre.xmnda.m0[id])
let gm_xl0_xpre_xmnda = abs(@m.xdut.xl0.xpre.xmnda.m0[gm])
echo RESULT mg_xl0_xpre_xmnda $&mg_xl0_xpre_xmnda
echo RESULT id_xl0_xpre_xmnda $&id_xl0_xpre_xmnda
echo RESULT gm_xl0_xpre_xmnda $&gm_xl0_xpre_xmnda
echo RESULT vgs_xl0_xpre_xmnda $&vgs_xl0_xpre_xmnda
echo RESULT vds_xl0_xpre_xmnda $&vds_xl0_xpre_xmnda
echo RESULT vsb_xl0_xpre_xmnda $&vsb_xl0_xpre_xmnda
let vds_xl0_xpre_xmndb = abs(v(xdut.xl0.ob)[n] - v(xdut.xl0.xpre.tn)[n])
let vgs_xl0_xpre_xmndb = abs(v(xdut.vref)[n] - v(xdut.xl0.xpre.tn)[n])
let vsb_xl0_xpre_xmndb = abs(v(xdut.xl0.xpre.tn)[n] - 0)
let mg_xl0_xpre_xmndb = vds_xl0_xpre_xmndb - abs(@m.xdut.xl0.xpre.xmndb.m0[vdsat])
let id_xl0_xpre_xmndb = abs(@m.xdut.xl0.xpre.xmndb.m0[id])
let gm_xl0_xpre_xmndb = abs(@m.xdut.xl0.xpre.xmndb.m0[gm])
echo RESULT mg_xl0_xpre_xmndb $&mg_xl0_xpre_xmndb
echo RESULT id_xl0_xpre_xmndb $&id_xl0_xpre_xmndb
echo RESULT gm_xl0_xpre_xmndb $&gm_xl0_xpre_xmndb
echo RESULT vgs_xl0_xpre_xmndb $&vgs_xl0_xpre_xmndb
echo RESULT vds_xl0_xpre_xmndb $&vds_xl0_xpre_xmndb
echo RESULT vsb_xl0_xpre_xmndb $&vsb_xl0_xpre_xmndb
let vds_xl0_xhyst_xmt2 = abs(v(xdut.xl0.xhyst.ts)[n] - 0)
let vgs_xl0_xhyst_xmt2 = abs(v(xdut.vbn)[n] - 0)
let vsb_xl0_xhyst_xmt2 = abs(0 - 0)
let mg_xl0_xhyst_xmt2 = vds_xl0_xhyst_xmt2 - abs(@m.xdut.xl0.xhyst.xmt2.m0[vdsat])
let id_xl0_xhyst_xmt2 = abs(@m.xdut.xl0.xhyst.xmt2.m0[id])
let gm_xl0_xhyst_xmt2 = abs(@m.xdut.xl0.xhyst.xmt2.m0[gm])
echo RESULT mg_xl0_xhyst_xmt2 $&mg_xl0_xhyst_xmt2
echo RESULT id_xl0_xhyst_xmt2 $&id_xl0_xhyst_xmt2
echo RESULT gm_xl0_xhyst_xmt2 $&gm_xl0_xhyst_xmt2
echo RESULT vgs_xl0_xhyst_xmt2 $&vgs_xl0_xhyst_xmt2
echo RESULT vds_xl0_xhyst_xmt2 $&vds_xl0_xhyst_xmt2
echo RESULT vsb_xl0_xhyst_xmt2 $&vsb_xl0_xhyst_xmt2
let vds_xl0_xhyst_xms1 = abs(v(xdut.xl0.d2a)[n] - v(xdut.xl0.xhyst.sa)[n])
let vgs_xl0_xhyst_xms1 = abs(v(xdut.xl0.oa)[n] - v(xdut.xl0.xhyst.sa)[n])
let vsb_xl0_xhyst_xms1 = abs(v(xdut.xl0.xhyst.sa)[n] - 0)
let mg_xl0_xhyst_xms1 = vds_xl0_xhyst_xms1 - abs(@m.xdut.xl0.xhyst.xms1.m0[vdsat])
let id_xl0_xhyst_xms1 = abs(@m.xdut.xl0.xhyst.xms1.m0[id])
let gm_xl0_xhyst_xms1 = abs(@m.xdut.xl0.xhyst.xms1.m0[gm])
echo RESULT mg_xl0_xhyst_xms1 $&mg_xl0_xhyst_xms1
echo RESULT id_xl0_xhyst_xms1 $&id_xl0_xhyst_xms1
echo RESULT gm_xl0_xhyst_xms1 $&gm_xl0_xhyst_xms1
echo RESULT vgs_xl0_xhyst_xms1 $&vgs_xl0_xhyst_xms1
echo RESULT vds_xl0_xhyst_xms1 $&vds_xl0_xhyst_xms1
echo RESULT vsb_xl0_xhyst_xms1 $&vsb_xl0_xhyst_xms1
let vds_xl0_xhyst_xms2 = abs(v(xdut.xl0.d2b)[n] - v(xdut.xl0.xhyst.sb)[n])
let vgs_xl0_xhyst_xms2 = abs(v(xdut.xl0.ob)[n] - v(xdut.xl0.xhyst.sb)[n])
let vsb_xl0_xhyst_xms2 = abs(v(xdut.xl0.xhyst.sb)[n] - 0)
let mg_xl0_xhyst_xms2 = vds_xl0_xhyst_xms2 - abs(@m.xdut.xl0.xhyst.xms2.m0[vdsat])
let id_xl0_xhyst_xms2 = abs(@m.xdut.xl0.xhyst.xms2.m0[id])
let gm_xl0_xhyst_xms2 = abs(@m.xdut.xl0.xhyst.xms2.m0[gm])
echo RESULT mg_xl0_xhyst_xms2 $&mg_xl0_xhyst_xms2
echo RESULT id_xl0_xhyst_xms2 $&id_xl0_xhyst_xms2
echo RESULT gm_xl0_xhyst_xms2 $&gm_xl0_xhyst_xms2
echo RESULT vgs_xl0_xhyst_xms2 $&vgs_xl0_xhyst_xms2
echo RESULT vds_xl0_xhyst_xms2 $&vds_xl0_xhyst_xms2
echo RESULT vsb_xl0_xhyst_xms2 $&vsb_xl0_xhyst_xms2
let vds_xl0_xhyst_xmld1 = abs(v(xdut.xl0.d2a)[n] - v(vdd)[n])
let vgs_xl0_xhyst_xmld1 = abs(v(xdut.xl0.d2a)[n] - v(vdd)[n])
let vsb_xl0_xhyst_xmld1 = abs(v(vdd)[n] - v(vdd)[n])
let mg_xl0_xhyst_xmld1 = vds_xl0_xhyst_xmld1 - abs(@m.xdut.xl0.xhyst.xmld1.m0[vdsat])
let id_xl0_xhyst_xmld1 = abs(@m.xdut.xl0.xhyst.xmld1.m0[id])
let gm_xl0_xhyst_xmld1 = abs(@m.xdut.xl0.xhyst.xmld1.m0[gm])
echo RESULT mg_xl0_xhyst_xmld1 $&mg_xl0_xhyst_xmld1
echo RESULT id_xl0_xhyst_xmld1 $&id_xl0_xhyst_xmld1
echo RESULT gm_xl0_xhyst_xmld1 $&gm_xl0_xhyst_xmld1
echo RESULT vgs_xl0_xhyst_xmld1 $&vgs_xl0_xhyst_xmld1
echo RESULT vds_xl0_xhyst_xmld1 $&vds_xl0_xhyst_xmld1
echo RESULT vsb_xl0_xhyst_xmld1 $&vsb_xl0_xhyst_xmld1
let vds_xl0_xhyst_xmld2 = abs(v(xdut.xl0.d2b)[n] - v(vdd)[n])
let vgs_xl0_xhyst_xmld2 = abs(v(xdut.xl0.d2b)[n] - v(vdd)[n])
let vsb_xl0_xhyst_xmld2 = abs(v(vdd)[n] - v(vdd)[n])
let mg_xl0_xhyst_xmld2 = vds_xl0_xhyst_xmld2 - abs(@m.xdut.xl0.xhyst.xmld2.m0[vdsat])
let id_xl0_xhyst_xmld2 = abs(@m.xdut.xl0.xhyst.xmld2.m0[id])
let gm_xl0_xhyst_xmld2 = abs(@m.xdut.xl0.xhyst.xmld2.m0[gm])
echo RESULT mg_xl0_xhyst_xmld2 $&mg_xl0_xhyst_xmld2
echo RESULT id_xl0_xhyst_xmld2 $&id_xl0_xhyst_xmld2
echo RESULT gm_xl0_xhyst_xmld2 $&gm_xl0_xhyst_xmld2
echo RESULT vgs_xl0_xhyst_xmld2 $&vgs_xl0_xhyst_xmld2
echo RESULT vds_xl0_xhyst_xmld2 $&vds_xl0_xhyst_xmld2
echo RESULT vsb_xl0_xhyst_xmld2 $&vsb_xl0_xhyst_xmld2
let vds_xl0_xhyst_xmlc1 = abs(v(xdut.xl0.d2a)[n] - v(vdd)[n])
let vgs_xl0_xhyst_xmlc1 = abs(v(xdut.xl0.d2b)[n] - v(vdd)[n])
let vsb_xl0_xhyst_xmlc1 = abs(v(vdd)[n] - v(vdd)[n])
let mg_xl0_xhyst_xmlc1 = vds_xl0_xhyst_xmlc1 - abs(@m.xdut.xl0.xhyst.xmlc1.m0[vdsat])
let id_xl0_xhyst_xmlc1 = abs(@m.xdut.xl0.xhyst.xmlc1.m0[id])
let gm_xl0_xhyst_xmlc1 = abs(@m.xdut.xl0.xhyst.xmlc1.m0[gm])
echo RESULT mg_xl0_xhyst_xmlc1 $&mg_xl0_xhyst_xmlc1
echo RESULT id_xl0_xhyst_xmlc1 $&id_xl0_xhyst_xmlc1
echo RESULT gm_xl0_xhyst_xmlc1 $&gm_xl0_xhyst_xmlc1
echo RESULT vgs_xl0_xhyst_xmlc1 $&vgs_xl0_xhyst_xmlc1
echo RESULT vds_xl0_xhyst_xmlc1 $&vds_xl0_xhyst_xmlc1
echo RESULT vsb_xl0_xhyst_xmlc1 $&vsb_xl0_xhyst_xmlc1
let vds_xl0_xhyst_xmlc2 = abs(v(xdut.xl0.d2b)[n] - v(vdd)[n])
let vgs_xl0_xhyst_xmlc2 = abs(v(xdut.xl0.d2a)[n] - v(vdd)[n])
let vsb_xl0_xhyst_xmlc2 = abs(v(vdd)[n] - v(vdd)[n])
let mg_xl0_xhyst_xmlc2 = vds_xl0_xhyst_xmlc2 - abs(@m.xdut.xl0.xhyst.xmlc2.m0[vdsat])
let id_xl0_xhyst_xmlc2 = abs(@m.xdut.xl0.xhyst.xmlc2.m0[id])
let gm_xl0_xhyst_xmlc2 = abs(@m.xdut.xl0.xhyst.xmlc2.m0[gm])
echo RESULT mg_xl0_xhyst_xmlc2 $&mg_xl0_xhyst_xmlc2
echo RESULT id_xl0_xhyst_xmlc2 $&id_xl0_xhyst_xmlc2
echo RESULT gm_xl0_xhyst_xmlc2 $&gm_xl0_xhyst_xmlc2
echo RESULT vgs_xl0_xhyst_xmlc2 $&vgs_xl0_xhyst_xmlc2
echo RESULT vds_xl0_xhyst_xmlc2 $&vds_xl0_xhyst_xmlc2
echo RESULT vsb_xl0_xhyst_xmlc2 $&vsb_xl0_xhyst_xmlc2
let vds_xl0_xhyst_xmpu1 = abs(v(xdut.xl0.d2a)[n] - v(vdd)[n])
let vgs_xl0_xhyst_xmpu1 = abs(v(en)[n] - v(vdd)[n])
let vsb_xl0_xhyst_xmpu1 = abs(v(vdd)[n] - v(vdd)[n])
let mg_xl0_xhyst_xmpu1 = vds_xl0_xhyst_xmpu1 - abs(@m.xdut.xl0.xhyst.xmpu1.m0[vdsat])
let id_xl0_xhyst_xmpu1 = abs(@m.xdut.xl0.xhyst.xmpu1.m0[id])
let gm_xl0_xhyst_xmpu1 = abs(@m.xdut.xl0.xhyst.xmpu1.m0[gm])
echo RESULT mg_xl0_xhyst_xmpu1 $&mg_xl0_xhyst_xmpu1
echo RESULT id_xl0_xhyst_xmpu1 $&id_xl0_xhyst_xmpu1
echo RESULT gm_xl0_xhyst_xmpu1 $&gm_xl0_xhyst_xmpu1
echo RESULT vgs_xl0_xhyst_xmpu1 $&vgs_xl0_xhyst_xmpu1
echo RESULT vds_xl0_xhyst_xmpu1 $&vds_xl0_xhyst_xmpu1
echo RESULT vsb_xl0_xhyst_xmpu1 $&vsb_xl0_xhyst_xmpu1
let vds_xl0_xhyst_xmpu2 = abs(v(xdut.xl0.d2b)[n] - v(vdd)[n])
let vgs_xl0_xhyst_xmpu2 = abs(v(en)[n] - v(vdd)[n])
let vsb_xl0_xhyst_xmpu2 = abs(v(vdd)[n] - v(vdd)[n])
let mg_xl0_xhyst_xmpu2 = vds_xl0_xhyst_xmpu2 - abs(@m.xdut.xl0.xhyst.xmpu2.m0[vdsat])
let id_xl0_xhyst_xmpu2 = abs(@m.xdut.xl0.xhyst.xmpu2.m0[id])
let gm_xl0_xhyst_xmpu2 = abs(@m.xdut.xl0.xhyst.xmpu2.m0[gm])
echo RESULT mg_xl0_xhyst_xmpu2 $&mg_xl0_xhyst_xmpu2
echo RESULT id_xl0_xhyst_xmpu2 $&id_xl0_xhyst_xmpu2
echo RESULT gm_xl0_xhyst_xmpu2 $&gm_xl0_xhyst_xmpu2
echo RESULT vgs_xl0_xhyst_xmpu2 $&vgs_xl0_xhyst_xmpu2
echo RESULT vds_xl0_xhyst_xmpu2 $&vds_xl0_xhyst_xmpu2
echo RESULT vsb_xl0_xhyst_xmpu2 $&vsb_xl0_xhyst_xmpu2
let vds_xl0_xout_xmp3a = abs(v(xdut.xl0.xout.n3a)[n] - v(vdd)[n])
let vgs_xl0_xout_xmp3a = abs(v(xdut.xl0.d2a)[n] - v(vdd)[n])
let vsb_xl0_xout_xmp3a = abs(v(vdd)[n] - v(vdd)[n])
let mg_xl0_xout_xmp3a = vds_xl0_xout_xmp3a - abs(@m.xdut.xl0.xout.xmp3a.m0[vdsat])
let id_xl0_xout_xmp3a = abs(@m.xdut.xl0.xout.xmp3a.m0[id])
let gm_xl0_xout_xmp3a = abs(@m.xdut.xl0.xout.xmp3a.m0[gm])
echo RESULT mg_xl0_xout_xmp3a $&mg_xl0_xout_xmp3a
echo RESULT id_xl0_xout_xmp3a $&id_xl0_xout_xmp3a
echo RESULT gm_xl0_xout_xmp3a $&gm_xl0_xout_xmp3a
echo RESULT vgs_xl0_xout_xmp3a $&vgs_xl0_xout_xmp3a
echo RESULT vds_xl0_xout_xmp3a $&vds_xl0_xout_xmp3a
echo RESULT vsb_xl0_xout_xmp3a $&vsb_xl0_xout_xmp3a
let vds_xl0_xout_xmp3b = abs(v(xdut.xl0.xout.d3)[n] - v(vdd)[n])
let vgs_xl0_xout_xmp3b = abs(v(xdut.xl0.d2b)[n] - v(vdd)[n])
let vsb_xl0_xout_xmp3b = abs(v(vdd)[n] - v(vdd)[n])
let mg_xl0_xout_xmp3b = vds_xl0_xout_xmp3b - abs(@m.xdut.xl0.xout.xmp3b.m0[vdsat])
let id_xl0_xout_xmp3b = abs(@m.xdut.xl0.xout.xmp3b.m0[id])
let gm_xl0_xout_xmp3b = abs(@m.xdut.xl0.xout.xmp3b.m0[gm])
echo RESULT mg_xl0_xout_xmp3b $&mg_xl0_xout_xmp3b
echo RESULT id_xl0_xout_xmp3b $&id_xl0_xout_xmp3b
echo RESULT gm_xl0_xout_xmp3b $&gm_xl0_xout_xmp3b
echo RESULT vgs_xl0_xout_xmp3b $&vgs_xl0_xout_xmp3b
echo RESULT vds_xl0_xout_xmp3b $&vds_xl0_xout_xmp3b
echo RESULT vsb_xl0_xout_xmp3b $&vsb_xl0_xout_xmp3b
let vds_xl0_xout_xmn3a = abs(v(xdut.xl0.xout.n3a)[n] - 0)
let vgs_xl0_xout_xmn3a = abs(v(xdut.xl0.xout.n3a)[n] - 0)
let vsb_xl0_xout_xmn3a = abs(0 - 0)
let mg_xl0_xout_xmn3a = vds_xl0_xout_xmn3a - abs(@m.xdut.xl0.xout.xmn3a.m0[vdsat])
let id_xl0_xout_xmn3a = abs(@m.xdut.xl0.xout.xmn3a.m0[id])
let gm_xl0_xout_xmn3a = abs(@m.xdut.xl0.xout.xmn3a.m0[gm])
echo RESULT mg_xl0_xout_xmn3a $&mg_xl0_xout_xmn3a
echo RESULT id_xl0_xout_xmn3a $&id_xl0_xout_xmn3a
echo RESULT gm_xl0_xout_xmn3a $&gm_xl0_xout_xmn3a
echo RESULT vgs_xl0_xout_xmn3a $&vgs_xl0_xout_xmn3a
echo RESULT vds_xl0_xout_xmn3a $&vds_xl0_xout_xmn3a
echo RESULT vsb_xl0_xout_xmn3a $&vsb_xl0_xout_xmn3a
let vds_xl0_xout_xmn3b = abs(v(xdut.xl0.xout.d3)[n] - 0)
let vgs_xl0_xout_xmn3b = abs(v(xdut.xl0.xout.n3a)[n] - 0)
let vsb_xl0_xout_xmn3b = abs(0 - 0)
let mg_xl0_xout_xmn3b = vds_xl0_xout_xmn3b - abs(@m.xdut.xl0.xout.xmn3b.m0[vdsat])
let id_xl0_xout_xmn3b = abs(@m.xdut.xl0.xout.xmn3b.m0[id])
let gm_xl0_xout_xmn3b = abs(@m.xdut.xl0.xout.xmn3b.m0[gm])
echo RESULT mg_xl0_xout_xmn3b $&mg_xl0_xout_xmn3b
echo RESULT id_xl0_xout_xmn3b $&id_xl0_xout_xmn3b
echo RESULT gm_xl0_xout_xmn3b $&gm_xl0_xout_xmn3b
echo RESULT vgs_xl0_xout_xmn3b $&vgs_xl0_xout_xmn3b
echo RESULT vds_xl0_xout_xmn3b $&vds_xl0_xout_xmn3b
echo RESULT vsb_xl0_xout_xmn3b $&vsb_xl0_xout_xmn3b
let vds_xl0_xout_xmnandp1 = abs(v(xdut.xl0.xout.nd)[n] - v(vdd)[n])
let vgs_xl0_xout_xmnandp1 = abs(v(xdut.xl0.xout.d3)[n] - v(vdd)[n])
let vsb_xl0_xout_xmnandp1 = abs(v(vdd)[n] - v(vdd)[n])
let mg_xl0_xout_xmnandp1 = vds_xl0_xout_xmnandp1 - abs(@m.xdut.xl0.xout.xmnandp1.m0[vdsat])
let id_xl0_xout_xmnandp1 = abs(@m.xdut.xl0.xout.xmnandp1.m0[id])
let gm_xl0_xout_xmnandp1 = abs(@m.xdut.xl0.xout.xmnandp1.m0[gm])
echo RESULT mg_xl0_xout_xmnandp1 $&mg_xl0_xout_xmnandp1
echo RESULT id_xl0_xout_xmnandp1 $&id_xl0_xout_xmnandp1
echo RESULT gm_xl0_xout_xmnandp1 $&gm_xl0_xout_xmnandp1
echo RESULT vgs_xl0_xout_xmnandp1 $&vgs_xl0_xout_xmnandp1
echo RESULT vds_xl0_xout_xmnandp1 $&vds_xl0_xout_xmnandp1
echo RESULT vsb_xl0_xout_xmnandp1 $&vsb_xl0_xout_xmnandp1
let vds_xl0_xout_xmnandp2 = abs(v(xdut.xl0.xout.nd)[n] - v(vdd)[n])
let vgs_xl0_xout_xmnandp2 = abs(v(en)[n] - v(vdd)[n])
let vsb_xl0_xout_xmnandp2 = abs(v(vdd)[n] - v(vdd)[n])
let mg_xl0_xout_xmnandp2 = vds_xl0_xout_xmnandp2 - abs(@m.xdut.xl0.xout.xmnandp2.m0[vdsat])
let id_xl0_xout_xmnandp2 = abs(@m.xdut.xl0.xout.xmnandp2.m0[id])
let gm_xl0_xout_xmnandp2 = abs(@m.xdut.xl0.xout.xmnandp2.m0[gm])
echo RESULT mg_xl0_xout_xmnandp2 $&mg_xl0_xout_xmnandp2
echo RESULT id_xl0_xout_xmnandp2 $&id_xl0_xout_xmnandp2
echo RESULT gm_xl0_xout_xmnandp2 $&gm_xl0_xout_xmnandp2
echo RESULT vgs_xl0_xout_xmnandp2 $&vgs_xl0_xout_xmnandp2
echo RESULT vds_xl0_xout_xmnandp2 $&vds_xl0_xout_xmnandp2
echo RESULT vsb_xl0_xout_xmnandp2 $&vsb_xl0_xout_xmnandp2
let vds_xl0_xout_xmnandn1 = abs(v(xdut.xl0.xout.nd)[n] - v(xdut.xl0.xout.nm)[n])
let vgs_xl0_xout_xmnandn1 = abs(v(xdut.xl0.xout.d3)[n] - v(xdut.xl0.xout.nm)[n])
let vsb_xl0_xout_xmnandn1 = abs(v(xdut.xl0.xout.nm)[n] - 0)
let mg_xl0_xout_xmnandn1 = vds_xl0_xout_xmnandn1 - abs(@m.xdut.xl0.xout.xmnandn1.m0[vdsat])
let id_xl0_xout_xmnandn1 = abs(@m.xdut.xl0.xout.xmnandn1.m0[id])
let gm_xl0_xout_xmnandn1 = abs(@m.xdut.xl0.xout.xmnandn1.m0[gm])
echo RESULT mg_xl0_xout_xmnandn1 $&mg_xl0_xout_xmnandn1
echo RESULT id_xl0_xout_xmnandn1 $&id_xl0_xout_xmnandn1
echo RESULT gm_xl0_xout_xmnandn1 $&gm_xl0_xout_xmnandn1
echo RESULT vgs_xl0_xout_xmnandn1 $&vgs_xl0_xout_xmnandn1
echo RESULT vds_xl0_xout_xmnandn1 $&vds_xl0_xout_xmnandn1
echo RESULT vsb_xl0_xout_xmnandn1 $&vsb_xl0_xout_xmnandn1
let vds_xl0_xout_xmnandn2 = abs(v(xdut.xl0.xout.nm)[n] - 0)
let vgs_xl0_xout_xmnandn2 = abs(v(en)[n] - 0)
let vsb_xl0_xout_xmnandn2 = abs(0 - 0)
let mg_xl0_xout_xmnandn2 = vds_xl0_xout_xmnandn2 - abs(@m.xdut.xl0.xout.xmnandn2.m0[vdsat])
let id_xl0_xout_xmnandn2 = abs(@m.xdut.xl0.xout.xmnandn2.m0[id])
let gm_xl0_xout_xmnandn2 = abs(@m.xdut.xl0.xout.xmnandn2.m0[gm])
echo RESULT mg_xl0_xout_xmnandn2 $&mg_xl0_xout_xmnandn2
echo RESULT id_xl0_xout_xmnandn2 $&id_xl0_xout_xmnandn2
echo RESULT gm_xl0_xout_xmnandn2 $&gm_xl0_xout_xmnandn2
echo RESULT vgs_xl0_xout_xmnandn2 $&vgs_xl0_xout_xmnandn2
echo RESULT vds_xl0_xout_xmnandn2 $&vds_xl0_xout_xmnandn2
echo RESULT vsb_xl0_xout_xmnandn2 $&vsb_xl0_xout_xmnandn2
let vds_xl0_xout_xminv1p = abs(v(xdut.xl0.xout.i1)[n] - v(vdd)[n])
let vgs_xl0_xout_xminv1p = abs(v(xdut.xl0.xout.nd)[n] - v(vdd)[n])
let vsb_xl0_xout_xminv1p = abs(v(vdd)[n] - v(vdd)[n])
let mg_xl0_xout_xminv1p = vds_xl0_xout_xminv1p - abs(@m.xdut.xl0.xout.xminv1p.m0[vdsat])
let id_xl0_xout_xminv1p = abs(@m.xdut.xl0.xout.xminv1p.m0[id])
let gm_xl0_xout_xminv1p = abs(@m.xdut.xl0.xout.xminv1p.m0[gm])
echo RESULT mg_xl0_xout_xminv1p $&mg_xl0_xout_xminv1p
echo RESULT id_xl0_xout_xminv1p $&id_xl0_xout_xminv1p
echo RESULT gm_xl0_xout_xminv1p $&gm_xl0_xout_xminv1p
echo RESULT vgs_xl0_xout_xminv1p $&vgs_xl0_xout_xminv1p
echo RESULT vds_xl0_xout_xminv1p $&vds_xl0_xout_xminv1p
echo RESULT vsb_xl0_xout_xminv1p $&vsb_xl0_xout_xminv1p
let vds_xl0_xout_xminv1n = abs(v(xdut.xl0.xout.i1)[n] - 0)
let vgs_xl0_xout_xminv1n = abs(v(xdut.xl0.xout.nd)[n] - 0)
let vsb_xl0_xout_xminv1n = abs(0 - 0)
let mg_xl0_xout_xminv1n = vds_xl0_xout_xminv1n - abs(@m.xdut.xl0.xout.xminv1n.m0[vdsat])
let id_xl0_xout_xminv1n = abs(@m.xdut.xl0.xout.xminv1n.m0[id])
let gm_xl0_xout_xminv1n = abs(@m.xdut.xl0.xout.xminv1n.m0[gm])
echo RESULT mg_xl0_xout_xminv1n $&mg_xl0_xout_xminv1n
echo RESULT id_xl0_xout_xminv1n $&id_xl0_xout_xminv1n
echo RESULT gm_xl0_xout_xminv1n $&gm_xl0_xout_xminv1n
echo RESULT vgs_xl0_xout_xminv1n $&vgs_xl0_xout_xminv1n
echo RESULT vds_xl0_xout_xminv1n $&vds_xl0_xout_xminv1n
echo RESULT vsb_xl0_xout_xminv1n $&vsb_xl0_xout_xminv1n
let vds_xl0_xout_xminv2p = abs(v(xdut.xl0.xout.i2)[n] - v(vdd)[n])
let vgs_xl0_xout_xminv2p = abs(v(xdut.xl0.xout.i1)[n] - v(vdd)[n])
let vsb_xl0_xout_xminv2p = abs(v(vdd)[n] - v(vdd)[n])
let mg_xl0_xout_xminv2p = vds_xl0_xout_xminv2p - abs(@m.xdut.xl0.xout.xminv2p.m0[vdsat])
let id_xl0_xout_xminv2p = abs(@m.xdut.xl0.xout.xminv2p.m0[id])
let gm_xl0_xout_xminv2p = abs(@m.xdut.xl0.xout.xminv2p.m0[gm])
echo RESULT mg_xl0_xout_xminv2p $&mg_xl0_xout_xminv2p
echo RESULT id_xl0_xout_xminv2p $&id_xl0_xout_xminv2p
echo RESULT gm_xl0_xout_xminv2p $&gm_xl0_xout_xminv2p
echo RESULT vgs_xl0_xout_xminv2p $&vgs_xl0_xout_xminv2p
echo RESULT vds_xl0_xout_xminv2p $&vds_xl0_xout_xminv2p
echo RESULT vsb_xl0_xout_xminv2p $&vsb_xl0_xout_xminv2p
let vds_xl0_xout_xminv2n = abs(v(xdut.xl0.xout.i2)[n] - 0)
let vgs_xl0_xout_xminv2n = abs(v(xdut.xl0.xout.i1)[n] - 0)
let vsb_xl0_xout_xminv2n = abs(0 - 0)
let mg_xl0_xout_xminv2n = vds_xl0_xout_xminv2n - abs(@m.xdut.xl0.xout.xminv2n.m0[vdsat])
let id_xl0_xout_xminv2n = abs(@m.xdut.xl0.xout.xminv2n.m0[id])
let gm_xl0_xout_xminv2n = abs(@m.xdut.xl0.xout.xminv2n.m0[gm])
echo RESULT mg_xl0_xout_xminv2n $&mg_xl0_xout_xminv2n
echo RESULT id_xl0_xout_xminv2n $&id_xl0_xout_xminv2n
echo RESULT gm_xl0_xout_xminv2n $&gm_xl0_xout_xminv2n
echo RESULT vgs_xl0_xout_xminv2n $&vgs_xl0_xout_xminv2n
echo RESULT vds_xl0_xout_xminv2n $&vds_xl0_xout_xminv2n
echo RESULT vsb_xl0_xout_xminv2n $&vsb_xl0_xout_xminv2n
let vds_xl0_xout_xminv3p = abs(v(rx0_o)[n] - v(vdd)[n])
let vgs_xl0_xout_xminv3p = abs(v(xdut.xl0.xout.i2)[n] - v(vdd)[n])
let vsb_xl0_xout_xminv3p = abs(v(vdd)[n] - v(vdd)[n])
let mg_xl0_xout_xminv3p = vds_xl0_xout_xminv3p - abs(@m.xdut.xl0.xout.xminv3p.m0[vdsat])
let id_xl0_xout_xminv3p = abs(@m.xdut.xl0.xout.xminv3p.m0[id])
let gm_xl0_xout_xminv3p = abs(@m.xdut.xl0.xout.xminv3p.m0[gm])
echo RESULT mg_xl0_xout_xminv3p $&mg_xl0_xout_xminv3p
echo RESULT id_xl0_xout_xminv3p $&id_xl0_xout_xminv3p
echo RESULT gm_xl0_xout_xminv3p $&gm_xl0_xout_xminv3p
echo RESULT vgs_xl0_xout_xminv3p $&vgs_xl0_xout_xminv3p
echo RESULT vds_xl0_xout_xminv3p $&vds_xl0_xout_xminv3p
echo RESULT vsb_xl0_xout_xminv3p $&vsb_xl0_xout_xminv3p
let vds_xl0_xout_xminv3n = abs(v(rx0_o)[n] - 0)
let vgs_xl0_xout_xminv3n = abs(v(xdut.xl0.xout.i2)[n] - 0)
let vsb_xl0_xout_xminv3n = abs(0 - 0)
let mg_xl0_xout_xminv3n = vds_xl0_xout_xminv3n - abs(@m.xdut.xl0.xout.xminv3n.m0[vdsat])
let id_xl0_xout_xminv3n = abs(@m.xdut.xl0.xout.xminv3n.m0[id])
let gm_xl0_xout_xminv3n = abs(@m.xdut.xl0.xout.xminv3n.m0[gm])
echo RESULT mg_xl0_xout_xminv3n $&mg_xl0_xout_xminv3n
echo RESULT id_xl0_xout_xminv3n $&id_xl0_xout_xminv3n
echo RESULT gm_xl0_xout_xminv3n $&gm_xl0_xout_xminv3n
echo RESULT vgs_xl0_xout_xminv3n $&vgs_xl0_xout_xminv3n
echo RESULT vds_xl0_xout_xminv3n $&vds_xl0_xout_xminv3n
echo RESULT vsb_xl0_xout_xminv3n $&vsb_xl0_xout_xminv3n
let vv = v(xdut.xbias.enb)[n]
echo RESULT v_xbias_enb $&vv
let vv = v(en)[n]
echo RESULT v_en $&vv
let vv = v(vdd)[n]
echo RESULT v_vdd $&vv
let vv = v(xdut.xbias.nrb)[n]
echo RESULT v_xbias_nrb $&vv
let vv = v(xdut.vbn)[n]
echo RESULT v_vbn $&vv
let vv = v(xdut.vbp)[n]
echo RESULT v_vbp $&vv
let vv = v(xdut.vb2)[n]
echo RESULT v_vb2 $&vv
let vv = v(xdut.xbias.vf)[n]
echo RESULT v_xbias_vf $&vv
let vv = v(xdut.xbias.nmid)[n]
echo RESULT v_xbias_nmid $&vv
let vv = v(xdut.xl0.xpre.tp)[n]
echo RESULT v_xl0_xpre_tp $&vv
let vv = v(xdut.xl0.xpre.fa)[n]
echo RESULT v_xl0_xpre_fa $&vv
let vv = v(xdut.xl0.gp)[n]
echo RESULT v_xl0_gp $&vv
let vv = v(xdut.xl0.xpre.fb)[n]
echo RESULT v_xl0_xpre_fb $&vv
let vv = v(xdut.xl0.gn)[n]
echo RESULT v_xl0_gn $&vv
let vv = v(xdut.vref)[n]
echo RESULT v_vref $&vv
let vv = v(xdut.xl0.oa)[n]
echo RESULT v_xl0_oa $&vv
let vv = v(xdut.xl0.ob)[n]
echo RESULT v_xl0_ob $&vv
let vv = v(xdut.xl0.xpre.tn)[n]
echo RESULT v_xl0_xpre_tn $&vv
let vv = v(xdut.xl0.xhyst.ts)[n]
echo RESULT v_xl0_xhyst_ts $&vv
let vv = v(xdut.xl0.d2a)[n]
echo RESULT v_xl0_d2a $&vv
let vv = v(xdut.xl0.xhyst.sa)[n]
echo RESULT v_xl0_xhyst_sa $&vv
let vv = v(xdut.xl0.d2b)[n]
echo RESULT v_xl0_d2b $&vv
let vv = v(xdut.xl0.xhyst.sb)[n]
echo RESULT v_xl0_xhyst_sb $&vv
let vv = v(xdut.xl0.xout.n3a)[n]
echo RESULT v_xl0_xout_n3a $&vv
let vv = v(xdut.xl0.xout.d3)[n]
echo RESULT v_xl0_xout_d3 $&vv
let vv = v(xdut.xl0.xout.nd)[n]
echo RESULT v_xl0_xout_nd $&vv
let vv = v(xdut.xl0.xout.nm)[n]
echo RESULT v_xl0_xout_nm $&vv
let vv = v(xdut.xl0.xout.i1)[n]
echo RESULT v_xl0_xout_i1 $&vv
let vv = v(xdut.xl0.xout.i2)[n]
echo RESULT v_xl0_xout_i2 $&vv
let vv = v(rx0_o)[n]
echo RESULT v_rx0_o $&vv
.endc
.end
