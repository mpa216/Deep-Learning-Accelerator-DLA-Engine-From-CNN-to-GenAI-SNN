* NGSPICE file created from gf180mcu_ocd_ip_sram__sram64x8m8wm1.ext - technology: gf180mcuD

.subckt nmos_5p04310591302056_3v64x8m81 D a_0_n44# S VSUBS
X0 D a_0_n44# S VSUBS nfet_03v3 ad=0.3916p pd=2.66u as=0.3916p ps=2.66u w=0.89u l=0.28u
.ends

.subckt nmos_5p04310591302054_3v64x8m81 D a_0_n44# S VSUBS
X0 D a_0_n44# S VSUBS nfet_03v3 ad=1.8634p pd=9.35u as=1.8634p ps=9.35u w=4.235u l=0.28u
.ends

.subckt pmos_5p04310591302055_3v64x8m81 D a_0_n44# w_n174_n86# S
X0 D a_0_n44# S w_n174_n86# pfet_03v3 ad=4.1052p pd=19.54u as=4.1052p ps=19.54u w=9.33u l=0.28u
.ends

.subckt ypredec1_ys_3v64x8m81 nmos_5p04310591302054_3v64x8m81_3/D a_187_1127# pmos_5p04310591302055_3v64x8m81_3/S
+ VSUBS pmos_5p04310591302055_3v64x8m81_3/D
Xnmos_5p04310591302054_3v64x8m81_0 pmos_5p04310591302055_3v64x8m81_3/S pmos_5p04310591302055_3v64x8m81_0/D
+ nmos_5p04310591302054_3v64x8m81_3/D VSUBS nmos_5p04310591302054_3v64x8m81
Xnmos_5p04310591302054_3v64x8m81_1 nmos_5p04310591302054_3v64x8m81_3/D pmos_5p04310591302055_3v64x8m81_0/D
+ pmos_5p04310591302055_3v64x8m81_3/S VSUBS nmos_5p04310591302054_3v64x8m81
Xnmos_5p04310591302054_3v64x8m81_2 pmos_5p04310591302055_3v64x8m81_0/D a_187_1127#
+ nmos_5p04310591302054_3v64x8m81_3/D VSUBS nmos_5p04310591302054_3v64x8m81
Xnmos_5p04310591302054_3v64x8m81_3 nmos_5p04310591302054_3v64x8m81_3/D pmos_5p04310591302055_3v64x8m81_0/D
+ pmos_5p04310591302055_3v64x8m81_3/S VSUBS nmos_5p04310591302054_3v64x8m81
Xpmos_5p04310591302055_3v64x8m81_0 pmos_5p04310591302055_3v64x8m81_0/D a_187_1127#
+ pmos_5p04310591302055_3v64x8m81_3/D pmos_5p04310591302055_3v64x8m81_3/D pmos_5p04310591302055_3v64x8m81
Xpmos_5p04310591302055_3v64x8m81_1 pmos_5p04310591302055_3v64x8m81_3/D pmos_5p04310591302055_3v64x8m81_0/D
+ pmos_5p04310591302055_3v64x8m81_3/D pmos_5p04310591302055_3v64x8m81_3/S pmos_5p04310591302055_3v64x8m81
Xpmos_5p04310591302055_3v64x8m81_2 pmos_5p04310591302055_3v64x8m81_3/S pmos_5p04310591302055_3v64x8m81_0/D
+ pmos_5p04310591302055_3v64x8m81_3/D pmos_5p04310591302055_3v64x8m81_3/D pmos_5p04310591302055_3v64x8m81
Xpmos_5p04310591302055_3v64x8m81_3 pmos_5p04310591302055_3v64x8m81_3/D pmos_5p04310591302055_3v64x8m81_0/D
+ pmos_5p04310591302055_3v64x8m81_3/D pmos_5p04310591302055_3v64x8m81_3/S pmos_5p04310591302055_3v64x8m81
.ends

.subckt pmos_5p04310591302061_3v64x8m81 D a_0_n44# w_n174_n86# S
X0 D a_0_n44# S w_n174_n86# pfet_03v3 ad=1.1836p pd=6.26u as=1.1836p ps=6.26u w=2.69u l=0.28u
.ends

.subckt pmos_1p2$$47820844_3v64x8m81 pmos_5p04310591302061_3v64x8m81_0/S a_n14_n34#
+ pmos_5p04310591302061_3v64x8m81_0/D w_n133_n65#
Xpmos_5p04310591302061_3v64x8m81_0 pmos_5p04310591302061_3v64x8m81_0/D a_n14_n34#
+ w_n133_n65# pmos_5p04310591302061_3v64x8m81_0/S pmos_5p04310591302061_3v64x8m81
.ends

.subckt nmos_5p04310591302010_3v64x8m81 D a_0_n44# S VSUBS
X0 D a_0_n44# S VSUBS nfet_03v3 ad=0.4642p pd=2.99u as=0.4642p ps=2.99u w=1.055u l=0.28u
.ends

.subckt nmos_1p2$$46551084_3v64x8m81 nmos_5p04310591302010_3v64x8m81_0/D a_n14_n34#
+ nmos_5p04310591302010_3v64x8m81_0/S VSUBS
Xnmos_5p04310591302010_3v64x8m81_0 nmos_5p04310591302010_3v64x8m81_0/D a_n14_n34#
+ nmos_5p04310591302010_3v64x8m81_0/S VSUBS nmos_5p04310591302010_3v64x8m81
.ends

.subckt pmos_5p04310591302060_3v64x8m81 D a_0_n44# w_n174_n86# S
X0 D a_0_n44# S w_n174_n86# pfet_03v3 ad=1.1638p pd=6.17u as=1.1638p ps=6.17u w=2.645u l=0.28u
.ends

.subckt pmos_1p2$$47821868_3v64x8m81 pmos_5p04310591302060_3v64x8m81_0/S pmos_5p04310591302060_3v64x8m81_0/D
+ a_n14_n34# w_n133_n66#
Xpmos_5p04310591302060_3v64x8m81_0 pmos_5p04310591302060_3v64x8m81_0/D a_n14_n34#
+ w_n133_n66# pmos_5p04310591302060_3v64x8m81_0/S pmos_5p04310591302060_3v64x8m81
.ends

.subckt ypredec1_xa_3v64x8m81 m1_n40_n2861# pmos_1p2$$47820844_3v64x8m81_2/pmos_5p04310591302061_3v64x8m81_0/D
+ a_145_n4683# m3_0_n4986# m1_n40_n3567# m1_n40_n3285# a_0_56# a_465_n4683# m1_n40_n3426#
+ m1_n40_n3144# pmos_1p2$$47821868_3v64x8m81_3/w_n133_n66# m1_n40_n3003# a_305_n4683#
+ pmos_1p2$$47820844_3v64x8m81_2/w_n133_n65# M3_M2$$47819820_3v64x8m81_0/VSUBS pmos_1p2$$47821868_3v64x8m81_3/pmos_5p04310591302060_3v64x8m81_0/S
Xpmos_1p2$$47820844_3v64x8m81_0 pmos_1p2$$47821868_3v64x8m81_3/pmos_5p04310591302060_3v64x8m81_0/S
+ pmos_1p2$$47821868_3v64x8m81_3/pmos_5p04310591302060_3v64x8m81_0/D pmos_1p2$$47820844_3v64x8m81_2/pmos_5p04310591302061_3v64x8m81_0/D
+ pmos_1p2$$47820844_3v64x8m81_2/w_n133_n65# pmos_1p2$$47820844_3v64x8m81
Xpmos_1p2$$47820844_3v64x8m81_1 pmos_1p2$$47820844_3v64x8m81_2/pmos_5p04310591302061_3v64x8m81_0/D
+ pmos_1p2$$47821868_3v64x8m81_3/pmos_5p04310591302060_3v64x8m81_0/D pmos_1p2$$47821868_3v64x8m81_3/pmos_5p04310591302060_3v64x8m81_0/S
+ pmos_1p2$$47820844_3v64x8m81_2/w_n133_n65# pmos_1p2$$47820844_3v64x8m81
Xnmos_1p2$$46551084_3v64x8m81_0 M3_M2$$47819820_3v64x8m81_0/VSUBS pmos_1p2$$47821868_3v64x8m81_3/pmos_5p04310591302060_3v64x8m81_0/D
+ pmos_1p2$$47820844_3v64x8m81_2/pmos_5p04310591302061_3v64x8m81_0/D M3_M2$$47819820_3v64x8m81_0/VSUBS
+ nmos_1p2$$46551084_3v64x8m81
Xpmos_1p2$$47820844_3v64x8m81_2 pmos_1p2$$47821868_3v64x8m81_3/pmos_5p04310591302060_3v64x8m81_0/S
+ pmos_1p2$$47821868_3v64x8m81_3/pmos_5p04310591302060_3v64x8m81_0/D pmos_1p2$$47820844_3v64x8m81_2/pmos_5p04310591302061_3v64x8m81_0/D
+ pmos_1p2$$47820844_3v64x8m81_2/w_n133_n65# pmos_1p2$$47820844_3v64x8m81
Xpmos_1p2$$47821868_3v64x8m81_0 pmos_1p2$$47821868_3v64x8m81_3/pmos_5p04310591302060_3v64x8m81_0/S
+ pmos_1p2$$47821868_3v64x8m81_3/pmos_5p04310591302060_3v64x8m81_0/D a_145_n4683#
+ pmos_1p2$$47821868_3v64x8m81_3/w_n133_n66# pmos_1p2$$47821868_3v64x8m81
Xnmos_1p2$$46551084_3v64x8m81_1 pmos_1p2$$47820844_3v64x8m81_2/pmos_5p04310591302061_3v64x8m81_0/D
+ pmos_1p2$$47821868_3v64x8m81_3/pmos_5p04310591302060_3v64x8m81_0/D M3_M2$$47819820_3v64x8m81_0/VSUBS
+ M3_M2$$47819820_3v64x8m81_0/VSUBS nmos_1p2$$46551084_3v64x8m81
Xnmos_1p2$$46551084_3v64x8m81_2 pmos_1p2$$47820844_3v64x8m81_2/pmos_5p04310591302061_3v64x8m81_0/D
+ pmos_1p2$$47821868_3v64x8m81_3/pmos_5p04310591302060_3v64x8m81_0/D M3_M2$$47819820_3v64x8m81_0/VSUBS
+ M3_M2$$47819820_3v64x8m81_0/VSUBS nmos_1p2$$46551084_3v64x8m81
Xpmos_1p2$$47821868_3v64x8m81_2 pmos_1p2$$47821868_3v64x8m81_3/pmos_5p04310591302060_3v64x8m81_0/D
+ pmos_1p2$$47821868_3v64x8m81_3/pmos_5p04310591302060_3v64x8m81_0/S a_305_n4683#
+ pmos_1p2$$47821868_3v64x8m81_3/w_n133_n66# pmos_1p2$$47821868_3v64x8m81
Xpmos_1p2$$47821868_3v64x8m81_3 pmos_1p2$$47821868_3v64x8m81_3/pmos_5p04310591302060_3v64x8m81_0/S
+ pmos_1p2$$47821868_3v64x8m81_3/pmos_5p04310591302060_3v64x8m81_0/D a_465_n4683#
+ pmos_1p2$$47821868_3v64x8m81_3/w_n133_n66# pmos_1p2$$47821868_3v64x8m81
X0 a_361_n4624# a_305_n4683# a_201_n4624# M3_M2$$47819820_3v64x8m81_0/VSUBS nfet_03v3 ad=0.8268p pd=3.7u as=0.8268p ps=3.7u w=3.18u l=0.28u
X1 a_201_n4624# a_145_n4683# M3_M2$$47819820_3v64x8m81_0/VSUBS M3_M2$$47819820_3v64x8m81_0/VSUBS nfet_03v3 ad=0.8268p pd=3.7u as=1.4469p ps=7.27u w=3.18u l=0.28u
X2 pmos_1p2$$47821868_3v64x8m81_3/pmos_5p04310591302060_3v64x8m81_0/D a_465_n4683# a_361_n4624# M3_M2$$47819820_3v64x8m81_0/VSUBS nfet_03v3 ad=1.5423p pd=7.33u as=0.8268p ps=3.7u w=3.18u l=0.28u
.ends

.subckt ypredec1_xax8_3v64x8m81 ypredec1_xa_3v64x8m81_7/a_305_n4683# ypredec1_xa_3v64x8m81_5/a_0_56#
+ ypredec1_xa_3v64x8m81_6/pmos_1p2$$47820844_3v64x8m81_2/pmos_5p04310591302061_3v64x8m81_0/D
+ ypredec1_xa_3v64x8m81_4/pmos_1p2$$47820844_3v64x8m81_2/pmos_5p04310591302061_3v64x8m81_0/D
+ ypredec1_xa_3v64x8m81_7/a_465_n4683# ypredec1_xa_3v64x8m81_2/pmos_1p2$$47820844_3v64x8m81_2/pmos_5p04310591302061_3v64x8m81_0/D
+ ypredec1_xa_3v64x8m81_0/pmos_1p2$$47820844_3v64x8m81_2/pmos_5p04310591302061_3v64x8m81_0/D
+ ypredec1_xa_3v64x8m81_7/pmos_1p2$$47821868_3v64x8m81_3/w_n133_n66# ypredec1_xa_3v64x8m81_7/pmos_1p2$$47820844_3v64x8m81_2/pmos_5p04310591302061_3v64x8m81_0/D
+ ypredec1_xa_3v64x8m81_5/pmos_1p2$$47820844_3v64x8m81_2/pmos_5p04310591302061_3v64x8m81_0/D
+ ypredec1_xa_3v64x8m81_7/a_145_n4683# ypredec1_xa_3v64x8m81_7/pmos_1p2$$47821868_3v64x8m81_3/pmos_5p04310591302060_3v64x8m81_0/S
+ ypredec1_xa_3v64x8m81_3/pmos_1p2$$47820844_3v64x8m81_2/pmos_5p04310591302061_3v64x8m81_0/D
+ ypredec1_xa_3v64x8m81_5/a_465_n4683# ypredec1_xa_3v64x8m81_1/pmos_1p2$$47820844_3v64x8m81_2/pmos_5p04310591302061_3v64x8m81_0/D
+ ypredec1_xa_3v64x8m81_7/pmos_1p2$$47820844_3v64x8m81_2/w_n133_n65# ypredec1_xa_3v64x8m81_6/a_305_n4683#
+ ypredec1_xa_3v64x8m81_3/a_145_n4683# VSUBS
Xypredec1_xa_3v64x8m81_1 ypredec1_xa_3v64x8m81_7/a_465_n4683# ypredec1_xa_3v64x8m81_1/pmos_1p2$$47820844_3v64x8m81_2/pmos_5p04310591302061_3v64x8m81_0/D
+ ypredec1_xa_3v64x8m81_3/a_145_n4683# VSUBS ypredec1_xa_3v64x8m81_7/a_145_n4683#
+ ypredec1_xa_3v64x8m81_5/a_465_n4683# ypredec1_xa_3v64x8m81_5/a_0_56# ypredec1_xa_3v64x8m81_5/a_465_n4683#
+ ypredec1_xa_3v64x8m81_6/a_305_n4683# ypredec1_xa_3v64x8m81_3/a_145_n4683# ypredec1_xa_3v64x8m81_7/pmos_1p2$$47821868_3v64x8m81_3/w_n133_n66#
+ ypredec1_xa_3v64x8m81_7/a_305_n4683# ypredec1_xa_3v64x8m81_6/a_305_n4683# ypredec1_xa_3v64x8m81_7/pmos_1p2$$47820844_3v64x8m81_2/w_n133_n65#
+ VSUBS ypredec1_xa_3v64x8m81_7/pmos_1p2$$47821868_3v64x8m81_3/pmos_5p04310591302060_3v64x8m81_0/S
+ ypredec1_xa_3v64x8m81
Xypredec1_xa_3v64x8m81_2 ypredec1_xa_3v64x8m81_7/a_465_n4683# ypredec1_xa_3v64x8m81_2/pmos_1p2$$47820844_3v64x8m81_2/pmos_5p04310591302061_3v64x8m81_0/D
+ ypredec1_xa_3v64x8m81_3/a_145_n4683# VSUBS ypredec1_xa_3v64x8m81_7/a_145_n4683#
+ ypredec1_xa_3v64x8m81_5/a_465_n4683# VSUBS ypredec1_xa_3v64x8m81_7/a_465_n4683#
+ ypredec1_xa_3v64x8m81_6/a_305_n4683# ypredec1_xa_3v64x8m81_3/a_145_n4683# ypredec1_xa_3v64x8m81_7/pmos_1p2$$47821868_3v64x8m81_3/w_n133_n66#
+ ypredec1_xa_3v64x8m81_7/a_305_n4683# ypredec1_xa_3v64x8m81_6/a_305_n4683# ypredec1_xa_3v64x8m81_7/pmos_1p2$$47820844_3v64x8m81_2/w_n133_n65#
+ VSUBS ypredec1_xa_3v64x8m81_7/pmos_1p2$$47821868_3v64x8m81_3/pmos_5p04310591302060_3v64x8m81_0/S
+ ypredec1_xa_3v64x8m81
Xypredec1_xa_3v64x8m81_3 ypredec1_xa_3v64x8m81_7/a_465_n4683# ypredec1_xa_3v64x8m81_3/pmos_1p2$$47820844_3v64x8m81_2/pmos_5p04310591302061_3v64x8m81_0/D
+ ypredec1_xa_3v64x8m81_3/a_145_n4683# VSUBS ypredec1_xa_3v64x8m81_7/a_145_n4683#
+ ypredec1_xa_3v64x8m81_5/a_465_n4683# ypredec1_xa_3v64x8m81_3/a_0_56# ypredec1_xa_3v64x8m81_7/a_465_n4683#
+ ypredec1_xa_3v64x8m81_6/a_305_n4683# ypredec1_xa_3v64x8m81_3/a_145_n4683# ypredec1_xa_3v64x8m81_7/pmos_1p2$$47821868_3v64x8m81_3/w_n133_n66#
+ ypredec1_xa_3v64x8m81_7/a_305_n4683# ypredec1_xa_3v64x8m81_7/a_305_n4683# ypredec1_xa_3v64x8m81_7/pmos_1p2$$47820844_3v64x8m81_2/w_n133_n65#
+ VSUBS ypredec1_xa_3v64x8m81_7/pmos_1p2$$47821868_3v64x8m81_3/pmos_5p04310591302060_3v64x8m81_0/S
+ ypredec1_xa_3v64x8m81
Xypredec1_xa_3v64x8m81_4 ypredec1_xa_3v64x8m81_7/a_465_n4683# ypredec1_xa_3v64x8m81_4/pmos_1p2$$47820844_3v64x8m81_2/pmos_5p04310591302061_3v64x8m81_0/D
+ ypredec1_xa_3v64x8m81_7/a_145_n4683# VSUBS ypredec1_xa_3v64x8m81_7/a_145_n4683#
+ ypredec1_xa_3v64x8m81_5/a_465_n4683# ypredec1_xa_3v64x8m81_4/a_0_56# ypredec1_xa_3v64x8m81_5/a_465_n4683#
+ ypredec1_xa_3v64x8m81_6/a_305_n4683# ypredec1_xa_3v64x8m81_3/a_145_n4683# ypredec1_xa_3v64x8m81_7/pmos_1p2$$47821868_3v64x8m81_3/w_n133_n66#
+ ypredec1_xa_3v64x8m81_7/a_305_n4683# ypredec1_xa_3v64x8m81_7/a_305_n4683# ypredec1_xa_3v64x8m81_7/pmos_1p2$$47820844_3v64x8m81_2/w_n133_n65#
+ VSUBS ypredec1_xa_3v64x8m81_7/pmos_1p2$$47821868_3v64x8m81_3/pmos_5p04310591302060_3v64x8m81_0/S
+ ypredec1_xa_3v64x8m81
Xypredec1_xa_3v64x8m81_5 ypredec1_xa_3v64x8m81_7/a_465_n4683# ypredec1_xa_3v64x8m81_5/pmos_1p2$$47820844_3v64x8m81_2/pmos_5p04310591302061_3v64x8m81_0/D
+ ypredec1_xa_3v64x8m81_7/a_145_n4683# VSUBS ypredec1_xa_3v64x8m81_7/a_145_n4683#
+ ypredec1_xa_3v64x8m81_5/a_465_n4683# ypredec1_xa_3v64x8m81_5/a_0_56# ypredec1_xa_3v64x8m81_5/a_465_n4683#
+ ypredec1_xa_3v64x8m81_6/a_305_n4683# ypredec1_xa_3v64x8m81_3/a_145_n4683# ypredec1_xa_3v64x8m81_7/pmos_1p2$$47821868_3v64x8m81_3/w_n133_n66#
+ ypredec1_xa_3v64x8m81_7/a_305_n4683# ypredec1_xa_3v64x8m81_6/a_305_n4683# ypredec1_xa_3v64x8m81_7/pmos_1p2$$47820844_3v64x8m81_2/w_n133_n65#
+ VSUBS ypredec1_xa_3v64x8m81_7/pmos_1p2$$47821868_3v64x8m81_3/pmos_5p04310591302060_3v64x8m81_0/S
+ ypredec1_xa_3v64x8m81
Xypredec1_xa_3v64x8m81_6 ypredec1_xa_3v64x8m81_7/a_465_n4683# ypredec1_xa_3v64x8m81_6/pmos_1p2$$47820844_3v64x8m81_2/pmos_5p04310591302061_3v64x8m81_0/D
+ ypredec1_xa_3v64x8m81_7/a_145_n4683# VSUBS ypredec1_xa_3v64x8m81_7/a_145_n4683#
+ ypredec1_xa_3v64x8m81_5/a_465_n4683# ypredec1_xa_3v64x8m81_6/a_0_56# ypredec1_xa_3v64x8m81_7/a_465_n4683#
+ ypredec1_xa_3v64x8m81_6/a_305_n4683# ypredec1_xa_3v64x8m81_3/a_145_n4683# ypredec1_xa_3v64x8m81_7/pmos_1p2$$47821868_3v64x8m81_3/w_n133_n66#
+ ypredec1_xa_3v64x8m81_7/a_305_n4683# ypredec1_xa_3v64x8m81_6/a_305_n4683# ypredec1_xa_3v64x8m81_7/pmos_1p2$$47820844_3v64x8m81_2/w_n133_n65#
+ VSUBS ypredec1_xa_3v64x8m81_7/pmos_1p2$$47821868_3v64x8m81_3/pmos_5p04310591302060_3v64x8m81_0/S
+ ypredec1_xa_3v64x8m81
Xypredec1_xa_3v64x8m81_7 ypredec1_xa_3v64x8m81_7/a_465_n4683# ypredec1_xa_3v64x8m81_7/pmos_1p2$$47820844_3v64x8m81_2/pmos_5p04310591302061_3v64x8m81_0/D
+ ypredec1_xa_3v64x8m81_7/a_145_n4683# VSUBS ypredec1_xa_3v64x8m81_7/a_145_n4683#
+ ypredec1_xa_3v64x8m81_5/a_465_n4683# ypredec1_xa_3v64x8m81_7/a_0_56# ypredec1_xa_3v64x8m81_7/a_465_n4683#
+ ypredec1_xa_3v64x8m81_6/a_305_n4683# ypredec1_xa_3v64x8m81_3/a_145_n4683# ypredec1_xa_3v64x8m81_7/pmos_1p2$$47821868_3v64x8m81_3/w_n133_n66#
+ ypredec1_xa_3v64x8m81_7/a_305_n4683# ypredec1_xa_3v64x8m81_7/a_305_n4683# ypredec1_xa_3v64x8m81_7/pmos_1p2$$47820844_3v64x8m81_2/w_n133_n65#
+ VSUBS ypredec1_xa_3v64x8m81_7/pmos_1p2$$47821868_3v64x8m81_3/pmos_5p04310591302060_3v64x8m81_0/S
+ ypredec1_xa_3v64x8m81
Xypredec1_xa_3v64x8m81_0 ypredec1_xa_3v64x8m81_7/a_465_n4683# ypredec1_xa_3v64x8m81_0/pmos_1p2$$47820844_3v64x8m81_2/pmos_5p04310591302061_3v64x8m81_0/D
+ ypredec1_xa_3v64x8m81_3/a_145_n4683# VSUBS ypredec1_xa_3v64x8m81_7/a_145_n4683#
+ ypredec1_xa_3v64x8m81_5/a_465_n4683# ypredec1_xa_3v64x8m81_0/a_0_56# ypredec1_xa_3v64x8m81_5/a_465_n4683#
+ ypredec1_xa_3v64x8m81_6/a_305_n4683# ypredec1_xa_3v64x8m81_3/a_145_n4683# ypredec1_xa_3v64x8m81_7/pmos_1p2$$47821868_3v64x8m81_3/w_n133_n66#
+ ypredec1_xa_3v64x8m81_7/a_305_n4683# ypredec1_xa_3v64x8m81_7/a_305_n4683# ypredec1_xa_3v64x8m81_7/pmos_1p2$$47820844_3v64x8m81_2/w_n133_n65#
+ VSUBS ypredec1_xa_3v64x8m81_7/pmos_1p2$$47821868_3v64x8m81_3/pmos_5p04310591302060_3v64x8m81_0/S
+ ypredec1_xa_3v64x8m81
.ends

.subckt pmos_5p04310591302062_3v64x8m81 D a_n28_n44# a_132_n44# w_n202_n86# S_uq0
+ S
X0 D a_n28_n44# S w_n202_n86# pfet_03v3 ad=0.2067p pd=1.315u as=0.3498p ps=2.47u w=0.795u l=0.28u
X1 S_uq0 a_132_n44# D w_n202_n86# pfet_03v3 ad=0.3498p pd=2.47u as=0.2067p ps=1.315u w=0.795u l=0.28u
.ends

.subckt pmos_1p2$$47109164_3v64x8m81 pmos_5p04310591302062_3v64x8m81_0/w_n202_n86#
+ pmos_5p04310591302062_3v64x8m81_0/D a_118_159# pmos_5p04310591302062_3v64x8m81_0/S_uq0
+ pmos_5p04310591302062_3v64x8m81_0/S a_n42_159#
Xpmos_5p04310591302062_3v64x8m81_0 pmos_5p04310591302062_3v64x8m81_0/D a_n42_159#
+ a_118_159# pmos_5p04310591302062_3v64x8m81_0/w_n202_n86# pmos_5p04310591302062_3v64x8m81_0/S_uq0
+ pmos_5p04310591302062_3v64x8m81_0/S pmos_5p04310591302062_3v64x8m81
.ends

.subckt nmos_5p04310591302057_3v64x8m81 D a_0_n44# S VSUBS
X0 D a_0_n44# S VSUBS nfet_03v3 ad=0.9306p pd=5.11u as=0.9306p ps=5.11u w=2.115u l=0.28u
.ends

.subckt nmos_1p2$$47514668_3v64x8m81 nmos_5p04310591302057_3v64x8m81_0/S a_n14_n34#
+ nmos_5p04310591302057_3v64x8m81_0/D VSUBS
Xnmos_5p04310591302057_3v64x8m81_0 nmos_5p04310591302057_3v64x8m81_0/D a_n14_n34#
+ nmos_5p04310591302057_3v64x8m81_0/S VSUBS nmos_5p04310591302057_3v64x8m81
.ends

.subckt pmos_5p0431059130204_3v64x8m81 D a_0_n44# w_n174_n86# S
X0 D a_0_n44# S w_n174_n86# pfet_03v3 ad=2.794p pd=13.58u as=2.794p ps=13.58u w=6.35u l=0.28u
.ends

.subckt pmos_1p2$$46887980_3v64x8m81 w_n133_n66# pmos_5p0431059130204_3v64x8m81_0/D
+ pmos_5p0431059130204_3v64x8m81_0/S a_n14_n34#
Xpmos_5p0431059130204_3v64x8m81_0 pmos_5p0431059130204_3v64x8m81_0/D a_n14_n34# w_n133_n66#
+ pmos_5p0431059130204_3v64x8m81_0/S pmos_5p0431059130204_3v64x8m81
.ends

.subckt nmos_5p0431059130208_3v64x8m81 D a_0_n44# S VSUBS
X0 D a_0_n44# S VSUBS nfet_03v3 ad=0.1958p pd=1.77u as=0.1958p ps=1.77u w=0.445u l=0.28u
.ends

.subckt pmos_5p04310591302058_3v64x8m81 D a_n28_n44# a_132_n44# w_n202_n86# S_uq0
+ S
X0 D a_n28_n44# S w_n202_n86# pfet_03v3 ad=0.5499p pd=2.635u as=0.9306p ps=5.11u w=2.115u l=0.28u
X1 S_uq0 a_132_n44# D w_n202_n86# pfet_03v3 ad=0.9306p pd=5.11u as=0.5499p ps=2.635u w=2.115u l=0.28u
.ends

.subckt pmos_1p2$$47331372_3v64x8m81 a_n42_n34# w_n133_n66# pmos_5p04310591302058_3v64x8m81_0/D
+ pmos_5p04310591302058_3v64x8m81_0/S_uq0 a_118_n34# pmos_5p04310591302058_3v64x8m81_0/S
Xpmos_5p04310591302058_3v64x8m81_0 pmos_5p04310591302058_3v64x8m81_0/D a_n42_n34#
+ a_118_n34# w_n133_n66# pmos_5p04310591302058_3v64x8m81_0/S_uq0 pmos_5p04310591302058_3v64x8m81_0/S
+ pmos_5p04310591302058_3v64x8m81
.ends

.subckt nmos_5p04310591302059_3v64x8m81 D a_n28_n44# a_132_n44# S_uq0 S VSUBS
X0 D a_n28_n44# S VSUBS nfet_03v3 ad=0.2197p pd=1.365u as=0.3718p ps=2.57u w=0.845u l=0.28u
X1 S_uq0 a_132_n44# D VSUBS nfet_03v3 ad=0.3718p pd=2.57u as=0.2197p ps=1.365u w=0.845u l=0.28u
.ends

.subckt nmos_1p2$$47329324_3v64x8m81 a_118_n34# a_n41_n34# nmos_5p04310591302059_3v64x8m81_0/S_uq0
+ nmos_5p04310591302059_3v64x8m81_0/S nmos_5p04310591302059_3v64x8m81_0/D VSUBS
Xnmos_5p04310591302059_3v64x8m81_0 nmos_5p04310591302059_3v64x8m81_0/D a_n41_n34#
+ a_118_n34# nmos_5p04310591302059_3v64x8m81_0/S_uq0 nmos_5p04310591302059_3v64x8m81_0/S
+ VSUBS nmos_5p04310591302059_3v64x8m81
.ends

.subckt nmos_1p2_157_3v64x8m81 nmos_5p04310591302010_3v64x8m81_0/D a_n14_n34# nmos_5p04310591302010_3v64x8m81_0/S
+ VSUBS
Xnmos_5p04310591302010_3v64x8m81_0 nmos_5p04310591302010_3v64x8m81_0/D a_n14_n34#
+ nmos_5p04310591302010_3v64x8m81_0/S VSUBS nmos_5p04310591302010_3v64x8m81
.ends

.subckt pmos_5p04310591302041_3v64x8m81 D a_0_n44# w_n174_n86# S
X0 D a_0_n44# S w_n174_n86# pfet_03v3 ad=0.1958p pd=1.77u as=0.1958p ps=1.77u w=0.445u l=0.28u
.ends

.subckt pmos_1p2_161_3v64x8m81 pmos_5p04310591302041_3v64x8m81_0/D a_n14_89# pmos_5p04310591302041_3v64x8m81_0/S
+ w_n133_n65#
Xpmos_5p04310591302041_3v64x8m81_0 pmos_5p04310591302041_3v64x8m81_0/D a_n14_89# w_n133_n65#
+ pmos_5p04310591302041_3v64x8m81_0/S pmos_5p04310591302041_3v64x8m81
.ends

.subckt pmos_5p04310591302014_3v64x8m81 D a_0_n44# w_n174_n86# S
X0 D a_0_n44# S w_n174_n86# pfet_03v3 ad=0.4642p pd=2.99u as=0.4642p ps=2.99u w=1.055u l=0.28u
.ends

.subckt pmos_1p2_160_3v64x8m81 w_n133_n66# pmos_5p04310591302014_3v64x8m81_0/S pmos_5p04310591302014_3v64x8m81_0/D
+ a_n14_n34#
Xpmos_5p04310591302014_3v64x8m81_0 pmos_5p04310591302014_3v64x8m81_0/D a_n14_n34#
+ w_n133_n66# pmos_5p04310591302014_3v64x8m81_0/S pmos_5p04310591302014_3v64x8m81
.ends

.subckt alatch_3v64x8m81 enb en ab a vdd vss
Xnmos_5p0431059130208_3v64x8m81_0 vss ab nmos_5p0431059130208_3v64x8m81_1/D vss nmos_5p0431059130208_3v64x8m81
Xnmos_5p0431059130208_3v64x8m81_1 nmos_5p0431059130208_3v64x8m81_1/D enb nmos_5p0431059130208_3v64x8m81_1/S
+ vss nmos_5p0431059130208_3v64x8m81
Xpmos_1p2$$47331372_3v64x8m81_0 nmos_5p0431059130208_3v64x8m81_1/S vdd ab vdd nmos_5p0431059130208_3v64x8m81_1/S
+ vdd pmos_1p2$$47331372_3v64x8m81
Xnmos_1p2$$47329324_3v64x8m81_0 nmos_5p0431059130208_3v64x8m81_1/S nmos_5p0431059130208_3v64x8m81_1/S
+ vss vss ab vss nmos_1p2$$47329324_3v64x8m81
Xnmos_1p2_157_3v64x8m81_0 a en nmos_5p0431059130208_3v64x8m81_1/S vss nmos_1p2_157_3v64x8m81
Xpmos_1p2_161_3v64x8m81_1 vdd ab nmos_5p0431059130208_3v64x8m81_1/D vdd pmos_1p2_161_3v64x8m81
Xpmos_1p2_161_3v64x8m81_0 nmos_5p0431059130208_3v64x8m81_1/D en nmos_5p0431059130208_3v64x8m81_1/S
+ vdd pmos_1p2_161_3v64x8m81
Xpmos_1p2_160_3v64x8m81_0 vdd nmos_5p0431059130208_3v64x8m81_1/S a enb pmos_1p2_160_3v64x8m81
.ends

.subckt ypredec1_bot_3v64x8m81 m1_n9_2295# pmos_1p2$$46887980_3v64x8m81_0/pmos_5p0431059130204_3v64x8m81_0/D
+ m1_n9_2436# m1_n9_2154# m1_n9_2013# pmos_1p2$$46887980_3v64x8m81_1/pmos_5p0431059130204_3v64x8m81_0/S
+ m1_n9_1871# m1_n9_1730# pmos_1p2$$46887980_3v64x8m81_1/pmos_5p0431059130204_3v64x8m81_0/D
+ alatch_3v64x8m81_0/a alatch_3v64x8m81_0/enb alatch_3v64x8m81_0/vdd VSUBS alatch_3v64x8m81_0/en
Xnmos_1p2$$47514668_3v64x8m81_0 VSUBS pmos_1p2$$46887980_3v64x8m81_1/pmos_5p0431059130204_3v64x8m81_0/D
+ pmos_1p2$$46887980_3v64x8m81_0/pmos_5p0431059130204_3v64x8m81_0/D VSUBS nmos_1p2$$47514668_3v64x8m81
Xnmos_1p2$$47514668_3v64x8m81_1 VSUBS alatch_3v64x8m81_0/ab pmos_1p2$$46887980_3v64x8m81_1/pmos_5p0431059130204_3v64x8m81_0/D
+ VSUBS nmos_1p2$$47514668_3v64x8m81
Xpmos_1p2$$46887980_3v64x8m81_0 pmos_1p2$$46887980_3v64x8m81_1/pmos_5p0431059130204_3v64x8m81_0/S
+ pmos_1p2$$46887980_3v64x8m81_0/pmos_5p0431059130204_3v64x8m81_0/D pmos_1p2$$46887980_3v64x8m81_1/pmos_5p0431059130204_3v64x8m81_0/S
+ pmos_1p2$$46887980_3v64x8m81_1/pmos_5p0431059130204_3v64x8m81_0/D pmos_1p2$$46887980_3v64x8m81
Xpmos_1p2$$46887980_3v64x8m81_1 pmos_1p2$$46887980_3v64x8m81_1/pmos_5p0431059130204_3v64x8m81_0/S
+ pmos_1p2$$46887980_3v64x8m81_1/pmos_5p0431059130204_3v64x8m81_0/D pmos_1p2$$46887980_3v64x8m81_1/pmos_5p0431059130204_3v64x8m81_0/S
+ alatch_3v64x8m81_0/ab pmos_1p2$$46887980_3v64x8m81
Xalatch_3v64x8m81_0 alatch_3v64x8m81_0/enb alatch_3v64x8m81_0/en alatch_3v64x8m81_0/ab
+ alatch_3v64x8m81_0/a alatch_3v64x8m81_0/vdd VSUBS alatch_3v64x8m81
.ends

.subckt nmos_5p04310591302053_3v64x8m81 D a_0_n44# S VSUBS
X0 D a_0_n44# S VSUBS nfet_03v3 ad=0.2772p pd=2.14u as=0.2772p ps=2.14u w=0.63u l=0.28u
.ends

.subckt nmos_1p2$$47342636_3v64x8m81 nmos_5p04310591302053_3v64x8m81_0/S nmos_5p04310591302053_3v64x8m81_0/D
+ a_n14_n34# VSUBS
Xnmos_5p04310591302053_3v64x8m81_0 nmos_5p04310591302053_3v64x8m81_0/D a_n14_n34#
+ nmos_5p04310591302053_3v64x8m81_0/S VSUBS nmos_5p04310591302053_3v64x8m81
.ends

.subckt ypredec1_3v64x8m81 ly[5] ly[4] ly[7] ly[3] ly[2] ly[1] ly[0] ry[0] ry[1] ry[2]
+ ry[3] ry[4] ry[5] ry[6] ry[7] ly[6] men A[0] A[1] A[2] clk pmos_1p2$$47109164_3v64x8m81_0/pmos_5p04310591302062_3v64x8m81_0/w_n202_n86#
+ pmos_1p2$$47109164_3v64x8m81_0/pmos_5p04310591302062_3v64x8m81_0/S ypredec1_bot_3v64x8m81_2/alatch_3v64x8m81_0/vdd
+ M1_NWELL13_3v64x8m81_0/VSUBS ypredec1_bot_3v64x8m81_2/pmos_1p2$$46887980_3v64x8m81_1/pmos_5p0431059130204_3v64x8m81_0/S
+ ypredec1_ys_3v64x8m81_9/pmos_5p04310591302055_3v64x8m81_3/D
Xnmos_5p04310591302056_3v64x8m81_0 M1_NWELL13_3v64x8m81_0/VSUBS clk nmos_5p04310591302056_3v64x8m81_1/D
+ M1_NWELL13_3v64x8m81_0/VSUBS nmos_5p04310591302056_3v64x8m81
Xypredec1_ys_3v64x8m81_9 M1_NWELL13_3v64x8m81_0/VSUBS ypredec1_xax8_3v64x8m81_0/ypredec1_xa_3v64x8m81_3/pmos_1p2$$47820844_3v64x8m81_2/pmos_5p04310591302061_3v64x8m81_0/D
+ ry[7] M1_NWELL13_3v64x8m81_0/VSUBS ypredec1_ys_3v64x8m81_9/pmos_5p04310591302055_3v64x8m81_3/D
+ ypredec1_ys_3v64x8m81
Xnmos_5p04310591302056_3v64x8m81_1 nmos_5p04310591302056_3v64x8m81_1/D men M1_NWELL13_3v64x8m81_0/VSUBS
+ M1_NWELL13_3v64x8m81_0/VSUBS nmos_5p04310591302056_3v64x8m81
Xypredec1_xax8_3v64x8m81_0 ypredec1_bot_3v64x8m81_2/pmos_1p2$$46887980_3v64x8m81_1/pmos_5p0431059130204_3v64x8m81_0/D
+ M1_NWELL13_3v64x8m81_0/VSUBS ypredec1_xax8_3v64x8m81_0/ypredec1_xa_3v64x8m81_6/pmos_1p2$$47820844_3v64x8m81_2/pmos_5p04310591302061_3v64x8m81_0/D
+ ypredec1_xax8_3v64x8m81_0/ypredec1_xa_3v64x8m81_4/pmos_1p2$$47820844_3v64x8m81_2/pmos_5p04310591302061_3v64x8m81_0/D
+ ypredec1_bot_3v64x8m81_1/pmos_1p2$$46887980_3v64x8m81_1/pmos_5p0431059130204_3v64x8m81_0/D
+ ypredec1_xax8_3v64x8m81_0/ypredec1_xa_3v64x8m81_2/pmos_1p2$$47820844_3v64x8m81_2/pmos_5p04310591302061_3v64x8m81_0/D
+ ypredec1_xax8_3v64x8m81_0/ypredec1_xa_3v64x8m81_0/pmos_1p2$$47820844_3v64x8m81_2/pmos_5p04310591302061_3v64x8m81_0/D
+ ypredec1_bot_3v64x8m81_2/pmos_1p2$$46887980_3v64x8m81_1/pmos_5p0431059130204_3v64x8m81_0/S
+ ypredec1_xax8_3v64x8m81_0/ypredec1_xa_3v64x8m81_7/pmos_1p2$$47820844_3v64x8m81_2/pmos_5p04310591302061_3v64x8m81_0/D
+ ypredec1_xax8_3v64x8m81_0/ypredec1_xa_3v64x8m81_5/pmos_1p2$$47820844_3v64x8m81_2/pmos_5p04310591302061_3v64x8m81_0/D
+ ypredec1_bot_3v64x8m81_0/pmos_1p2$$46887980_3v64x8m81_0/pmos_5p0431059130204_3v64x8m81_0/D
+ ypredec1_bot_3v64x8m81_2/pmos_1p2$$46887980_3v64x8m81_1/pmos_5p0431059130204_3v64x8m81_0/S
+ ypredec1_xax8_3v64x8m81_0/ypredec1_xa_3v64x8m81_3/pmos_1p2$$47820844_3v64x8m81_2/pmos_5p04310591302061_3v64x8m81_0/D
+ ypredec1_bot_3v64x8m81_1/pmos_1p2$$46887980_3v64x8m81_0/pmos_5p0431059130204_3v64x8m81_0/D
+ ypredec1_xax8_3v64x8m81_0/ypredec1_xa_3v64x8m81_1/pmos_1p2$$47820844_3v64x8m81_2/pmos_5p04310591302061_3v64x8m81_0/D
+ ypredec1_bot_3v64x8m81_2/pmos_1p2$$46887980_3v64x8m81_1/pmos_5p0431059130204_3v64x8m81_0/S
+ ypredec1_bot_3v64x8m81_2/pmos_1p2$$46887980_3v64x8m81_0/pmos_5p0431059130204_3v64x8m81_0/D
+ ypredec1_bot_3v64x8m81_0/pmos_1p2$$46887980_3v64x8m81_1/pmos_5p0431059130204_3v64x8m81_0/D
+ M1_NWELL13_3v64x8m81_0/VSUBS ypredec1_xax8_3v64x8m81
Xpmos_1p2$$47109164_3v64x8m81_0 pmos_1p2$$47109164_3v64x8m81_0/pmos_5p04310591302062_3v64x8m81_0/w_n202_n86#
+ ypredec1_bot_3v64x8m81_2/alatch_3v64x8m81_0/enb nmos_5p04310591302056_3v64x8m81_1/D
+ pmos_1p2$$47109164_3v64x8m81_0/pmos_5p04310591302062_3v64x8m81_0/S pmos_1p2$$47109164_3v64x8m81_0/pmos_5p04310591302062_3v64x8m81_0/S
+ nmos_5p04310591302056_3v64x8m81_1/D pmos_1p2$$47109164_3v64x8m81
Xypredec1_bot_3v64x8m81_0 ypredec1_bot_3v64x8m81_2/pmos_1p2$$46887980_3v64x8m81_1/pmos_5p0431059130204_3v64x8m81_0/D
+ ypredec1_bot_3v64x8m81_0/pmos_1p2$$46887980_3v64x8m81_0/pmos_5p0431059130204_3v64x8m81_0/D
+ ypredec1_bot_3v64x8m81_1/pmos_1p2$$46887980_3v64x8m81_1/pmos_5p0431059130204_3v64x8m81_0/D
+ ypredec1_bot_3v64x8m81_0/pmos_1p2$$46887980_3v64x8m81_1/pmos_5p0431059130204_3v64x8m81_0/D
+ ypredec1_bot_3v64x8m81_1/pmos_1p2$$46887980_3v64x8m81_0/pmos_5p0431059130204_3v64x8m81_0/D
+ ypredec1_bot_3v64x8m81_2/pmos_1p2$$46887980_3v64x8m81_1/pmos_5p0431059130204_3v64x8m81_0/S
+ ypredec1_bot_3v64x8m81_2/pmos_1p2$$46887980_3v64x8m81_0/pmos_5p0431059130204_3v64x8m81_0/D
+ ypredec1_bot_3v64x8m81_0/pmos_1p2$$46887980_3v64x8m81_0/pmos_5p0431059130204_3v64x8m81_0/D
+ ypredec1_bot_3v64x8m81_0/pmos_1p2$$46887980_3v64x8m81_1/pmos_5p0431059130204_3v64x8m81_0/D
+ A[0] ypredec1_bot_3v64x8m81_2/alatch_3v64x8m81_0/enb ypredec1_bot_3v64x8m81_2/alatch_3v64x8m81_0/vdd
+ M1_NWELL13_3v64x8m81_0/VSUBS nmos_5p04310591302056_3v64x8m81_1/D ypredec1_bot_3v64x8m81
Xypredec1_bot_3v64x8m81_1 ypredec1_bot_3v64x8m81_2/pmos_1p2$$46887980_3v64x8m81_1/pmos_5p0431059130204_3v64x8m81_0/D
+ ypredec1_bot_3v64x8m81_1/pmos_1p2$$46887980_3v64x8m81_0/pmos_5p0431059130204_3v64x8m81_0/D
+ ypredec1_bot_3v64x8m81_1/pmos_1p2$$46887980_3v64x8m81_1/pmos_5p0431059130204_3v64x8m81_0/D
+ ypredec1_bot_3v64x8m81_0/pmos_1p2$$46887980_3v64x8m81_1/pmos_5p0431059130204_3v64x8m81_0/D
+ ypredec1_bot_3v64x8m81_1/pmos_1p2$$46887980_3v64x8m81_0/pmos_5p0431059130204_3v64x8m81_0/D
+ ypredec1_bot_3v64x8m81_2/pmos_1p2$$46887980_3v64x8m81_1/pmos_5p0431059130204_3v64x8m81_0/S
+ ypredec1_bot_3v64x8m81_2/pmos_1p2$$46887980_3v64x8m81_0/pmos_5p0431059130204_3v64x8m81_0/D
+ ypredec1_bot_3v64x8m81_0/pmos_1p2$$46887980_3v64x8m81_0/pmos_5p0431059130204_3v64x8m81_0/D
+ ypredec1_bot_3v64x8m81_1/pmos_1p2$$46887980_3v64x8m81_1/pmos_5p0431059130204_3v64x8m81_0/D
+ A[2] ypredec1_bot_3v64x8m81_2/alatch_3v64x8m81_0/enb ypredec1_bot_3v64x8m81_2/alatch_3v64x8m81_0/vdd
+ M1_NWELL13_3v64x8m81_0/VSUBS nmos_5p04310591302056_3v64x8m81_1/D ypredec1_bot_3v64x8m81
Xypredec1_bot_3v64x8m81_2 ypredec1_bot_3v64x8m81_2/pmos_1p2$$46887980_3v64x8m81_1/pmos_5p0431059130204_3v64x8m81_0/D
+ ypredec1_bot_3v64x8m81_2/pmos_1p2$$46887980_3v64x8m81_0/pmos_5p0431059130204_3v64x8m81_0/D
+ ypredec1_bot_3v64x8m81_1/pmos_1p2$$46887980_3v64x8m81_1/pmos_5p0431059130204_3v64x8m81_0/D
+ ypredec1_bot_3v64x8m81_0/pmos_1p2$$46887980_3v64x8m81_1/pmos_5p0431059130204_3v64x8m81_0/D
+ ypredec1_bot_3v64x8m81_1/pmos_1p2$$46887980_3v64x8m81_0/pmos_5p0431059130204_3v64x8m81_0/D
+ ypredec1_bot_3v64x8m81_2/pmos_1p2$$46887980_3v64x8m81_1/pmos_5p0431059130204_3v64x8m81_0/S
+ ypredec1_bot_3v64x8m81_2/pmos_1p2$$46887980_3v64x8m81_0/pmos_5p0431059130204_3v64x8m81_0/D
+ ypredec1_bot_3v64x8m81_0/pmos_1p2$$46887980_3v64x8m81_0/pmos_5p0431059130204_3v64x8m81_0/D
+ ypredec1_bot_3v64x8m81_2/pmos_1p2$$46887980_3v64x8m81_1/pmos_5p0431059130204_3v64x8m81_0/D
+ A[1] ypredec1_bot_3v64x8m81_2/alatch_3v64x8m81_0/enb ypredec1_bot_3v64x8m81_2/alatch_3v64x8m81_0/vdd
+ M1_NWELL13_3v64x8m81_0/VSUBS nmos_5p04310591302056_3v64x8m81_1/D ypredec1_bot_3v64x8m81
Xypredec1_ys_3v64x8m81_0 M1_NWELL13_3v64x8m81_0/VSUBS ypredec1_xax8_3v64x8m81_0/ypredec1_xa_3v64x8m81_0/pmos_1p2$$47820844_3v64x8m81_2/pmos_5p04310591302061_3v64x8m81_0/D
+ ly[3] M1_NWELL13_3v64x8m81_0/VSUBS ypredec1_ys_3v64x8m81_9/pmos_5p04310591302055_3v64x8m81_3/D
+ ypredec1_ys_3v64x8m81
Xypredec1_ys_3v64x8m81_10 M1_NWELL13_3v64x8m81_0/VSUBS ypredec1_xax8_3v64x8m81_0/ypredec1_xa_3v64x8m81_1/pmos_1p2$$47820844_3v64x8m81_2/pmos_5p04310591302061_3v64x8m81_0/D
+ ry[1] M1_NWELL13_3v64x8m81_0/VSUBS ypredec1_ys_3v64x8m81_9/pmos_5p04310591302055_3v64x8m81_3/D
+ ypredec1_ys_3v64x8m81
Xypredec1_ys_3v64x8m81_1 M1_NWELL13_3v64x8m81_0/VSUBS ypredec1_xax8_3v64x8m81_0/ypredec1_xa_3v64x8m81_6/pmos_1p2$$47820844_3v64x8m81_2/pmos_5p04310591302061_3v64x8m81_0/D
+ ly[4] M1_NWELL13_3v64x8m81_0/VSUBS ypredec1_ys_3v64x8m81_9/pmos_5p04310591302055_3v64x8m81_3/D
+ ypredec1_ys_3v64x8m81
Xypredec1_ys_3v64x8m81_11 M1_NWELL13_3v64x8m81_0/VSUBS ypredec1_xax8_3v64x8m81_0/ypredec1_xa_3v64x8m81_4/pmos_1p2$$47820844_3v64x8m81_2/pmos_5p04310591302061_3v64x8m81_0/D
+ ry[2] M1_NWELL13_3v64x8m81_0/VSUBS ypredec1_ys_3v64x8m81_9/pmos_5p04310591302055_3v64x8m81_3/D
+ ypredec1_ys_3v64x8m81
Xypredec1_ys_3v64x8m81_2 M1_NWELL13_3v64x8m81_0/VSUBS ypredec1_xax8_3v64x8m81_0/ypredec1_xa_3v64x8m81_2/pmos_1p2$$47820844_3v64x8m81_2/pmos_5p04310591302061_3v64x8m81_0/D
+ ly[5] M1_NWELL13_3v64x8m81_0/VSUBS ypredec1_ys_3v64x8m81_9/pmos_5p04310591302055_3v64x8m81_3/D
+ ypredec1_ys_3v64x8m81
Xypredec1_ys_3v64x8m81_12 M1_NWELL13_3v64x8m81_0/VSUBS ypredec1_xax8_3v64x8m81_0/ypredec1_xa_3v64x8m81_0/pmos_1p2$$47820844_3v64x8m81_2/pmos_5p04310591302061_3v64x8m81_0/D
+ ry[3] M1_NWELL13_3v64x8m81_0/VSUBS ypredec1_ys_3v64x8m81_9/pmos_5p04310591302055_3v64x8m81_3/D
+ ypredec1_ys_3v64x8m81
Xypredec1_ys_3v64x8m81_3 M1_NWELL13_3v64x8m81_0/VSUBS ypredec1_xax8_3v64x8m81_0/ypredec1_xa_3v64x8m81_7/pmos_1p2$$47820844_3v64x8m81_2/pmos_5p04310591302061_3v64x8m81_0/D
+ ly[6] M1_NWELL13_3v64x8m81_0/VSUBS ypredec1_ys_3v64x8m81_9/pmos_5p04310591302055_3v64x8m81_3/D
+ ypredec1_ys_3v64x8m81
Xypredec1_ys_3v64x8m81_13 M1_NWELL13_3v64x8m81_0/VSUBS ypredec1_xax8_3v64x8m81_0/ypredec1_xa_3v64x8m81_6/pmos_1p2$$47820844_3v64x8m81_2/pmos_5p04310591302061_3v64x8m81_0/D
+ ry[4] M1_NWELL13_3v64x8m81_0/VSUBS ypredec1_ys_3v64x8m81_9/pmos_5p04310591302055_3v64x8m81_3/D
+ ypredec1_ys_3v64x8m81
Xypredec1_ys_3v64x8m81_4 M1_NWELL13_3v64x8m81_0/VSUBS ypredec1_xax8_3v64x8m81_0/ypredec1_xa_3v64x8m81_5/pmos_1p2$$47820844_3v64x8m81_2/pmos_5p04310591302061_3v64x8m81_0/D
+ ly[0] M1_NWELL13_3v64x8m81_0/VSUBS ypredec1_ys_3v64x8m81_9/pmos_5p04310591302055_3v64x8m81_3/D
+ ypredec1_ys_3v64x8m81
Xypredec1_ys_3v64x8m81_14 M1_NWELL13_3v64x8m81_0/VSUBS ypredec1_xax8_3v64x8m81_0/ypredec1_xa_3v64x8m81_5/pmos_1p2$$47820844_3v64x8m81_2/pmos_5p04310591302061_3v64x8m81_0/D
+ ry[0] M1_NWELL13_3v64x8m81_0/VSUBS ypredec1_ys_3v64x8m81_9/pmos_5p04310591302055_3v64x8m81_3/D
+ ypredec1_ys_3v64x8m81
Xypredec1_ys_3v64x8m81_5 M1_NWELL13_3v64x8m81_0/VSUBS ypredec1_xax8_3v64x8m81_0/ypredec1_xa_3v64x8m81_1/pmos_1p2$$47820844_3v64x8m81_2/pmos_5p04310591302061_3v64x8m81_0/D
+ ly[1] M1_NWELL13_3v64x8m81_0/VSUBS ypredec1_ys_3v64x8m81_9/pmos_5p04310591302055_3v64x8m81_3/D
+ ypredec1_ys_3v64x8m81
Xypredec1_ys_3v64x8m81_15 M1_NWELL13_3v64x8m81_0/VSUBS ypredec1_xax8_3v64x8m81_0/ypredec1_xa_3v64x8m81_3/pmos_1p2$$47820844_3v64x8m81_2/pmos_5p04310591302061_3v64x8m81_0/D
+ ly[7] M1_NWELL13_3v64x8m81_0/VSUBS ypredec1_ys_3v64x8m81_9/pmos_5p04310591302055_3v64x8m81_3/D
+ ypredec1_ys_3v64x8m81
Xnmos_1p2$$47342636_3v64x8m81_0 ypredec1_bot_3v64x8m81_2/alatch_3v64x8m81_0/enb M1_NWELL13_3v64x8m81_0/VSUBS
+ nmos_5p04310591302056_3v64x8m81_1/D M1_NWELL13_3v64x8m81_0/VSUBS nmos_1p2$$47342636_3v64x8m81
Xypredec1_ys_3v64x8m81_6 M1_NWELL13_3v64x8m81_0/VSUBS ypredec1_xax8_3v64x8m81_0/ypredec1_xa_3v64x8m81_4/pmos_1p2$$47820844_3v64x8m81_2/pmos_5p04310591302061_3v64x8m81_0/D
+ ly[2] M1_NWELL13_3v64x8m81_0/VSUBS ypredec1_ys_3v64x8m81_9/pmos_5p04310591302055_3v64x8m81_3/D
+ ypredec1_ys_3v64x8m81
Xypredec1_ys_3v64x8m81_7 M1_NWELL13_3v64x8m81_0/VSUBS ypredec1_xax8_3v64x8m81_0/ypredec1_xa_3v64x8m81_2/pmos_1p2$$47820844_3v64x8m81_2/pmos_5p04310591302061_3v64x8m81_0/D
+ ry[5] M1_NWELL13_3v64x8m81_0/VSUBS ypredec1_ys_3v64x8m81_9/pmos_5p04310591302055_3v64x8m81_3/D
+ ypredec1_ys_3v64x8m81
Xypredec1_ys_3v64x8m81_8 M1_NWELL13_3v64x8m81_0/VSUBS ypredec1_xax8_3v64x8m81_0/ypredec1_xa_3v64x8m81_7/pmos_1p2$$47820844_3v64x8m81_2/pmos_5p04310591302061_3v64x8m81_0/D
+ ry[6] M1_NWELL13_3v64x8m81_0/VSUBS ypredec1_ys_3v64x8m81_9/pmos_5p04310591302055_3v64x8m81_3/D
+ ypredec1_ys_3v64x8m81
X0 a_5490_186# clk nmos_5p04310591302056_3v64x8m81_1/D pmos_1p2$$47109164_3v64x8m81_0/pmos_5p04310591302062_3v64x8m81_0/S pfet_03v3 ad=0.1917p pd=1.425u as=0.34345p ps=1.71u w=1.065u l=0.28u
X1 nmos_5p04310591302056_3v64x8m81_1/D clk a_5176_186# pmos_1p2$$47109164_3v64x8m81_0/pmos_5p04310591302062_3v64x8m81_0/S pfet_03v3 ad=0.34345p pd=1.71u as=0.19435p ps=1.43u w=1.065u l=0.28u
X2 a_5176_186# men pmos_1p2$$47109164_3v64x8m81_0/pmos_5p04310591302062_3v64x8m81_0/S pmos_1p2$$47109164_3v64x8m81_0/pmos_5p04310591302062_3v64x8m81_0/S pfet_03v3 ad=0.19435p pd=1.43u as=0.59108p ps=3.24u w=1.065u l=0.28u
X3 pmos_1p2$$47109164_3v64x8m81_0/pmos_5p04310591302062_3v64x8m81_0/S men a_5490_186# pmos_1p2$$47109164_3v64x8m81_0/pmos_5p04310591302062_3v64x8m81_0/S pfet_03v3 ad=0.59108p pd=3.24u as=0.1917p ps=1.425u w=1.065u l=0.28u
.ends

.subckt pmos_5p04310591302074_3v64x8m81 D a_0_n44# w_n174_n86# S
X0 D a_0_n44# S w_n174_n86# pfet_03v3 ad=0.1848p pd=1.72u as=0.1848p ps=1.72u w=0.42u l=0.56u
.ends

.subckt pmos_5p04310591302073_3v64x8m81 D a_n28_n44# a_132_n44# w_n202_n86# S_uq0
+ S
X0 D a_n28_n44# S w_n202_n86# pfet_03v3 ad=0.4563p pd=2.275u as=0.7722p ps=4.39u w=1.755u l=0.28u
X1 S_uq0 a_132_n44# D w_n202_n86# pfet_03v3 ad=0.7722p pd=4.39u as=0.4563p ps=2.275u w=1.755u l=0.28u
.ends

.subckt pmos_1p2$$48623660_3v64x8m81 a_n42_n34# w_n133_n66# pmos_5p04310591302073_3v64x8m81_0/S
+ pmos_5p04310591302073_3v64x8m81_0/S_uq0 a_118_n34# pmos_5p04310591302073_3v64x8m81_0/D
Xpmos_5p04310591302073_3v64x8m81_0 pmos_5p04310591302073_3v64x8m81_0/D a_n42_n34#
+ a_118_n34# w_n133_n66# pmos_5p04310591302073_3v64x8m81_0/S_uq0 pmos_5p04310591302073_3v64x8m81_0/S
+ pmos_5p04310591302073_3v64x8m81
.ends

.subckt pmos_5p04310591302091_3v64x8m81 D a_0_n44# w_n174_n86# S
X0 D a_0_n44# S w_n174_n86# pfet_03v3 ad=4.004p pd=19.08u as=4.004p ps=19.08u w=9.1u l=0.28u
.ends

.subckt pmos_1p2$$48624684_3v64x8m81 pmos_5p04310591302091_3v64x8m81_0/S a_n14_n34#
+ pmos_5p04310591302091_3v64x8m81_0/D w_n133_n65#
Xpmos_5p04310591302091_3v64x8m81_0 pmos_5p04310591302091_3v64x8m81_0/D a_n14_n34#
+ w_n133_n65# pmos_5p04310591302091_3v64x8m81_0/S pmos_5p04310591302091_3v64x8m81
.ends

.subckt pmos_5p04310591302089_3v64x8m81 D_uq2 D_uq1 a_2502_n44# D_uq0 a_1699_n44#
+ D a_n67_n44# a_2341_n44# a_1378_n44# a_2020_n44# a_1057_n44# a_n548_n44# S_uq9 S_uq8
+ S_uq7 S_uq6 a_94_n44# S_uq5 a_736_n44# a_n227_n44# S_uq4 S_uq2 S_uq3 a_896_n44#
+ S_uq1 S_uq0 w_n722_n86# S a_415_n44# a_2181_n44# a_1538_n44# a_575_n44# a_1860_n44#
+ D_uq8 D_uq7 a_1217_n44# a_n388_n44# D_uq6 a_254_n44# D_uq4 D_uq5 D_uq3
X0 D_uq8 a_n548_n44# S_uq9 w_n722_n86# pfet_03v3 ad=2.2282p pd=9.09u as=3.7708p ps=18.02u w=8.57u l=0.28u
X1 S_uq5 a_575_n44# D_uq5 w_n722_n86# pfet_03v3 ad=2.24962p pd=9.095u as=2.2282p ps=9.09u w=8.57u l=0.28u
X2 D_uq5 a_415_n44# S_uq6 w_n722_n86# pfet_03v3 ad=2.2282p pd=9.09u as=2.24962p ps=9.095u w=8.57u l=0.28u
X3 D_uq3 a_1057_n44# S_uq4 w_n722_n86# pfet_03v3 ad=2.2282p pd=9.09u as=2.24962p ps=9.095u w=8.57u l=0.28u
X4 D a_2020_n44# S_uq1 w_n722_n86# pfet_03v3 ad=2.24962p pd=9.095u as=2.2282p ps=9.09u w=8.57u l=0.28u
X5 S_uq4 a_896_n44# D_uq4 w_n722_n86# pfet_03v3 ad=2.24962p pd=9.095u as=2.2282p ps=9.09u w=8.57u l=0.28u
X6 D_uq4 a_736_n44# S_uq5 w_n722_n86# pfet_03v3 ad=2.2282p pd=9.09u as=2.24962p ps=9.095u w=8.57u l=0.28u
X7 D_uq2 a_1378_n44# S_uq3 w_n722_n86# pfet_03v3 ad=2.2282p pd=9.09u as=2.24962p ps=9.095u w=8.57u l=0.28u
X8 D_uq0 a_2341_n44# S w_n722_n86# pfet_03v3 ad=2.24962p pd=9.095u as=2.2282p ps=9.09u w=8.57u l=0.28u
X9 S_uq7 a_n67_n44# D_uq7 w_n722_n86# pfet_03v3 ad=2.24962p pd=9.095u as=2.2282p ps=9.09u w=8.57u l=0.28u
X10 D_uq1 a_1699_n44# S_uq2 w_n722_n86# pfet_03v3 ad=2.24962p pd=9.095u as=2.24962p ps=9.095u w=8.57u l=0.28u
X11 S_uq0 a_2502_n44# D_uq0 w_n722_n86# pfet_03v3 ad=3.7708p pd=18.02u as=2.24962p ps=9.095u w=8.57u l=0.28u
X12 S_uq8 a_n388_n44# D_uq8 w_n722_n86# pfet_03v3 ad=2.24962p pd=9.095u as=2.2282p ps=9.09u w=8.57u l=0.28u
X13 S_uq3 a_1217_n44# D_uq3 w_n722_n86# pfet_03v3 ad=2.24962p pd=9.095u as=2.2282p ps=9.09u w=8.57u l=0.28u
X14 S_uq1 a_1860_n44# D_uq1 w_n722_n86# pfet_03v3 ad=2.2282p pd=9.09u as=2.24962p ps=9.095u w=8.57u l=0.28u
X15 S_uq2 a_1538_n44# D_uq2 w_n722_n86# pfet_03v3 ad=2.24962p pd=9.095u as=2.2282p ps=9.09u w=8.57u l=0.28u
X16 S a_2181_n44# D w_n722_n86# pfet_03v3 ad=2.2282p pd=9.09u as=2.24962p ps=9.095u w=8.57u l=0.28u
X17 D_uq6 a_94_n44# S_uq7 w_n722_n86# pfet_03v3 ad=2.2282p pd=9.09u as=2.24962p ps=9.095u w=8.57u l=0.28u
X18 D_uq7 a_n227_n44# S_uq8 w_n722_n86# pfet_03v3 ad=2.2282p pd=9.09u as=2.24962p ps=9.095u w=8.57u l=0.28u
X19 S_uq6 a_254_n44# D_uq6 w_n722_n86# pfet_03v3 ad=2.24962p pd=9.095u as=2.2282p ps=9.09u w=8.57u l=0.28u
.ends

.subckt pmos_5p04310591302088_3v64x8m81 D_uq2 D_uq1 D_uq0 D a_n252_n44# a_550_n44#
+ a_229_n44# w_n426_n86# S_uq4 S_uq2 S_uq3 S_uq1 a_390_n44# S_uq0 S a_n92_n44# a_1032_n44#
+ a_1192_n44# a_711_n44# a_69_n44# D_uq3 a_871_n44#
X0 D_uq1 a_390_n44# S_uq2 w_n426_n86# pfet_03v3 ad=1.5132p pd=6.34u as=1.52775p ps=6.345u w=5.82u l=0.28u
X1 D_uq3 a_n252_n44# S_uq4 w_n426_n86# pfet_03v3 ad=1.5132p pd=6.34u as=2.5608p ps=12.52u w=5.82u l=0.28u
X2 D_uq2 a_69_n44# S_uq3 w_n426_n86# pfet_03v3 ad=1.5132p pd=6.34u as=1.52775p ps=6.345u w=5.82u l=0.28u
X3 S_uq2 a_229_n44# D_uq2 w_n426_n86# pfet_03v3 ad=1.52775p pd=6.345u as=1.5132p ps=6.34u w=5.82u l=0.28u
X4 S_uq1 a_550_n44# D_uq1 w_n426_n86# pfet_03v3 ad=1.52775p pd=6.345u as=1.5132p ps=6.34u w=5.82u l=0.28u
X5 S_uq0 a_1192_n44# D_uq0 w_n426_n86# pfet_03v3 ad=2.5608p pd=12.52u as=1.5132p ps=6.34u w=5.82u l=0.28u
X6 D_uq0 a_1032_n44# S w_n426_n86# pfet_03v3 ad=1.5132p pd=6.34u as=1.52775p ps=6.345u w=5.82u l=0.28u
X7 S_uq3 a_n92_n44# D_uq3 w_n426_n86# pfet_03v3 ad=1.52775p pd=6.345u as=1.5132p ps=6.34u w=5.82u l=0.28u
X8 S a_871_n44# D w_n426_n86# pfet_03v3 ad=1.52775p pd=6.345u as=1.5132p ps=6.34u w=5.82u l=0.28u
X9 D a_711_n44# S_uq1 w_n426_n86# pfet_03v3 ad=1.5132p pd=6.34u as=1.52775p ps=6.345u w=5.82u l=0.28u
.ends

.subckt nmos_5p04310591302086_3v64x8m81 D a_0_n44# S VSUBS
X0 D a_0_n44# S VSUBS nfet_03v3 ad=0.6182p pd=3.69u as=0.6182p ps=3.69u w=1.405u l=0.28u
.ends

.subckt nmos_1p2$$48302124_3v64x8m81 nmos_5p04310591302086_3v64x8m81_0/D a_n14_n34#
+ nmos_5p04310591302086_3v64x8m81_0/S VSUBS
Xnmos_5p04310591302086_3v64x8m81_0 nmos_5p04310591302086_3v64x8m81_0/D a_n14_n34#
+ nmos_5p04310591302086_3v64x8m81_0/S VSUBS nmos_5p04310591302086_3v64x8m81
.ends

.subckt pmos_1p2$$46285868_3v64x8m81 w_n133_n66# pmos_5p04310591302014_3v64x8m81_0/S
+ pmos_5p04310591302014_3v64x8m81_0/D a_n14_n34#
Xpmos_5p04310591302014_3v64x8m81_0 pmos_5p04310591302014_3v64x8m81_0/D a_n14_n34#
+ w_n133_n66# pmos_5p04310591302014_3v64x8m81_0/S pmos_5p04310591302014_3v64x8m81
.ends

.subckt pmos_5p0431059130203_3v64x8m81 D a_n28_n44# a_132_n44# w_n202_n86# S_uq0 S
X0 D a_n28_n44# S w_n202_n86# pfet_03v3 ad=0.1378p pd=1.05u as=0.2332p ps=1.94u w=0.53u l=0.28u
X1 S_uq0 a_132_n44# D w_n202_n86# pfet_03v3 ad=0.2332p pd=1.94u as=0.1378p ps=1.05u w=0.53u l=0.28u
.ends

.subckt pmos_1p2$$46273580_3v64x8m81 w_n133_n66# a_n42_n34# pmos_5p0431059130203_3v64x8m81_0/S_uq0
+ pmos_5p0431059130203_3v64x8m81_0/S a_118_n34# pmos_5p0431059130203_3v64x8m81_0/D
Xpmos_5p0431059130203_3v64x8m81_0 pmos_5p0431059130203_3v64x8m81_0/D a_n42_n34# a_118_n34#
+ w_n133_n66# pmos_5p0431059130203_3v64x8m81_0/S_uq0 pmos_5p0431059130203_3v64x8m81_0/S
+ pmos_5p0431059130203_3v64x8m81
.ends

.subckt pmos_5p04310591302094_3v64x8m81 D a_0_n44# w_n174_n86# S
X0 D a_0_n44# S w_n174_n86# pfet_03v3 ad=0.3872p pd=2.64u as=0.3872p ps=2.64u w=0.88u l=0.28u
.ends

.subckt pmos_5p04310591302092_3v64x8m81 D a_0_n44# w_n174_n86# S
X0 D a_0_n44# S w_n174_n86# pfet_03v3 ad=0.1848p pd=1.72u as=0.1848p ps=1.72u w=0.42u l=0.465u
.ends

.subckt pmos_5p04310591302087_3v64x8m81 D a_0_n44# w_n174_n86# S
X0 D a_0_n44# S w_n174_n86# pfet_03v3 ad=4.6552p pd=22.04u as=4.6552p ps=22.04u w=10.58u l=0.28u
.ends

.subckt pmos_1p2$$47815724_3v64x8m81 pmos_5p04310591302087_3v64x8m81_0/S a_n14_n34#
+ pmos_5p04310591302087_3v64x8m81_0/D w_n133_n65#
Xpmos_5p04310591302087_3v64x8m81_0 pmos_5p04310591302087_3v64x8m81_0/D a_n14_n34#
+ w_n133_n65# pmos_5p04310591302087_3v64x8m81_0/S pmos_5p04310591302087_3v64x8m81
.ends

.subckt nmos_1p2$$46563372_3v64x8m81 nmos_5p0431059130208_3v64x8m81_0/S a_n14_89#
+ nmos_5p0431059130208_3v64x8m81_0/D VSUBS
Xnmos_5p0431059130208_3v64x8m81_0 nmos_5p0431059130208_3v64x8m81_0/D a_n14_89# nmos_5p0431059130208_3v64x8m81_0/S
+ VSUBS nmos_5p0431059130208_3v64x8m81
.ends

.subckt pmos_5p04310591302051_3v64x8m81 D a_n28_n44# a_132_n44# w_n202_n86# S_uq0
+ S
X0 D a_n28_n44# S w_n202_n86# pfet_03v3 ad=0.6877p pd=3.165u as=1.1638p ps=6.17u w=2.645u l=0.28u
X1 S_uq0 a_132_n44# D w_n202_n86# pfet_03v3 ad=1.1638p pd=6.17u as=0.6877p ps=3.165u w=2.645u l=0.28u
.ends

.subckt nmos_5p04310591302083_3v64x8m81 D a_0_n44# S VSUBS
X0 D a_0_n44# S VSUBS nfet_03v3 ad=0.1646p pd=1.64u as=0.1646p ps=1.64u w=0.35u l=0.28u
.ends

.subckt nmos_5p04310591302093_3v64x8m81 D a_0_n44# S VSUBS
X0 D a_0_n44# S VSUBS nfet_03v3 ad=0.1576p pd=1.64u as=0.1576p ps=1.64u w=0.28u l=0.56u
.ends

.subckt nmos_5p04310591302085_3v64x8m81 D_uq1 D_uq0 a_530_n44# D a_n112_n44# a_209_n44#
+ a_369_n44# a_48_n44# S_uq1 S_uq0 S VSUBS
X0 D_uq1 a_n112_n44# S_uq1 VSUBS nfet_03v3 ad=1.2103p pd=5.175u as=2.0482p ps=10.19u w=4.655u l=0.28u
X1 S_uq0 a_369_n44# D VSUBS nfet_03v3 ad=1.22192p pd=5.18u as=1.2103p ps=5.175u w=4.655u l=0.28u
X2 D a_209_n44# S VSUBS nfet_03v3 ad=1.2103p pd=5.175u as=1.22192p ps=5.18u w=4.655u l=0.28u
X3 D_uq0 a_530_n44# S_uq0 VSUBS nfet_03v3 ad=2.0482p pd=10.19u as=1.22192p ps=5.18u w=4.655u l=0.28u
X4 S a_48_n44# D_uq1 VSUBS nfet_03v3 ad=1.22192p pd=5.18u as=1.2103p ps=5.175u w=4.655u l=0.28u
.ends

.subckt nmos_1p2$$48306220_3v64x8m81 nmos_5p04310591302085_3v64x8m81_0/D a_n125_n34#
+ a_34_n34# nmos_5p04310591302085_3v64x8m81_0/S_uq1 nmos_5p04310591302085_3v64x8m81_0/S_uq0
+ nmos_5p04310591302085_3v64x8m81_0/D_uq1 nmos_5p04310591302085_3v64x8m81_0/D_uq0
+ nmos_5p04310591302085_3v64x8m81_0/S a_516_n34# a_195_n34# a_355_n34# VSUBS
Xnmos_5p04310591302085_3v64x8m81_0 nmos_5p04310591302085_3v64x8m81_0/D_uq1 nmos_5p04310591302085_3v64x8m81_0/D_uq0
+ a_516_n34# nmos_5p04310591302085_3v64x8m81_0/D a_n125_n34# a_195_n34# a_355_n34#
+ a_34_n34# nmos_5p04310591302085_3v64x8m81_0/S_uq1 nmos_5p04310591302085_3v64x8m81_0/S_uq0
+ nmos_5p04310591302085_3v64x8m81_0/S VSUBS nmos_5p04310591302085_3v64x8m81
.ends

.subckt pmos_5p04310591302020_3v64x8m81 D a_n28_n44# a_132_n44# w_n202_n86# S_uq0
+ S
X0 D a_n28_n44# S w_n202_n86# pfet_03v3 ad=0.2743p pd=1.575u as=0.4642p ps=2.99u w=1.055u l=0.28u
X1 S_uq0 a_132_n44# D w_n202_n86# pfet_03v3 ad=0.4642p pd=2.99u as=0.2743p ps=1.575u w=1.055u l=0.28u
.ends

.subckt nmos_1p2$$202595372_3v64x8m81 nmos_5p0431059130208_3v64x8m81_0/S a_n14_89#
+ nmos_5p0431059130208_3v64x8m81_0/D VSUBS
Xnmos_5p0431059130208_3v64x8m81_0 nmos_5p0431059130208_3v64x8m81_0/D a_n14_89# nmos_5p0431059130208_3v64x8m81_0/S
+ VSUBS nmos_5p0431059130208_3v64x8m81
.ends

.subckt pmos_1p2$$202587180_3v64x8m81 pmos_5p04310591302014_3v64x8m81_0/S a_n14_n34#
+ pmos_5p04310591302014_3v64x8m81_0/D w_n133_n65#
Xpmos_5p04310591302014_3v64x8m81_0 pmos_5p04310591302014_3v64x8m81_0/D a_n14_n34#
+ w_n133_n65# pmos_5p04310591302014_3v64x8m81_0/S pmos_5p04310591302014_3v64x8m81
.ends

.subckt pmos_5p04310591302082_3v64x8m81 a_20_n44# D_uq1 D_uq0 D a_181_n44# a_502_n44#
+ S_uq2 a_662_n44# S_uq1 a_n140_n44# S_uq0 S a_341_n44# w_n314_n86#
X0 S a_341_n44# D w_n314_n86# pfet_03v3 ad=0.30318p pd=1.68u as=0.3003p ps=1.675u w=1.155u l=0.28u
X1 S_uq0 a_662_n44# D_uq0 w_n314_n86# pfet_03v3 ad=0.5082p pd=3.19u as=0.3003p ps=1.675u w=1.155u l=0.28u
X2 D_uq0 a_502_n44# S w_n314_n86# pfet_03v3 ad=0.3003p pd=1.675u as=0.30318p ps=1.68u w=1.155u l=0.28u
X3 S_uq1 a_20_n44# D_uq1 w_n314_n86# pfet_03v3 ad=0.30318p pd=1.68u as=0.3003p ps=1.675u w=1.155u l=0.28u
X4 D a_181_n44# S_uq1 w_n314_n86# pfet_03v3 ad=0.3003p pd=1.675u as=0.30318p ps=1.68u w=1.155u l=0.28u
X5 D_uq1 a_n140_n44# S_uq2 w_n314_n86# pfet_03v3 ad=0.3003p pd=1.675u as=0.5082p ps=3.19u w=1.155u l=0.28u
.ends

.subckt nmos_1p2$$202596396_3v64x8m81 nmos_5p0431059130208_3v64x8m81_0/S a_n14_89#
+ nmos_5p0431059130208_3v64x8m81_0/D VSUBS
Xnmos_5p0431059130208_3v64x8m81_0 nmos_5p0431059130208_3v64x8m81_0/D a_n14_89# nmos_5p0431059130208_3v64x8m81_0/S
+ VSUBS nmos_5p0431059130208_3v64x8m81
.ends

.subckt pmos_5p04310591302080_3v64x8m81 D a_n28_n44# a_132_n44# w_n202_n86# S_uq0
+ S
X0 D a_n28_n44# S w_n202_n86# pfet_03v3 ad=0.3445p pd=1.845u as=0.583p ps=3.53u w=1.325u l=0.28u
X1 S_uq0 a_132_n44# D w_n202_n86# pfet_03v3 ad=0.583p pd=3.53u as=0.3445p ps=1.845u w=1.325u l=0.28u
.ends

.subckt nmos_5p04310591302078_3v64x8m81 D_uq0 D S_uq0 S a_217_n44# a_n104_n44# a_56_n44#
+ VSUBS
X0 D_uq0 a_217_n44# S_uq0 VSUBS nfet_03v3 ad=0.4092p pd=2.74u as=0.24412p ps=1.455u w=0.93u l=0.28u
X1 S_uq0 a_56_n44# D VSUBS nfet_03v3 ad=0.24412p pd=1.455u as=0.2418p ps=1.45u w=0.93u l=0.28u
X2 D a_n104_n44# S VSUBS nfet_03v3 ad=0.2418p pd=1.45u as=0.4092p ps=2.74u w=0.93u l=0.28u
.ends

.subckt nmos_5p04310591302076_3v64x8m81 D a_n28_n44# a_132_n44# S_uq0 S VSUBS
X0 D a_n28_n44# S VSUBS nfet_03v3 ad=0.1456p pd=1.08u as=0.2464p ps=2u w=0.56u l=0.28u
X1 S_uq0 a_132_n44# D VSUBS nfet_03v3 ad=0.2464p pd=2u as=0.1456p ps=1.08u w=0.56u l=0.28u
.ends

.subckt nmos_5p04310591302075_3v64x8m81 D_uq2 D_uq1 D_uq0 D a_n252_n44# a_550_n44#
+ a_229_n44# S_uq4 S_uq2 S_uq3 S_uq1 a_390_n44# S_uq0 S a_n92_n44# a_1032_n44# a_1192_n44#
+ a_711_n44# a_69_n44# D_uq3 a_871_n44# VSUBS
X0 D_uq1 a_390_n44# S_uq2 VSUBS nfet_03v3 ad=0.2327p pd=1.415u as=0.23492p ps=1.42u w=0.895u l=0.28u
X1 D_uq3 a_n252_n44# S_uq4 VSUBS nfet_03v3 ad=0.2327p pd=1.415u as=0.3938p ps=2.67u w=0.895u l=0.28u
X2 D_uq2 a_69_n44# S_uq3 VSUBS nfet_03v3 ad=0.2327p pd=1.415u as=0.23492p ps=1.42u w=0.895u l=0.28u
X3 S_uq2 a_229_n44# D_uq2 VSUBS nfet_03v3 ad=0.23492p pd=1.42u as=0.2327p ps=1.415u w=0.895u l=0.28u
X4 S_uq1 a_550_n44# D_uq1 VSUBS nfet_03v3 ad=0.23492p pd=1.42u as=0.2327p ps=1.415u w=0.895u l=0.28u
X5 S_uq0 a_1192_n44# D_uq0 VSUBS nfet_03v3 ad=0.3938p pd=2.67u as=0.2327p ps=1.415u w=0.895u l=0.28u
X6 D_uq0 a_1032_n44# S VSUBS nfet_03v3 ad=0.2327p pd=1.415u as=0.23492p ps=1.42u w=0.895u l=0.28u
X7 S_uq3 a_n92_n44# D_uq3 VSUBS nfet_03v3 ad=0.23492p pd=1.42u as=0.2327p ps=1.415u w=0.895u l=0.28u
X8 S a_871_n44# D VSUBS nfet_03v3 ad=0.23492p pd=1.42u as=0.2327p ps=1.415u w=0.895u l=0.28u
X9 D a_711_n44# S_uq1 VSUBS nfet_03v3 ad=0.2327p pd=1.415u as=0.23492p ps=1.42u w=0.895u l=0.28u
.ends

.subckt nmos_5p04310591302039_3v64x8m81 D a_n28_n44# a_132_n44# S_uq0 S VSUBS
X0 D a_n28_n44# S VSUBS nfet_03v3 ad=0.2743p pd=1.575u as=0.4642p ps=2.99u w=1.055u l=0.28u
X1 S_uq0 a_132_n44# D VSUBS nfet_03v3 ad=0.4642p pd=2.99u as=0.2743p ps=1.575u w=1.055u l=0.28u
.ends

.subckt nmos_5p04310591302081_3v64x8m81 D_uq2 D_uq1 D_uq0 D a_634_n44# a_n168_n44#
+ a_313_n44# a_795_n44# S_uq2 a_474_n44# S_uq1 a_n8_n44# S_uq0 S a_153_n44# VSUBS
X0 D_uq1 a_153_n44# S_uq1 VSUBS nfet_03v3 ad=0.1079p pd=0.935u as=0.10892p ps=0.94u w=0.415u l=0.28u
X1 D a_474_n44# S VSUBS nfet_03v3 ad=0.1079p pd=0.935u as=0.10892p ps=0.94u w=0.415u l=0.28u
X2 D_uq2 a_n168_n44# S_uq2 VSUBS nfet_03v3 ad=0.1079p pd=0.935u as=0.1826p ps=1.71u w=0.415u l=0.28u
X3 S_uq1 a_n8_n44# D_uq2 VSUBS nfet_03v3 ad=0.10892p pd=0.94u as=0.1079p ps=0.935u w=0.415u l=0.28u
X4 D_uq0 a_795_n44# S_uq0 VSUBS nfet_03v3 ad=0.1826p pd=1.71u as=0.10892p ps=0.94u w=0.415u l=0.28u
X5 S a_313_n44# D_uq1 VSUBS nfet_03v3 ad=0.10892p pd=0.94u as=0.1079p ps=0.935u w=0.415u l=0.28u
X6 S_uq0 a_634_n44# D VSUBS nfet_03v3 ad=0.10892p pd=0.94u as=0.1079p ps=0.935u w=0.415u l=0.28u
.ends

.subckt pmos_1p2$$202586156_3v64x8m81 pmos_5p04310591302014_3v64x8m81_0/S a_n14_n34#
+ pmos_5p04310591302014_3v64x8m81_0/D w_n133_n65#
Xpmos_5p04310591302014_3v64x8m81_0 pmos_5p04310591302014_3v64x8m81_0/D a_n14_n34#
+ w_n133_n65# pmos_5p04310591302014_3v64x8m81_0/S pmos_5p04310591302014_3v64x8m81
.ends

.subckt pmos_5p04310591302079_3v64x8m81 D_uq2 D_uq1 D_uq0 D a_486_n44# a_165_n44#
+ a_n156_n44# S_uq2 S_uq1 S_uq0 S a_4_n44# a_646_n44# w_n330_n86# a_808_n44# a_325_n44#
X0 S_uq0 a_646_n44# D w_n330_n86# pfet_03v3 ad=0.27162p pd=1.555u as=0.2665p ps=1.545u w=1.025u l=0.28u
X1 D_uq1 a_165_n44# S_uq1 w_n330_n86# pfet_03v3 ad=0.2665p pd=1.545u as=0.26905p ps=1.55u w=1.025u l=0.28u
X2 D a_486_n44# S w_n330_n86# pfet_03v3 ad=0.2665p pd=1.545u as=0.26905p ps=1.55u w=1.025u l=0.28u
X3 S_uq1 a_4_n44# D_uq2 w_n330_n86# pfet_03v3 ad=0.26905p pd=1.55u as=0.2665p ps=1.545u w=1.025u l=0.28u
X4 D_uq2 a_n156_n44# S_uq2 w_n330_n86# pfet_03v3 ad=0.2665p pd=1.545u as=0.451p ps=2.93u w=1.025u l=0.28u
X5 S a_325_n44# D_uq1 w_n330_n86# pfet_03v3 ad=0.26905p pd=1.55u as=0.2665p ps=1.545u w=1.025u l=0.28u
X6 D_uq0 a_808_n44# S_uq0 w_n330_n86# pfet_03v3 ad=0.451p pd=2.93u as=0.27162p ps=1.555u w=1.025u l=0.28u
.ends

.subckt pmos_5p04310591302077_3v64x8m81 D_uq2 D_uq1 D_uq0 D a_n252_n44# a_550_n44#
+ a_229_n44# w_n426_n86# S_uq4 S_uq2 S_uq3 S_uq1 a_390_n44# S_uq0 S a_n92_n44# a_1032_n44#
+ a_1192_n44# a_711_n44# a_69_n44# D_uq3 a_871_n44#
X0 D_uq1 a_390_n44# S_uq2 w_n426_n86# pfet_03v3 ad=0.572p pd=2.72u as=0.5775p ps=2.725u w=2.2u l=0.28u
X1 D_uq3 a_n252_n44# S_uq4 w_n426_n86# pfet_03v3 ad=0.572p pd=2.72u as=0.968p ps=5.28u w=2.2u l=0.28u
X2 D_uq2 a_69_n44# S_uq3 w_n426_n86# pfet_03v3 ad=0.572p pd=2.72u as=0.5775p ps=2.725u w=2.2u l=0.28u
X3 S_uq2 a_229_n44# D_uq2 w_n426_n86# pfet_03v3 ad=0.5775p pd=2.725u as=0.572p ps=2.72u w=2.2u l=0.28u
X4 S_uq1 a_550_n44# D_uq1 w_n426_n86# pfet_03v3 ad=0.5775p pd=2.725u as=0.572p ps=2.72u w=2.2u l=0.28u
X5 S_uq0 a_1192_n44# D_uq0 w_n426_n86# pfet_03v3 ad=0.968p pd=5.28u as=0.572p ps=2.72u w=2.2u l=0.28u
X6 D_uq0 a_1032_n44# S w_n426_n86# pfet_03v3 ad=0.572p pd=2.72u as=0.5775p ps=2.725u w=2.2u l=0.28u
X7 S_uq3 a_n92_n44# D_uq3 w_n426_n86# pfet_03v3 ad=0.5775p pd=2.725u as=0.572p ps=2.72u w=2.2u l=0.28u
X8 S a_871_n44# D w_n426_n86# pfet_03v3 ad=0.5775p pd=2.725u as=0.572p ps=2.72u w=2.2u l=0.28u
X9 D a_711_n44# S_uq1 w_n426_n86# pfet_03v3 ad=0.572p pd=2.72u as=0.5775p ps=2.725u w=2.2u l=0.28u
.ends

.subckt wen_v2_3v64x8m81 IGWEN clk wen GWE vdd vss
Xpmos_5p04310591302020_3v64x8m81_0 pmos_5p04310591302080_3v64x8m81_0/D nmos_5p0431059130208_3v64x8m81_3/D
+ nmos_5p0431059130208_3v64x8m81_3/D vdd nmos_5p0431059130208_3v64x8m81_1/S nmos_5p0431059130208_3v64x8m81_1/S
+ pmos_5p04310591302020_3v64x8m81
Xnmos_1p2$$202595372_3v64x8m81_0 pmos_5p04310591302014_3v64x8m81_2/S pmos_5p04310591302041_3v64x8m81_1/S
+ vss vss nmos_1p2$$202595372_3v64x8m81
Xpmos_1p2$$202587180_3v64x8m81_0 nmos_5p0431059130208_3v64x8m81_2/S nmos_5p0431059130208_3v64x8m81_4/D
+ pmos_5p04310591302041_3v64x8m81_1/S vdd pmos_1p2$$202587180_3v64x8m81
Xpmos_5p04310591302082_3v64x8m81_0 wen pmos_5p04310591302082_3v64x8m81_0/D pmos_5p04310591302082_3v64x8m81_0/D
+ pmos_5p04310591302082_3v64x8m81_0/D wen wen vdd wen vdd wen vdd vdd wen vdd pmos_5p04310591302082_3v64x8m81
Xnmos_1p2$$202595372_3v64x8m81_1 pmos_5p04310591302041_3v64x8m81_1/S nmos_5p0431059130208_3v64x8m81_4/D
+ pmos_5p04310591302041_3v64x8m81_1/D vss nmos_1p2$$202595372_3v64x8m81
Xnmos_1p2$$202596396_3v64x8m81_0 pmos_5p04310591302041_3v64x8m81_1/D pmos_5p04310591302014_3v64x8m81_2/S
+ vss vss nmos_1p2$$202596396_3v64x8m81
Xpmos_5p04310591302080_3v64x8m81_0 pmos_5p04310591302080_3v64x8m81_0/D pmos_5p04310591302014_3v64x8m81_2/S
+ pmos_5p04310591302014_3v64x8m81_2/S vdd vdd vdd pmos_5p04310591302080_3v64x8m81
Xnmos_5p04310591302010_3v64x8m81_0 pmos_5p04310591302041_3v64x8m81_1/S nmos_5p0431059130208_3v64x8m81_3/D
+ nmos_5p0431059130208_3v64x8m81_2/S vss nmos_5p04310591302010_3v64x8m81
Xnmos_5p04310591302078_3v64x8m81_0 pmos_5p04310591302082_3v64x8m81_0/D pmos_5p04310591302082_3v64x8m81_0/D
+ vss vss wen wen wen vss nmos_5p04310591302078_3v64x8m81
Xnmos_5p0431059130208_3v64x8m81_0 vss pmos_5p04310591302079_3v64x8m81_0/D nmos_5p0431059130208_3v64x8m81_1/D
+ vss nmos_5p0431059130208_3v64x8m81
Xnmos_5p04310591302076_3v64x8m81_0 pmos_5p04310591302080_3v64x8m81_0/D pmos_5p04310591302014_3v64x8m81_2/S
+ pmos_5p04310591302014_3v64x8m81_2/S vss vss vss nmos_5p04310591302076_3v64x8m81
Xnmos_5p0431059130208_3v64x8m81_1 nmos_5p0431059130208_3v64x8m81_1/D nmos_5p0431059130208_3v64x8m81_3/D
+ nmos_5p0431059130208_3v64x8m81_1/S vss nmos_5p0431059130208_3v64x8m81
Xnmos_5p04310591302075_3v64x8m81_0 GWE GWE GWE GWE pmos_5p04310591302079_3v64x8m81_0/D
+ pmos_5p04310591302079_3v64x8m81_0/D pmos_5p04310591302079_3v64x8m81_0/D vss vss
+ vss vss pmos_5p04310591302079_3v64x8m81_0/D vss vss pmos_5p04310591302079_3v64x8m81_0/D
+ pmos_5p04310591302079_3v64x8m81_0/D pmos_5p04310591302079_3v64x8m81_0/D pmos_5p04310591302079_3v64x8m81_0/D
+ pmos_5p04310591302079_3v64x8m81_0/D GWE pmos_5p04310591302079_3v64x8m81_0/D vss
+ nmos_5p04310591302075_3v64x8m81
Xnmos_5p0431059130208_3v64x8m81_2 vss wen nmos_5p0431059130208_3v64x8m81_2/S vss nmos_5p0431059130208_3v64x8m81
Xnmos_5p04310591302075_3v64x8m81_1 IGWEN IGWEN IGWEN IGWEN pmos_5p04310591302082_3v64x8m81_0/D
+ pmos_5p04310591302082_3v64x8m81_0/D pmos_5p04310591302082_3v64x8m81_0/D vss vss
+ vss vss pmos_5p04310591302082_3v64x8m81_0/D vss vss pmos_5p04310591302082_3v64x8m81_0/D
+ pmos_5p04310591302082_3v64x8m81_0/D pmos_5p04310591302082_3v64x8m81_0/D pmos_5p04310591302082_3v64x8m81_0/D
+ pmos_5p04310591302082_3v64x8m81_0/D IGWEN pmos_5p04310591302082_3v64x8m81_0/D vss
+ nmos_5p04310591302075_3v64x8m81
Xpmos_5p04310591302041_3v64x8m81_0 nmos_5p0431059130208_3v64x8m81_1/D nmos_5p0431059130208_3v64x8m81_4/D
+ vdd nmos_5p0431059130208_3v64x8m81_1/S pmos_5p04310591302041_3v64x8m81
Xnmos_5p0431059130208_3v64x8m81_3 nmos_5p0431059130208_3v64x8m81_3/D clk vss vss nmos_5p0431059130208_3v64x8m81
Xpmos_5p04310591302041_3v64x8m81_1 pmos_5p04310591302041_3v64x8m81_1/D nmos_5p0431059130208_3v64x8m81_3/D
+ vdd pmos_5p04310591302041_3v64x8m81_1/S pmos_5p04310591302041_3v64x8m81
Xnmos_5p0431059130208_3v64x8m81_4 nmos_5p0431059130208_3v64x8m81_4/D nmos_5p0431059130208_3v64x8m81_3/D
+ vss vss nmos_5p0431059130208_3v64x8m81
Xnmos_5p04310591302039_3v64x8m81_0 pmos_5p04310591302080_3v64x8m81_0/D nmos_5p0431059130208_3v64x8m81_4/D
+ nmos_5p0431059130208_3v64x8m81_4/D nmos_5p0431059130208_3v64x8m81_1/S nmos_5p0431059130208_3v64x8m81_1/S
+ vss nmos_5p04310591302039_3v64x8m81
Xnmos_5p04310591302081_3v64x8m81_0 pmos_5p04310591302079_3v64x8m81_0/D pmos_5p04310591302079_3v64x8m81_0/D
+ pmos_5p04310591302079_3v64x8m81_0/D pmos_5p04310591302079_3v64x8m81_0/D nmos_5p0431059130208_3v64x8m81_1/S
+ nmos_5p0431059130208_3v64x8m81_1/S nmos_5p0431059130208_3v64x8m81_1/S nmos_5p0431059130208_3v64x8m81_1/S
+ vss nmos_5p0431059130208_3v64x8m81_1/S vss nmos_5p0431059130208_3v64x8m81_1/S vss
+ vss nmos_5p0431059130208_3v64x8m81_1/S vss nmos_5p04310591302081_3v64x8m81
Xpmos_1p2$$202586156_3v64x8m81_0 pmos_5p04310591302041_3v64x8m81_1/D pmos_5p04310591302014_3v64x8m81_2/S
+ vdd vdd pmos_1p2$$202586156_3v64x8m81
Xpmos_5p04310591302014_3v64x8m81_0 vdd pmos_5p04310591302079_3v64x8m81_0/D vdd nmos_5p0431059130208_3v64x8m81_1/D
+ pmos_5p04310591302014_3v64x8m81
Xpmos_5p04310591302014_3v64x8m81_1 nmos_5p0431059130208_3v64x8m81_3/D clk vdd vdd
+ pmos_5p04310591302014_3v64x8m81
Xpmos_5p04310591302014_3v64x8m81_2 vdd pmos_5p04310591302041_3v64x8m81_1/S vdd pmos_5p04310591302014_3v64x8m81_2/S
+ pmos_5p04310591302014_3v64x8m81
Xpmos_5p04310591302014_3v64x8m81_3 vdd wen vdd nmos_5p0431059130208_3v64x8m81_2/S
+ pmos_5p04310591302014_3v64x8m81
Xpmos_5p04310591302014_3v64x8m81_4 nmos_5p0431059130208_3v64x8m81_4/D nmos_5p0431059130208_3v64x8m81_3/D
+ vdd vdd pmos_5p04310591302014_3v64x8m81
Xpmos_5p04310591302079_3v64x8m81_0 pmos_5p04310591302079_3v64x8m81_0/D pmos_5p04310591302079_3v64x8m81_0/D
+ pmos_5p04310591302079_3v64x8m81_0/D pmos_5p04310591302079_3v64x8m81_0/D nmos_5p0431059130208_3v64x8m81_1/S
+ nmos_5p0431059130208_3v64x8m81_1/S nmos_5p0431059130208_3v64x8m81_1/S vdd vdd vdd
+ vdd nmos_5p0431059130208_3v64x8m81_1/S nmos_5p0431059130208_3v64x8m81_1/S vdd nmos_5p0431059130208_3v64x8m81_1/S
+ nmos_5p0431059130208_3v64x8m81_1/S pmos_5p04310591302079_3v64x8m81
Xpmos_5p04310591302077_3v64x8m81_0 IGWEN IGWEN IGWEN IGWEN pmos_5p04310591302082_3v64x8m81_0/D
+ pmos_5p04310591302082_3v64x8m81_0/D pmos_5p04310591302082_3v64x8m81_0/D vdd vdd
+ vdd vdd vdd pmos_5p04310591302082_3v64x8m81_0/D vdd vdd pmos_5p04310591302082_3v64x8m81_0/D
+ pmos_5p04310591302082_3v64x8m81_0/D pmos_5p04310591302082_3v64x8m81_0/D pmos_5p04310591302082_3v64x8m81_0/D
+ pmos_5p04310591302082_3v64x8m81_0/D IGWEN pmos_5p04310591302082_3v64x8m81_0/D pmos_5p04310591302077_3v64x8m81
Xpmos_5p04310591302077_3v64x8m81_2 GWE GWE GWE GWE pmos_5p04310591302079_3v64x8m81_0/D
+ pmos_5p04310591302079_3v64x8m81_0/D pmos_5p04310591302079_3v64x8m81_0/D vdd vdd
+ vdd vdd vdd pmos_5p04310591302079_3v64x8m81_0/D vdd vdd pmos_5p04310591302079_3v64x8m81_0/D
+ pmos_5p04310591302079_3v64x8m81_0/D pmos_5p04310591302079_3v64x8m81_0/D pmos_5p04310591302079_3v64x8m81_0/D
+ pmos_5p04310591302079_3v64x8m81_0/D GWE pmos_5p04310591302079_3v64x8m81_0/D pmos_5p04310591302077_3v64x8m81
.ends

.subckt nmos_5p04310591302090_3v64x8m81 D a_0_n44# S VSUBS
X0 D a_0_n44# S VSUBS nfet_03v3 ad=0.1576p pd=1.64u as=0.1576p ps=1.64u w=0.28u l=0.465u
.ends

.subckt pmos_1p2$$47330348_3v64x8m81 pmos_5p04310591302041_3v64x8m81_0/D a_n14_89#
+ pmos_5p04310591302041_3v64x8m81_0/S w_n133_n65#
Xpmos_5p04310591302041_3v64x8m81_0 pmos_5p04310591302041_3v64x8m81_0/D a_n14_89# w_n133_n65#
+ pmos_5p04310591302041_3v64x8m81_0/S pmos_5p04310591302041_3v64x8m81
.ends

.subckt nmos_1p2$$48629804_3v64x8m81 nmos_5p04310591302039_3v64x8m81_0/D nmos_5p04310591302039_3v64x8m81_0/S
+ a_118_n34# a_n41_n34# nmos_5p04310591302039_3v64x8m81_0/S_uq0 VSUBS
Xnmos_5p04310591302039_3v64x8m81_0 nmos_5p04310591302039_3v64x8m81_0/D a_n41_n34#
+ a_118_n34# nmos_5p04310591302039_3v64x8m81_0/S_uq0 nmos_5p04310591302039_3v64x8m81_0/S
+ VSUBS nmos_5p04310591302039_3v64x8m81
.ends

.subckt nmos_5p04310591302084_3v64x8m81 D_uq2 D_uq1 D_uq0 a_1394_n44# D a_2357_n44#
+ a_1073_n44# a_2036_n44# a_n51_n44# a_1715_n44# a_752_n44# S_uq9 S_uq8 S_uq7 a_n532_n44#
+ S_uq6 S_uq5 a_431_n44# S_uq4 a_1554_n44# a_591_n44# S_uq2 S_uq3 a_2197_n44# S_uq1
+ a_n211_n44# S_uq0 S a_110_n44# a_1876_n44# a_1233_n44# a_270_n44# D_uq8 D_uq7 a_912_n44#
+ D_uq6 a_2518_n44# D_uq4 D_uq5 D_uq3 a_n372_n44# VSUBS
X0 S_uq6 a_270_n44# D_uq6 VSUBS nfet_03v3 ad=0.90167p pd=3.96u as=0.8931p ps=3.955u w=3.435u l=0.28u
X1 D_uq1 a_1715_n44# S_uq2 VSUBS nfet_03v3 ad=0.90167p pd=3.96u as=0.90167p ps=3.96u w=3.435u l=0.28u
X2 D_uq6 a_110_n44# S_uq7 VSUBS nfet_03v3 ad=0.8931p pd=3.955u as=0.90167p ps=3.96u w=3.435u l=0.28u
X3 D a_2036_n44# S_uq1 VSUBS nfet_03v3 ad=0.90167p pd=3.96u as=0.8931p ps=3.955u w=3.435u l=0.28u
X4 S_uq7 a_n51_n44# D_uq7 VSUBS nfet_03v3 ad=0.90167p pd=3.96u as=0.8931p ps=3.955u w=3.435u l=0.28u
X5 S_uq5 a_591_n44# D_uq5 VSUBS nfet_03v3 ad=0.90167p pd=3.96u as=0.8931p ps=3.955u w=3.435u l=0.28u
X6 D_uq3 a_1073_n44# S_uq4 VSUBS nfet_03v3 ad=0.8931p pd=3.955u as=0.90167p ps=3.96u w=3.435u l=0.28u
X7 D_uq5 a_431_n44# S_uq6 VSUBS nfet_03v3 ad=0.8931p pd=3.955u as=0.90167p ps=3.96u w=3.435u l=0.28u
X8 D_uq0 a_2357_n44# S VSUBS nfet_03v3 ad=0.90167p pd=3.96u as=0.8931p ps=3.955u w=3.435u l=0.28u
X9 D_uq2 a_1394_n44# S_uq3 VSUBS nfet_03v3 ad=0.8931p pd=3.955u as=0.90167p ps=3.96u w=3.435u l=0.28u
X10 S_uq8 a_n372_n44# D_uq8 VSUBS nfet_03v3 ad=0.90167p pd=3.96u as=0.8931p ps=3.955u w=3.435u l=0.28u
X11 D_uq4 a_752_n44# S_uq5 VSUBS nfet_03v3 ad=0.8931p pd=3.955u as=0.90167p ps=3.96u w=3.435u l=0.28u
X12 S_uq0 a_2518_n44# D_uq0 VSUBS nfet_03v3 ad=1.5114p pd=7.75u as=0.90167p ps=3.96u w=3.435u l=0.28u
X13 S_uq3 a_1233_n44# D_uq3 VSUBS nfet_03v3 ad=0.90167p pd=3.96u as=0.8931p ps=3.955u w=3.435u l=0.28u
X14 S_uq1 a_1876_n44# D_uq1 VSUBS nfet_03v3 ad=0.8931p pd=3.955u as=0.90167p ps=3.96u w=3.435u l=0.28u
X15 D_uq7 a_n211_n44# S_uq8 VSUBS nfet_03v3 ad=0.8931p pd=3.955u as=0.90167p ps=3.96u w=3.435u l=0.28u
X16 S a_2197_n44# D VSUBS nfet_03v3 ad=0.8931p pd=3.955u as=0.90167p ps=3.96u w=3.435u l=0.28u
X17 S_uq2 a_1554_n44# D_uq2 VSUBS nfet_03v3 ad=0.90167p pd=3.96u as=0.8931p ps=3.955u w=3.435u l=0.28u
X18 D_uq8 a_n532_n44# S_uq9 VSUBS nfet_03v3 ad=0.8931p pd=3.955u as=1.5114p ps=7.75u w=3.435u l=0.28u
X19 S_uq4 a_912_n44# D_uq4 VSUBS nfet_03v3 ad=0.90167p pd=3.96u as=0.8931p ps=3.955u w=3.435u l=0.28u
.ends

.subckt nmos_1p2$$48308268_3v64x8m81 nmos_5p04310591302084_3v64x8m81_0/a_912_n44#
+ nmos_5p04310591302084_3v64x8m81_0/a_1715_n44# nmos_5p04310591302084_3v64x8m81_0/a_n532_n44#
+ nmos_5p04310591302084_3v64x8m81_0/S nmos_5p04310591302084_3v64x8m81_0/a_1554_n44#
+ nmos_5p04310591302084_3v64x8m81_0/S_uq9 nmos_5p04310591302084_3v64x8m81_0/a_2197_n44#
+ nmos_5p04310591302084_3v64x8m81_0/S_uq8 nmos_5p04310591302084_3v64x8m81_0/a_n211_n44#
+ nmos_5p04310591302084_3v64x8m81_0/S_uq7 nmos_5p04310591302084_3v64x8m81_0/S_uq6
+ nmos_5p04310591302084_3v64x8m81_0/S_uq5 nmos_5p04310591302084_3v64x8m81_0/a_n51_n44#
+ nmos_5p04310591302084_3v64x8m81_0/S_uq4 nmos_5p04310591302084_3v64x8m81_0/a_1233_n44#
+ nmos_5p04310591302084_3v64x8m81_0/a_1876_n44# nmos_5p04310591302084_3v64x8m81_0/S_uq3
+ nmos_5p04310591302084_3v64x8m81_0/S_uq2 nmos_5p04310591302084_3v64x8m81_0/S_uq1
+ nmos_5p04310591302084_3v64x8m81_0/a_752_n44# nmos_5p04310591302084_3v64x8m81_0/S_uq0
+ nmos_5p04310591302084_3v64x8m81_0/D nmos_5p04310591302084_3v64x8m81_0/a_2518_n44#
+ nmos_5p04310591302084_3v64x8m81_0/a_n372_n44# nmos_5p04310591302084_3v64x8m81_0/a_431_n44#
+ nmos_5p04310591302084_3v64x8m81_0/D_uq8 nmos_5p04310591302084_3v64x8m81_0/a_591_n44#
+ nmos_5p04310591302084_3v64x8m81_0/D_uq7 nmos_5p04310591302084_3v64x8m81_0/D_uq6
+ nmos_5p04310591302084_3v64x8m81_0/a_1394_n44# nmos_5p04310591302084_3v64x8m81_0/D_uq5
+ nmos_5p04310591302084_3v64x8m81_0/a_2357_n44# nmos_5p04310591302084_3v64x8m81_0/D_uq4
+ nmos_5p04310591302084_3v64x8m81_0/a_110_n44# nmos_5p04310591302084_3v64x8m81_0/D_uq3
+ nmos_5p04310591302084_3v64x8m81_0/a_270_n44# nmos_5p04310591302084_3v64x8m81_0/D_uq2
+ nmos_5p04310591302084_3v64x8m81_0/D_uq1 nmos_5p04310591302084_3v64x8m81_0/D_uq0
+ nmos_5p04310591302084_3v64x8m81_0/a_1073_n44# VSUBS nmos_5p04310591302084_3v64x8m81_0/a_2036_n44#
Xnmos_5p04310591302084_3v64x8m81_0 nmos_5p04310591302084_3v64x8m81_0/D_uq2 nmos_5p04310591302084_3v64x8m81_0/D_uq1
+ nmos_5p04310591302084_3v64x8m81_0/D_uq0 nmos_5p04310591302084_3v64x8m81_0/a_1394_n44#
+ nmos_5p04310591302084_3v64x8m81_0/D nmos_5p04310591302084_3v64x8m81_0/a_2357_n44#
+ nmos_5p04310591302084_3v64x8m81_0/a_1073_n44# nmos_5p04310591302084_3v64x8m81_0/a_2036_n44#
+ nmos_5p04310591302084_3v64x8m81_0/a_n51_n44# nmos_5p04310591302084_3v64x8m81_0/a_1715_n44#
+ nmos_5p04310591302084_3v64x8m81_0/a_752_n44# nmos_5p04310591302084_3v64x8m81_0/S_uq9
+ nmos_5p04310591302084_3v64x8m81_0/S_uq8 nmos_5p04310591302084_3v64x8m81_0/S_uq7
+ nmos_5p04310591302084_3v64x8m81_0/a_n532_n44# nmos_5p04310591302084_3v64x8m81_0/S_uq6
+ nmos_5p04310591302084_3v64x8m81_0/S_uq5 nmos_5p04310591302084_3v64x8m81_0/a_431_n44#
+ nmos_5p04310591302084_3v64x8m81_0/S_uq4 nmos_5p04310591302084_3v64x8m81_0/a_1554_n44#
+ nmos_5p04310591302084_3v64x8m81_0/a_591_n44# nmos_5p04310591302084_3v64x8m81_0/S_uq2
+ nmos_5p04310591302084_3v64x8m81_0/S_uq3 nmos_5p04310591302084_3v64x8m81_0/a_2197_n44#
+ nmos_5p04310591302084_3v64x8m81_0/S_uq1 nmos_5p04310591302084_3v64x8m81_0/a_n211_n44#
+ nmos_5p04310591302084_3v64x8m81_0/S_uq0 nmos_5p04310591302084_3v64x8m81_0/S nmos_5p04310591302084_3v64x8m81_0/a_110_n44#
+ nmos_5p04310591302084_3v64x8m81_0/a_1876_n44# nmos_5p04310591302084_3v64x8m81_0/a_1233_n44#
+ nmos_5p04310591302084_3v64x8m81_0/a_270_n44# nmos_5p04310591302084_3v64x8m81_0/D_uq8
+ nmos_5p04310591302084_3v64x8m81_0/D_uq7 nmos_5p04310591302084_3v64x8m81_0/a_912_n44#
+ nmos_5p04310591302084_3v64x8m81_0/D_uq6 nmos_5p04310591302084_3v64x8m81_0/a_2518_n44#
+ nmos_5p04310591302084_3v64x8m81_0/D_uq4 nmos_5p04310591302084_3v64x8m81_0/D_uq5
+ nmos_5p04310591302084_3v64x8m81_0/D_uq3 nmos_5p04310591302084_3v64x8m81_0/a_n372_n44#
+ VSUBS nmos_5p04310591302084_3v64x8m81
.ends

.subckt gen_3v64x8_3v64x8m81 VSS tblhl IGWEN cen clk WEN GWE wen_v2_3v64x8m81_0/wen
+ VDD_uq3 pmos_5p04310591302088_3v64x8m81_0/D men VDD VDD_uq2
Xpmos_5p04310591302074_3v64x8m81_1 pmos_5p04310591302074_3v64x8m81_1/D pmos_5p04310591302074_3v64x8m81_0/D
+ VDD VDD pmos_5p04310591302074_3v64x8m81
Xpmos_1p2$$48623660_3v64x8m81_0 pmos_5p04310591302094_3v64x8m81_0/D VDD VDD VDD pmos_5p04310591302094_3v64x8m81_0/D
+ pmos_1p2$$48623660_3v64x8m81_0/pmos_5p04310591302073_3v64x8m81_0/D pmos_1p2$$48623660_3v64x8m81
Xpmos_1p2$$48624684_3v64x8m81_0 VDD_uq2 pmos_5p04310591302051_3v64x8m81_0/D pmos_1p2$$48624684_3v64x8m81_2/pmos_5p04310591302091_3v64x8m81_0/S
+ VDD_uq2 pmos_1p2$$48624684_3v64x8m81
Xnmos_1p2$$46551084_3v64x8m81_0 cen nmos_1p2$$47342636_3v64x8m81_1/nmos_5p04310591302053_3v64x8m81_0/S
+ nmos_1p2$$46563372_3v64x8m81_2/nmos_5p0431059130208_3v64x8m81_0/S VSS nmos_1p2$$46551084_3v64x8m81
Xpmos_5p04310591302089_3v64x8m81_0 men men pmos_5p04310591302088_3v64x8m81_0/D men
+ pmos_5p04310591302088_3v64x8m81_0/D men pmos_5p04310591302088_3v64x8m81_0/D pmos_5p04310591302088_3v64x8m81_0/D
+ pmos_5p04310591302088_3v64x8m81_0/D pmos_5p04310591302088_3v64x8m81_0/D pmos_5p04310591302088_3v64x8m81_0/D
+ pmos_5p04310591302088_3v64x8m81_0/D VDD_uq3 VDD_uq3 VDD_uq3 VDD_uq3 pmos_5p04310591302088_3v64x8m81_0/D
+ VDD_uq3 pmos_5p04310591302088_3v64x8m81_0/D pmos_5p04310591302088_3v64x8m81_0/D
+ VDD_uq3 VDD_uq3 VDD_uq3 pmos_5p04310591302088_3v64x8m81_0/D VDD_uq3 VDD_uq3 VDD_uq3
+ VDD_uq3 pmos_5p04310591302088_3v64x8m81_0/D pmos_5p04310591302088_3v64x8m81_0/D
+ pmos_5p04310591302088_3v64x8m81_0/D pmos_5p04310591302088_3v64x8m81_0/D pmos_5p04310591302088_3v64x8m81_0/D
+ men men pmos_5p04310591302088_3v64x8m81_0/D pmos_5p04310591302088_3v64x8m81_0/D
+ men pmos_5p04310591302088_3v64x8m81_0/D men men men pmos_5p04310591302089_3v64x8m81
Xpmos_5p04310591302088_3v64x8m81_0 pmos_5p04310591302088_3v64x8m81_0/D pmos_5p04310591302088_3v64x8m81_0/D
+ pmos_5p04310591302088_3v64x8m81_0/D pmos_5p04310591302088_3v64x8m81_0/D pmos_1p2$$47815724_3v64x8m81_7/pmos_5p04310591302087_3v64x8m81_0/S
+ pmos_1p2$$47815724_3v64x8m81_7/pmos_5p04310591302087_3v64x8m81_0/S pmos_1p2$$47815724_3v64x8m81_7/pmos_5p04310591302087_3v64x8m81_0/S
+ VDD_uq3 VDD_uq3 VDD_uq3 VDD_uq3 VDD_uq3 pmos_1p2$$47815724_3v64x8m81_7/pmos_5p04310591302087_3v64x8m81_0/S
+ VDD_uq3 VDD_uq3 pmos_1p2$$47815724_3v64x8m81_7/pmos_5p04310591302087_3v64x8m81_0/S
+ pmos_1p2$$47815724_3v64x8m81_7/pmos_5p04310591302087_3v64x8m81_0/S pmos_1p2$$47815724_3v64x8m81_7/pmos_5p04310591302087_3v64x8m81_0/S
+ pmos_1p2$$47815724_3v64x8m81_7/pmos_5p04310591302087_3v64x8m81_0/S pmos_1p2$$47815724_3v64x8m81_7/pmos_5p04310591302087_3v64x8m81_0/S
+ pmos_5p04310591302088_3v64x8m81_0/D pmos_1p2$$47815724_3v64x8m81_7/pmos_5p04310591302087_3v64x8m81_0/S
+ pmos_5p04310591302088_3v64x8m81
Xpmos_1p2$$48624684_3v64x8m81_1 VDD_uq2 pmos_1p2$$48623660_3v64x8m81_0/pmos_5p04310591302073_3v64x8m81_0/D
+ pmos_1p2$$48624684_3v64x8m81_2/pmos_5p04310591302091_3v64x8m81_0/S VDD_uq2 pmos_1p2$$48624684_3v64x8m81
Xpmos_1p2$$48624684_3v64x8m81_2 pmos_1p2$$48624684_3v64x8m81_2/pmos_5p04310591302091_3v64x8m81_0/S
+ clk VDD_uq2 VDD_uq2 pmos_1p2$$48624684_3v64x8m81
Xnmos_1p2$$48302124_3v64x8m81_0 pmos_1p2$$48623660_3v64x8m81_0/pmos_5p04310591302073_3v64x8m81_0/D
+ pmos_5p04310591302094_3v64x8m81_0/D VSS VSS nmos_1p2$$48302124_3v64x8m81
Xpmos_1p2$$46285868_3v64x8m81_0 VDD_uq2 VDD_uq2 nmos_1p2$$46563372_3v64x8m81_0/nmos_5p0431059130208_3v64x8m81_0/D
+ nmos_1p2$$47342636_3v64x8m81_1/nmos_5p04310591302053_3v64x8m81_0/S pmos_1p2$$46285868_3v64x8m81
Xpmos_1p2$$46285868_3v64x8m81_1 VDD_uq2 nmos_1p2$$46563372_3v64x8m81_2/nmos_5p0431059130208_3v64x8m81_0/S
+ cen nmos_1p2$$46563372_3v64x8m81_0/nmos_5p0431059130208_3v64x8m81_0/D pmos_1p2$$46285868_3v64x8m81
Xpmos_1p2$$46273580_3v64x8m81_0 VDD_uq2 pmos_5p04310591302051_3v64x8m81_0/D VDD_uq2
+ VDD_uq2 pmos_5p04310591302051_3v64x8m81_0/D pmos_1p2$$46273580_3v64x8m81_0/pmos_5p0431059130203_3v64x8m81_0/D
+ pmos_1p2$$46273580_3v64x8m81
Xpmos_5p04310591302094_3v64x8m81_0 pmos_5p04310591302094_3v64x8m81_0/D pmos_5p04310591302092_3v64x8m81_0/D
+ VDD VDD pmos_5p04310591302094_3v64x8m81
Xpmos_5p04310591302092_3v64x8m81_0 pmos_5p04310591302092_3v64x8m81_0/D pmos_5p04310591302074_3v64x8m81_1/D
+ VDD VDD pmos_5p04310591302092_3v64x8m81
Xpmos_1p2$$47815724_3v64x8m81_0 pmos_1p2$$47815724_3v64x8m81_3/pmos_5p04310591302087_3v64x8m81_0/S
+ tblhl VDD_uq2 VDD_uq2 pmos_1p2$$47815724_3v64x8m81
Xnmos_1p2$$46563372_3v64x8m81_0 VSS nmos_1p2$$47342636_3v64x8m81_1/nmos_5p04310591302053_3v64x8m81_0/S
+ nmos_1p2$$46563372_3v64x8m81_0/nmos_5p0431059130208_3v64x8m81_0/D VSS nmos_1p2$$46563372_3v64x8m81
Xpmos_1p2$$47815724_3v64x8m81_1 VDD_uq2 pmos_1p2$$47815724_3v64x8m81_7/pmos_5p04310591302087_3v64x8m81_0/S
+ pmos_1p2$$47815724_3v64x8m81_3/pmos_5p04310591302087_3v64x8m81_0/S VDD_uq2 pmos_1p2$$47815724_3v64x8m81
Xnmos_1p2$$46563372_3v64x8m81_1 pmos_1p2$$46273580_3v64x8m81_0/pmos_5p0431059130203_3v64x8m81_0/D
+ pmos_5p04310591302051_3v64x8m81_0/D VSS VSS nmos_1p2$$46563372_3v64x8m81
Xpmos_1p2$$47815724_3v64x8m81_2 VDD_uq2 tblhl pmos_1p2$$47815724_3v64x8m81_3/pmos_5p04310591302087_3v64x8m81_0/S
+ VDD_uq2 pmos_1p2$$47815724_3v64x8m81
Xnmos_1p2$$46563372_3v64x8m81_2 nmos_1p2$$46563372_3v64x8m81_2/nmos_5p0431059130208_3v64x8m81_0/S
+ nmos_1p2$$46563372_3v64x8m81_0/nmos_5p0431059130208_3v64x8m81_0/D pmos_1p2$$46273580_3v64x8m81_0/pmos_5p0431059130203_3v64x8m81_0/D
+ VSS nmos_1p2$$46563372_3v64x8m81
Xpmos_1p2$$47815724_3v64x8m81_3 pmos_1p2$$47815724_3v64x8m81_3/pmos_5p04310591302087_3v64x8m81_0/S
+ pmos_1p2$$47815724_3v64x8m81_7/pmos_5p04310591302087_3v64x8m81_0/S VDD_uq2 VDD_uq2
+ pmos_1p2$$47815724_3v64x8m81
Xpmos_1p2$$47815724_3v64x8m81_4 VDD_uq2 pmos_1p2$$47815724_3v64x8m81_3/pmos_5p04310591302087_3v64x8m81_0/S
+ pmos_1p2$$47815724_3v64x8m81_7/pmos_5p04310591302087_3v64x8m81_0/S VDD_uq2 pmos_1p2$$47815724_3v64x8m81
Xpmos_1p2$$47815724_3v64x8m81_5 VDD_uq2 pmos_1p2$$48624684_3v64x8m81_2/pmos_5p04310591302091_3v64x8m81_0/S
+ pmos_1p2$$47815724_3v64x8m81_7/pmos_5p04310591302087_3v64x8m81_0/S VDD_uq2 pmos_1p2$$47815724_3v64x8m81
Xpmos_1p2$$47815724_3v64x8m81_6 pmos_1p2$$47815724_3v64x8m81_7/pmos_5p04310591302087_3v64x8m81_0/S
+ pmos_1p2$$47815724_3v64x8m81_3/pmos_5p04310591302087_3v64x8m81_0/S VDD_uq2 VDD_uq2
+ pmos_1p2$$47815724_3v64x8m81
Xpmos_1p2$$47815724_3v64x8m81_7 pmos_1p2$$47815724_3v64x8m81_7/pmos_5p04310591302087_3v64x8m81_0/S
+ pmos_1p2$$48624684_3v64x8m81_2/pmos_5p04310591302091_3v64x8m81_0/S VDD_uq2 VDD_uq2
+ pmos_1p2$$47815724_3v64x8m81
Xpmos_5p04310591302051_3v64x8m81_0 pmos_5p04310591302051_3v64x8m81_0/D nmos_1p2$$46563372_3v64x8m81_2/nmos_5p0431059130208_3v64x8m81_0/S
+ nmos_1p2$$46563372_3v64x8m81_2/nmos_5p0431059130208_3v64x8m81_0/S VDD_uq2 VDD_uq2
+ VDD_uq2 pmos_5p04310591302051_3v64x8m81
Xnmos_5p04310591302083_3v64x8m81_0 pmos_5p04310591302094_3v64x8m81_0/D pmos_5p04310591302092_3v64x8m81_0/D
+ VSS VSS nmos_5p04310591302083_3v64x8m81
Xnmos_5p04310591302093_3v64x8m81_0 pmos_5p04310591302074_3v64x8m81_0/D clk VSS VSS
+ nmos_5p04310591302093_3v64x8m81
Xnmos_1p2$$48306220_3v64x8m81_0 pmos_5p04310591302088_3v64x8m81_0/D pmos_1p2$$47815724_3v64x8m81_7/pmos_5p04310591302087_3v64x8m81_0/S
+ pmos_1p2$$47815724_3v64x8m81_7/pmos_5p04310591302087_3v64x8m81_0/S VSS VSS pmos_5p04310591302088_3v64x8m81_0/D
+ pmos_5p04310591302088_3v64x8m81_0/D VSS pmos_1p2$$47815724_3v64x8m81_7/pmos_5p04310591302087_3v64x8m81_0/S
+ pmos_1p2$$47815724_3v64x8m81_7/pmos_5p04310591302087_3v64x8m81_0/S pmos_1p2$$47815724_3v64x8m81_7/pmos_5p04310591302087_3v64x8m81_0/S
+ VSS nmos_1p2$$48306220_3v64x8m81
Xwen_v2_3v64x8m81_0 IGWEN clk wen_v2_3v64x8m81_0/wen GWE VDD VSS wen_v2_3v64x8m81
Xnmos_5p04310591302093_3v64x8m81_1 pmos_5p04310591302074_3v64x8m81_1/D pmos_5p04310591302074_3v64x8m81_0/D
+ VSS VSS nmos_5p04310591302093_3v64x8m81
Xnmos_1p2$$47342636_3v64x8m81_0 VSS nmos_1p2$$47342636_3v64x8m81_1/nmos_5p04310591302053_3v64x8m81_0/S
+ clk VSS nmos_1p2$$47342636_3v64x8m81
Xnmos_1p2$$47342636_3v64x8m81_1 nmos_1p2$$47342636_3v64x8m81_1/nmos_5p04310591302053_3v64x8m81_0/S
+ VSS men VSS nmos_1p2$$47342636_3v64x8m81
Xnmos_5p04310591302090_3v64x8m81_0 pmos_5p04310591302092_3v64x8m81_0/D pmos_5p04310591302074_3v64x8m81_1/D
+ VSS VSS nmos_5p04310591302090_3v64x8m81
Xpmos_1p2$$47330348_3v64x8m81_0 pmos_1p2$$46273580_3v64x8m81_0/pmos_5p0431059130203_3v64x8m81_0/D
+ nmos_1p2$$47342636_3v64x8m81_1/nmos_5p04310591302053_3v64x8m81_0/S nmos_1p2$$46563372_3v64x8m81_2/nmos_5p0431059130208_3v64x8m81_0/S
+ VDD_uq2 pmos_1p2$$47330348_3v64x8m81
Xnmos_1p2$$48629804_3v64x8m81_0 pmos_5p04310591302051_3v64x8m81_0/D VSS nmos_1p2$$46563372_3v64x8m81_2/nmos_5p0431059130208_3v64x8m81_0/S
+ nmos_1p2$$46563372_3v64x8m81_2/nmos_5p0431059130208_3v64x8m81_0/S VSS VSS nmos_1p2$$48629804_3v64x8m81
Xnmos_1p2$$48308268_3v64x8m81_0 pmos_5p04310591302088_3v64x8m81_0/D pmos_5p04310591302088_3v64x8m81_0/D
+ pmos_5p04310591302088_3v64x8m81_0/D VSS pmos_5p04310591302088_3v64x8m81_0/D VSS
+ pmos_5p04310591302088_3v64x8m81_0/D VSS pmos_5p04310591302088_3v64x8m81_0/D VSS
+ VSS VSS pmos_5p04310591302088_3v64x8m81_0/D VSS pmos_5p04310591302088_3v64x8m81_0/D
+ pmos_5p04310591302088_3v64x8m81_0/D VSS VSS VSS pmos_5p04310591302088_3v64x8m81_0/D
+ VSS men pmos_5p04310591302088_3v64x8m81_0/D pmos_5p04310591302088_3v64x8m81_0/D
+ pmos_5p04310591302088_3v64x8m81_0/D men pmos_5p04310591302088_3v64x8m81_0/D men
+ men pmos_5p04310591302088_3v64x8m81_0/D men pmos_5p04310591302088_3v64x8m81_0/D
+ men pmos_5p04310591302088_3v64x8m81_0/D men pmos_5p04310591302088_3v64x8m81_0/D
+ men men men pmos_5p04310591302088_3v64x8m81_0/D VSS pmos_5p04310591302088_3v64x8m81_0/D
+ nmos_1p2$$48308268_3v64x8m81
Xpmos_5p04310591302074_3v64x8m81_0 pmos_5p04310591302074_3v64x8m81_0/D clk VDD VDD
+ pmos_5p04310591302074_3v64x8m81
X0 a_8790_2243# tblhl pmos_1p2$$47815724_3v64x8m81_3/pmos_5p04310591302087_3v64x8m81_0/S VSS nfet_03v3 ad=0.5499p pd=2.635u as=0.5499p ps=2.635u w=2.115u l=0.28u
X1 a_3606_4291# men VDD_uq2 VDD_uq2 pfet_03v3 ad=0.2769p pd=1.585u as=0.50587p ps=3.08u w=1.065u l=0.28u
X2 a_7891_338# pmos_1p2$$48624684_3v64x8m81_2/pmos_5p04310591302091_3v64x8m81_0/S pmos_1p2$$47815724_3v64x8m81_7/pmos_5p04310591302087_3v64x8m81_0/S VSS nfet_03v3 ad=2.2009p pd=8.985u as=2.2009p ps=8.985u w=8.465u l=0.28u
X3 a_6888_183# clk a_6728_183# VSS nfet_03v3 ad=2.7521p pd=11.105u as=2.7521p ps=11.105u w=10.585u l=0.28u
X4 VSS pmos_1p2$$47815724_3v64x8m81_3/pmos_5p04310591302087_3v64x8m81_0/S a_7891_338# VSS nfet_03v3 ad=3.93622p pd=17.86u as=2.2009p ps=8.985u w=8.465u l=0.28u
X5 pmos_1p2$$47815724_3v64x8m81_3/pmos_5p04310591302087_3v64x8m81_0/S tblhl a_8470_2243# VSS nfet_03v3 ad=0.5499p pd=2.635u as=0.5499p ps=2.635u w=2.115u l=0.28u
X6 a_8470_2243# pmos_1p2$$47815724_3v64x8m81_7/pmos_5p04310591302087_3v64x8m81_0/S VSS VSS nfet_03v3 ad=0.5499p pd=2.635u as=0.96232p ps=5.14u w=2.115u l=0.28u
X7 pmos_1p2$$48624684_3v64x8m81_2/pmos_5p04310591302091_3v64x8m81_0/S pmos_5p04310591302051_3v64x8m81_0/D a_6888_183# VSS nfet_03v3 ad=5.2925p pd=22.17u as=2.7521p ps=11.105u w=10.585u l=0.28u
X8 a_7571_338# pmos_1p2$$47815724_3v64x8m81_3/pmos_5p04310591302087_3v64x8m81_0/S VSS VSS nfet_03v3 ad=2.2009p pd=8.985u as=3.85157p ps=17.84u w=8.465u l=0.28u
X9 pmos_1p2$$47815724_3v64x8m81_7/pmos_5p04310591302087_3v64x8m81_0/S pmos_1p2$$48624684_3v64x8m81_2/pmos_5p04310591302091_3v64x8m81_0/S a_7571_338# VSS nfet_03v3 ad=2.2009p pd=8.985u as=2.2009p ps=8.985u w=8.465u l=0.28u
X10 a_6728_183# pmos_1p2$$48623660_3v64x8m81_0/pmos_5p04310591302073_3v64x8m81_0/D VSS VSS nfet_03v3 ad=2.7521p pd=11.105u as=4.6574p ps=22.05u w=10.585u l=0.28u
X11 nmos_1p2$$47342636_3v64x8m81_1/nmos_5p04310591302053_3v64x8m81_0/S clk a_3606_4291# VDD_uq2 pfet_03v3 ad=0.50587p pd=3.08u as=0.2769p ps=1.585u w=1.065u l=0.28u
X12 VSS pmos_1p2$$47815724_3v64x8m81_7/pmos_5p04310591302087_3v64x8m81_0/S a_8790_2243# VSS nfet_03v3 ad=0.99405p pd=5.17u as=0.5499p ps=2.635u w=2.115u l=0.28u
.ends

.subckt nmos_5p04310591302071_3v64x8m81 D a_0_n44# S VSUBS
X0 D a_0_n44# S VSUBS nfet_03v3 ad=1.3508p pd=7.02u as=1.3508p ps=7.02u w=3.07u l=0.28u
.ends

.subckt nmos_1p2$$47336492_3v64x8m81 nmos_5p04310591302071_3v64x8m81_0/D a_n14_n34#
+ nmos_5p04310591302071_3v64x8m81_0/S VSUBS
Xnmos_5p04310591302071_3v64x8m81_0 nmos_5p04310591302071_3v64x8m81_0/D a_n14_n34#
+ nmos_5p04310591302071_3v64x8m81_0/S VSUBS nmos_5p04310591302071_3v64x8m81
.ends

.subckt pmos_5p04310591302070_3v64x8m81 D a_0_n44# w_n174_n86# S
X0 D a_0_n44# S w_n174_n86# pfet_03v3 ad=3.3528p pd=16.12u as=3.3528p ps=16.12u w=7.62u l=0.28u
.ends

.subckt pmos_1p2$$47337516_3v64x8m81 a_n14_n34# pmos_5p04310591302070_3v64x8m81_0/S
+ pmos_5p04310591302070_3v64x8m81_0/D w_n133_n65#
Xpmos_5p04310591302070_3v64x8m81_0 pmos_5p04310591302070_3v64x8m81_0/D a_n14_n34#
+ w_n133_n65# pmos_5p04310591302070_3v64x8m81_0/S pmos_5p04310591302070_3v64x8m81
.ends

.subckt xpredec1_bot_3v64x8m81 m1_n74_2740# pmos_1p2$$47337516_3v64x8m81_0/pmos_5p04310591302070_3v64x8m81_0/D
+ pmos_1p2$$47337516_3v64x8m81_1/pmos_5p04310591302070_3v64x8m81_0/D m1_n74_3446#
+ alatch_3v64x8m81_0/enb m1_n74_3164# alatch_3v64x8m81_0/vdd m1_n74_3305# alatch_3v64x8m81_0/a
+ m1_n74_3023# pmos_1p2$$47337516_3v64x8m81_1/pmos_5p04310591302070_3v64x8m81_0/S
+ alatch_3v64x8m81_0/en m1_n74_2881# VSUBS
Xnmos_1p2$$47336492_3v64x8m81_0 pmos_1p2$$47337516_3v64x8m81_0/pmos_5p04310591302070_3v64x8m81_0/D
+ pmos_1p2$$47337516_3v64x8m81_1/pmos_5p04310591302070_3v64x8m81_0/D VSUBS VSUBS nmos_1p2$$47336492_3v64x8m81
Xnmos_1p2$$47336492_3v64x8m81_1 pmos_1p2$$47337516_3v64x8m81_1/pmos_5p04310591302070_3v64x8m81_0/D
+ alatch_3v64x8m81_0/ab VSUBS VSUBS nmos_1p2$$47336492_3v64x8m81
Xpmos_1p2$$47337516_3v64x8m81_0 pmos_1p2$$47337516_3v64x8m81_1/pmos_5p04310591302070_3v64x8m81_0/D
+ pmos_1p2$$47337516_3v64x8m81_1/pmos_5p04310591302070_3v64x8m81_0/S pmos_1p2$$47337516_3v64x8m81_0/pmos_5p04310591302070_3v64x8m81_0/D
+ pmos_1p2$$47337516_3v64x8m81_1/pmos_5p04310591302070_3v64x8m81_0/S pmos_1p2$$47337516_3v64x8m81
Xpmos_1p2$$47337516_3v64x8m81_1 alatch_3v64x8m81_0/ab pmos_1p2$$47337516_3v64x8m81_1/pmos_5p04310591302070_3v64x8m81_0/S
+ pmos_1p2$$47337516_3v64x8m81_1/pmos_5p04310591302070_3v64x8m81_0/D pmos_1p2$$47337516_3v64x8m81_1/pmos_5p04310591302070_3v64x8m81_0/S
+ pmos_1p2$$47337516_3v64x8m81
Xalatch_3v64x8m81_0 alatch_3v64x8m81_0/enb alatch_3v64x8m81_0/en alatch_3v64x8m81_0/ab
+ alatch_3v64x8m81_0/a alatch_3v64x8m81_0/vdd VSUBS alatch_3v64x8m81
.ends

.subckt pmos_5p04310591302072_3v64x8m81 D a_0_n44# w_n174_n86# S
X0 D a_0_n44# S w_n174_n86# pfet_03v3 ad=2.1406p pd=10.61u as=2.1406p ps=10.61u w=4.865u l=0.28u
.ends

.subckt pmos_1p2$$47512620_3v64x8m81 pmos_5p04310591302072_3v64x8m81_0/S w_n133_n66#
+ pmos_5p04310591302072_3v64x8m81_0/D a_n14_n34#
Xpmos_5p04310591302072_3v64x8m81_0 pmos_5p04310591302072_3v64x8m81_0/D a_n14_n34#
+ w_n133_n66# pmos_5p04310591302072_3v64x8m81_0/S pmos_5p04310591302072_3v64x8m81
.ends

.subckt pmos_5p04310591302068_3v64x8m81 D a_0_n44# w_n174_n86# S
X0 D a_0_n44# S w_n174_n86# pfet_03v3 ad=2.3276p pd=11.46u as=2.3276p ps=11.46u w=5.29u l=0.28u
.ends

.subckt pmos_1p2$$47513644_3v64x8m81 pmos_5p04310591302068_3v64x8m81_0/D a_n14_n34#
+ w_n133_n65# pmos_5p04310591302068_3v64x8m81_0/S
Xpmos_5p04310591302068_3v64x8m81_0 pmos_5p04310591302068_3v64x8m81_0/D a_n14_n34#
+ w_n133_n65# pmos_5p04310591302068_3v64x8m81_0/S pmos_5p04310591302068_3v64x8m81
.ends

.subckt xpredec1_xa_3v64x8m81 m1_n40_n4147# m1_n40_n4005# m3_n46_n5510# a_145_n5643#
+ m1_n40_n3864# m1_n40_n3582# m1_n40_n3723# a_0_56# m1_n40_n3441# pmos_1p2$$47513644_3v64x8m81_2/pmos_5p04310591302068_3v64x8m81_0/D
+ a_465_n5643# M3_M2$$47333420_3v64x8m81_1/VSUBS pmos_1p2$$47513644_3v64x8m81_2/pmos_5p04310591302068_3v64x8m81_0/S
+ a_305_n5643#
Xnmos_1p2$$47514668_3v64x8m81_0 M3_M2$$47333420_3v64x8m81_1/VSUBS pmos_1p2$$47512620_3v64x8m81_3/pmos_5p04310591302072_3v64x8m81_0/S
+ pmos_1p2$$47513644_3v64x8m81_2/pmos_5p04310591302068_3v64x8m81_0/D M3_M2$$47333420_3v64x8m81_1/VSUBS
+ nmos_1p2$$47514668_3v64x8m81
Xnmos_1p2$$47514668_3v64x8m81_2 M3_M2$$47333420_3v64x8m81_1/VSUBS pmos_1p2$$47512620_3v64x8m81_3/pmos_5p04310591302072_3v64x8m81_0/S
+ pmos_1p2$$47513644_3v64x8m81_2/pmos_5p04310591302068_3v64x8m81_0/D M3_M2$$47333420_3v64x8m81_1/VSUBS
+ nmos_1p2$$47514668_3v64x8m81
Xnmos_1p2$$47514668_3v64x8m81_1 pmos_1p2$$47513644_3v64x8m81_2/pmos_5p04310591302068_3v64x8m81_0/D
+ pmos_1p2$$47512620_3v64x8m81_3/pmos_5p04310591302072_3v64x8m81_0/S M3_M2$$47333420_3v64x8m81_1/VSUBS
+ M3_M2$$47333420_3v64x8m81_1/VSUBS nmos_1p2$$47514668_3v64x8m81
Xpmos_1p2$$47512620_3v64x8m81_0 pmos_1p2$$47513644_3v64x8m81_2/pmos_5p04310591302068_3v64x8m81_0/S
+ pmos_1p2$$47513644_3v64x8m81_2/pmos_5p04310591302068_3v64x8m81_0/S pmos_1p2$$47512620_3v64x8m81_3/pmos_5p04310591302072_3v64x8m81_0/S
+ a_145_n5643# pmos_1p2$$47512620_3v64x8m81
Xpmos_1p2$$47512620_3v64x8m81_1 pmos_1p2$$47513644_3v64x8m81_2/pmos_5p04310591302068_3v64x8m81_0/S
+ pmos_1p2$$47513644_3v64x8m81_2/pmos_5p04310591302068_3v64x8m81_0/S pmos_1p2$$47512620_3v64x8m81_3/pmos_5p04310591302072_3v64x8m81_0/S
+ a_465_n5643# pmos_1p2$$47512620_3v64x8m81
Xpmos_1p2$$47513644_3v64x8m81_1 pmos_1p2$$47513644_3v64x8m81_2/pmos_5p04310591302068_3v64x8m81_0/D
+ pmos_1p2$$47512620_3v64x8m81_3/pmos_5p04310591302072_3v64x8m81_0/S pmos_1p2$$47513644_3v64x8m81_2/pmos_5p04310591302068_3v64x8m81_0/S
+ pmos_1p2$$47513644_3v64x8m81_2/pmos_5p04310591302068_3v64x8m81_0/S pmos_1p2$$47513644_3v64x8m81
Xpmos_1p2$$47513644_3v64x8m81_0 pmos_1p2$$47513644_3v64x8m81_2/pmos_5p04310591302068_3v64x8m81_0/S
+ pmos_1p2$$47512620_3v64x8m81_3/pmos_5p04310591302072_3v64x8m81_0/S pmos_1p2$$47513644_3v64x8m81_2/pmos_5p04310591302068_3v64x8m81_0/S
+ pmos_1p2$$47513644_3v64x8m81_2/pmos_5p04310591302068_3v64x8m81_0/D pmos_1p2$$47513644_3v64x8m81
Xpmos_1p2$$47513644_3v64x8m81_2 pmos_1p2$$47513644_3v64x8m81_2/pmos_5p04310591302068_3v64x8m81_0/D
+ pmos_1p2$$47512620_3v64x8m81_3/pmos_5p04310591302072_3v64x8m81_0/S pmos_1p2$$47513644_3v64x8m81_2/pmos_5p04310591302068_3v64x8m81_0/S
+ pmos_1p2$$47513644_3v64x8m81_2/pmos_5p04310591302068_3v64x8m81_0/S pmos_1p2$$47513644_3v64x8m81
Xpmos_1p2$$47512620_3v64x8m81_3 pmos_1p2$$47512620_3v64x8m81_3/pmos_5p04310591302072_3v64x8m81_0/S
+ pmos_1p2$$47513644_3v64x8m81_2/pmos_5p04310591302068_3v64x8m81_0/S pmos_1p2$$47513644_3v64x8m81_2/pmos_5p04310591302068_3v64x8m81_0/S
+ a_305_n5643# pmos_1p2$$47512620_3v64x8m81
X0 a_361_n5592# a_305_n5643# a_201_n5592# M3_M2$$47333420_3v64x8m81_1/VSUBS nfet_03v3 ad=1.5145p pd=6.345u as=1.5145p ps=6.345u w=5.825u l=0.28u
X1 a_201_n5592# a_145_n5643# M3_M2$$47333420_3v64x8m81_1/VSUBS M3_M2$$47333420_3v64x8m81_1/VSUBS nfet_03v3 ad=1.5145p pd=6.345u as=2.65037p ps=12.56u w=5.825u l=0.28u
X2 pmos_1p2$$47512620_3v64x8m81_3/pmos_5p04310591302072_3v64x8m81_0/S a_465_n5643# a_361_n5592# M3_M2$$47333420_3v64x8m81_1/VSUBS nfet_03v3 ad=2.82512p pd=12.62u as=1.5145p ps=6.345u w=5.825u l=0.28u
.ends

.subckt xpredec1_3v64x8m81 vdd men x[7] x[6] x[5] x[4] x[2] x[1] x[0] clk vdd_uq0
+ w_5024_6624# pmos_1p2$$47109164_3v64x8m81_0/pmos_5p04310591302062_3v64x8m81_0/w_n202_n86#
+ xpredec1_xa_3v64x8m81_7/m3_n46_n5510# A[2] xpredec1_bot_3v64x8m81_2/alatch_3v64x8m81_0/vdd
+ A[1] A[0] vss x[3]
Xxpredec1_bot_3v64x8m81_2 xpredec1_bot_3v64x8m81_0/pmos_1p2$$47337516_3v64x8m81_0/pmos_5p04310591302070_3v64x8m81_0/D
+ xpredec1_bot_3v64x8m81_2/pmos_1p2$$47337516_3v64x8m81_0/pmos_5p04310591302070_3v64x8m81_0/D
+ xpredec1_bot_3v64x8m81_2/pmos_1p2$$47337516_3v64x8m81_1/pmos_5p04310591302070_3v64x8m81_0/D
+ xpredec1_bot_3v64x8m81_1/pmos_1p2$$47337516_3v64x8m81_1/pmos_5p04310591302070_3v64x8m81_0/D
+ xpredec1_bot_3v64x8m81_2/alatch_3v64x8m81_0/enb xpredec1_bot_3v64x8m81_0/pmos_1p2$$47337516_3v64x8m81_1/pmos_5p04310591302070_3v64x8m81_0/D
+ xpredec1_bot_3v64x8m81_2/alatch_3v64x8m81_0/vdd xpredec1_bot_3v64x8m81_2/pmos_1p2$$47337516_3v64x8m81_1/pmos_5p04310591302070_3v64x8m81_0/D
+ A[1] xpredec1_bot_3v64x8m81_1/pmos_1p2$$47337516_3v64x8m81_0/pmos_5p04310591302070_3v64x8m81_0/D
+ vdd_uq0 nmos_5p04310591302056_3v64x8m81_1/D xpredec1_bot_3v64x8m81_2/pmos_1p2$$47337516_3v64x8m81_0/pmos_5p04310591302070_3v64x8m81_0/D
+ vss xpredec1_bot_3v64x8m81
Xnmos_5p04310591302056_3v64x8m81_0 vss clk nmos_5p04310591302056_3v64x8m81_1/D vss
+ nmos_5p04310591302056_3v64x8m81
Xnmos_5p04310591302056_3v64x8m81_1 nmos_5p04310591302056_3v64x8m81_1/D men vss vss
+ nmos_5p04310591302056_3v64x8m81
Xxpredec1_xa_3v64x8m81_0 xpredec1_bot_3v64x8m81_0/pmos_1p2$$47337516_3v64x8m81_0/pmos_5p04310591302070_3v64x8m81_0/D
+ xpredec1_bot_3v64x8m81_2/pmos_1p2$$47337516_3v64x8m81_0/pmos_5p04310591302070_3v64x8m81_0/D
+ xpredec1_xa_3v64x8m81_7/m3_n46_n5510# xpredec1_bot_3v64x8m81_0/pmos_1p2$$47337516_3v64x8m81_1/pmos_5p04310591302070_3v64x8m81_0/D
+ xpredec1_bot_3v64x8m81_1/pmos_1p2$$47337516_3v64x8m81_0/pmos_5p04310591302070_3v64x8m81_0/D
+ xpredec1_bot_3v64x8m81_2/pmos_1p2$$47337516_3v64x8m81_1/pmos_5p04310591302070_3v64x8m81_0/D
+ xpredec1_bot_3v64x8m81_0/pmos_1p2$$47337516_3v64x8m81_1/pmos_5p04310591302070_3v64x8m81_0/D
+ xpredec1_xa_3v64x8m81_0/a_0_56# xpredec1_bot_3v64x8m81_1/pmos_1p2$$47337516_3v64x8m81_1/pmos_5p04310591302070_3v64x8m81_0/D
+ x[3] xpredec1_bot_3v64x8m81_1/pmos_1p2$$47337516_3v64x8m81_0/pmos_5p04310591302070_3v64x8m81_0/D
+ vss vdd_uq0 xpredec1_bot_3v64x8m81_2/pmos_1p2$$47337516_3v64x8m81_1/pmos_5p04310591302070_3v64x8m81_0/D
+ xpredec1_xa_3v64x8m81
Xxpredec1_xa_3v64x8m81_1 xpredec1_bot_3v64x8m81_0/pmos_1p2$$47337516_3v64x8m81_0/pmos_5p04310591302070_3v64x8m81_0/D
+ xpredec1_bot_3v64x8m81_2/pmos_1p2$$47337516_3v64x8m81_0/pmos_5p04310591302070_3v64x8m81_0/D
+ xpredec1_xa_3v64x8m81_7/m3_n46_n5510# xpredec1_bot_3v64x8m81_0/pmos_1p2$$47337516_3v64x8m81_1/pmos_5p04310591302070_3v64x8m81_0/D
+ xpredec1_bot_3v64x8m81_1/pmos_1p2$$47337516_3v64x8m81_0/pmos_5p04310591302070_3v64x8m81_0/D
+ xpredec1_bot_3v64x8m81_2/pmos_1p2$$47337516_3v64x8m81_1/pmos_5p04310591302070_3v64x8m81_0/D
+ xpredec1_bot_3v64x8m81_0/pmos_1p2$$47337516_3v64x8m81_1/pmos_5p04310591302070_3v64x8m81_0/D
+ vss xpredec1_bot_3v64x8m81_1/pmos_1p2$$47337516_3v64x8m81_1/pmos_5p04310591302070_3v64x8m81_0/D
+ x[1] xpredec1_bot_3v64x8m81_1/pmos_1p2$$47337516_3v64x8m81_0/pmos_5p04310591302070_3v64x8m81_0/D
+ vss vdd_uq0 xpredec1_bot_3v64x8m81_2/pmos_1p2$$47337516_3v64x8m81_0/pmos_5p04310591302070_3v64x8m81_0/D
+ xpredec1_xa_3v64x8m81
Xxpredec1_xa_3v64x8m81_3 xpredec1_bot_3v64x8m81_0/pmos_1p2$$47337516_3v64x8m81_0/pmos_5p04310591302070_3v64x8m81_0/D
+ xpredec1_bot_3v64x8m81_2/pmos_1p2$$47337516_3v64x8m81_0/pmos_5p04310591302070_3v64x8m81_0/D
+ xpredec1_xa_3v64x8m81_7/m3_n46_n5510# xpredec1_bot_3v64x8m81_0/pmos_1p2$$47337516_3v64x8m81_1/pmos_5p04310591302070_3v64x8m81_0/D
+ xpredec1_bot_3v64x8m81_1/pmos_1p2$$47337516_3v64x8m81_0/pmos_5p04310591302070_3v64x8m81_0/D
+ xpredec1_bot_3v64x8m81_2/pmos_1p2$$47337516_3v64x8m81_1/pmos_5p04310591302070_3v64x8m81_0/D
+ xpredec1_bot_3v64x8m81_0/pmos_1p2$$47337516_3v64x8m81_1/pmos_5p04310591302070_3v64x8m81_0/D
+ xpredec1_xa_3v64x8m81_3/a_0_56# xpredec1_bot_3v64x8m81_1/pmos_1p2$$47337516_3v64x8m81_1/pmos_5p04310591302070_3v64x8m81_0/D
+ x[7] xpredec1_bot_3v64x8m81_1/pmos_1p2$$47337516_3v64x8m81_1/pmos_5p04310591302070_3v64x8m81_0/D
+ vss vdd_uq0 xpredec1_bot_3v64x8m81_2/pmos_1p2$$47337516_3v64x8m81_1/pmos_5p04310591302070_3v64x8m81_0/D
+ xpredec1_xa_3v64x8m81
Xxpredec1_xa_3v64x8m81_2 xpredec1_bot_3v64x8m81_0/pmos_1p2$$47337516_3v64x8m81_0/pmos_5p04310591302070_3v64x8m81_0/D
+ xpredec1_bot_3v64x8m81_2/pmos_1p2$$47337516_3v64x8m81_0/pmos_5p04310591302070_3v64x8m81_0/D
+ xpredec1_xa_3v64x8m81_7/m3_n46_n5510# xpredec1_bot_3v64x8m81_0/pmos_1p2$$47337516_3v64x8m81_1/pmos_5p04310591302070_3v64x8m81_0/D
+ xpredec1_bot_3v64x8m81_1/pmos_1p2$$47337516_3v64x8m81_0/pmos_5p04310591302070_3v64x8m81_0/D
+ xpredec1_bot_3v64x8m81_2/pmos_1p2$$47337516_3v64x8m81_1/pmos_5p04310591302070_3v64x8m81_0/D
+ xpredec1_bot_3v64x8m81_0/pmos_1p2$$47337516_3v64x8m81_1/pmos_5p04310591302070_3v64x8m81_0/D
+ vss xpredec1_bot_3v64x8m81_1/pmos_1p2$$47337516_3v64x8m81_1/pmos_5p04310591302070_3v64x8m81_0/D
+ x[5] xpredec1_bot_3v64x8m81_1/pmos_1p2$$47337516_3v64x8m81_1/pmos_5p04310591302070_3v64x8m81_0/D
+ vss vdd_uq0 xpredec1_bot_3v64x8m81_2/pmos_1p2$$47337516_3v64x8m81_0/pmos_5p04310591302070_3v64x8m81_0/D
+ xpredec1_xa_3v64x8m81
Xxpredec1_xa_3v64x8m81_4 xpredec1_bot_3v64x8m81_0/pmos_1p2$$47337516_3v64x8m81_0/pmos_5p04310591302070_3v64x8m81_0/D
+ xpredec1_bot_3v64x8m81_2/pmos_1p2$$47337516_3v64x8m81_0/pmos_5p04310591302070_3v64x8m81_0/D
+ xpredec1_xa_3v64x8m81_7/m3_n46_n5510# xpredec1_bot_3v64x8m81_0/pmos_1p2$$47337516_3v64x8m81_0/pmos_5p04310591302070_3v64x8m81_0/D
+ xpredec1_bot_3v64x8m81_1/pmos_1p2$$47337516_3v64x8m81_0/pmos_5p04310591302070_3v64x8m81_0/D
+ xpredec1_bot_3v64x8m81_2/pmos_1p2$$47337516_3v64x8m81_1/pmos_5p04310591302070_3v64x8m81_0/D
+ xpredec1_bot_3v64x8m81_0/pmos_1p2$$47337516_3v64x8m81_1/pmos_5p04310591302070_3v64x8m81_0/D
+ xpredec1_xa_3v64x8m81_4/a_0_56# xpredec1_bot_3v64x8m81_1/pmos_1p2$$47337516_3v64x8m81_1/pmos_5p04310591302070_3v64x8m81_0/D
+ x[2] xpredec1_bot_3v64x8m81_1/pmos_1p2$$47337516_3v64x8m81_0/pmos_5p04310591302070_3v64x8m81_0/D
+ vss vdd_uq0 xpredec1_bot_3v64x8m81_2/pmos_1p2$$47337516_3v64x8m81_1/pmos_5p04310591302070_3v64x8m81_0/D
+ xpredec1_xa_3v64x8m81
Xxpredec1_xa_3v64x8m81_5 xpredec1_bot_3v64x8m81_0/pmos_1p2$$47337516_3v64x8m81_0/pmos_5p04310591302070_3v64x8m81_0/D
+ xpredec1_bot_3v64x8m81_2/pmos_1p2$$47337516_3v64x8m81_0/pmos_5p04310591302070_3v64x8m81_0/D
+ xpredec1_xa_3v64x8m81_7/m3_n46_n5510# xpredec1_bot_3v64x8m81_0/pmos_1p2$$47337516_3v64x8m81_0/pmos_5p04310591302070_3v64x8m81_0/D
+ xpredec1_bot_3v64x8m81_1/pmos_1p2$$47337516_3v64x8m81_0/pmos_5p04310591302070_3v64x8m81_0/D
+ xpredec1_bot_3v64x8m81_2/pmos_1p2$$47337516_3v64x8m81_1/pmos_5p04310591302070_3v64x8m81_0/D
+ xpredec1_bot_3v64x8m81_0/pmos_1p2$$47337516_3v64x8m81_1/pmos_5p04310591302070_3v64x8m81_0/D
+ xpredec1_xa_3v64x8m81_5/a_0_56# xpredec1_bot_3v64x8m81_1/pmos_1p2$$47337516_3v64x8m81_1/pmos_5p04310591302070_3v64x8m81_0/D
+ x[0] xpredec1_bot_3v64x8m81_1/pmos_1p2$$47337516_3v64x8m81_0/pmos_5p04310591302070_3v64x8m81_0/D
+ vss vdd_uq0 xpredec1_bot_3v64x8m81_2/pmos_1p2$$47337516_3v64x8m81_0/pmos_5p04310591302070_3v64x8m81_0/D
+ xpredec1_xa_3v64x8m81
Xxpredec1_xa_3v64x8m81_6 xpredec1_bot_3v64x8m81_0/pmos_1p2$$47337516_3v64x8m81_0/pmos_5p04310591302070_3v64x8m81_0/D
+ xpredec1_bot_3v64x8m81_2/pmos_1p2$$47337516_3v64x8m81_0/pmos_5p04310591302070_3v64x8m81_0/D
+ xpredec1_xa_3v64x8m81_7/m3_n46_n5510# xpredec1_bot_3v64x8m81_0/pmos_1p2$$47337516_3v64x8m81_0/pmos_5p04310591302070_3v64x8m81_0/D
+ xpredec1_bot_3v64x8m81_1/pmos_1p2$$47337516_3v64x8m81_0/pmos_5p04310591302070_3v64x8m81_0/D
+ xpredec1_bot_3v64x8m81_2/pmos_1p2$$47337516_3v64x8m81_1/pmos_5p04310591302070_3v64x8m81_0/D
+ xpredec1_bot_3v64x8m81_0/pmos_1p2$$47337516_3v64x8m81_1/pmos_5p04310591302070_3v64x8m81_0/D
+ xpredec1_xa_3v64x8m81_6/a_0_56# xpredec1_bot_3v64x8m81_1/pmos_1p2$$47337516_3v64x8m81_1/pmos_5p04310591302070_3v64x8m81_0/D
+ x[4] xpredec1_bot_3v64x8m81_1/pmos_1p2$$47337516_3v64x8m81_1/pmos_5p04310591302070_3v64x8m81_0/D
+ vss vdd_uq0 xpredec1_bot_3v64x8m81_2/pmos_1p2$$47337516_3v64x8m81_0/pmos_5p04310591302070_3v64x8m81_0/D
+ xpredec1_xa_3v64x8m81
Xxpredec1_xa_3v64x8m81_7 xpredec1_bot_3v64x8m81_0/pmos_1p2$$47337516_3v64x8m81_0/pmos_5p04310591302070_3v64x8m81_0/D
+ xpredec1_bot_3v64x8m81_2/pmos_1p2$$47337516_3v64x8m81_0/pmos_5p04310591302070_3v64x8m81_0/D
+ xpredec1_xa_3v64x8m81_7/m3_n46_n5510# xpredec1_bot_3v64x8m81_0/pmos_1p2$$47337516_3v64x8m81_0/pmos_5p04310591302070_3v64x8m81_0/D
+ xpredec1_bot_3v64x8m81_1/pmos_1p2$$47337516_3v64x8m81_0/pmos_5p04310591302070_3v64x8m81_0/D
+ xpredec1_bot_3v64x8m81_2/pmos_1p2$$47337516_3v64x8m81_1/pmos_5p04310591302070_3v64x8m81_0/D
+ xpredec1_bot_3v64x8m81_0/pmos_1p2$$47337516_3v64x8m81_1/pmos_5p04310591302070_3v64x8m81_0/D
+ xpredec1_xa_3v64x8m81_7/a_0_56# xpredec1_bot_3v64x8m81_1/pmos_1p2$$47337516_3v64x8m81_1/pmos_5p04310591302070_3v64x8m81_0/D
+ x[6] xpredec1_bot_3v64x8m81_1/pmos_1p2$$47337516_3v64x8m81_1/pmos_5p04310591302070_3v64x8m81_0/D
+ vss vdd_uq0 xpredec1_bot_3v64x8m81_2/pmos_1p2$$47337516_3v64x8m81_1/pmos_5p04310591302070_3v64x8m81_0/D
+ xpredec1_xa_3v64x8m81
Xpmos_1p2$$47109164_3v64x8m81_0 pmos_1p2$$47109164_3v64x8m81_0/pmos_5p04310591302062_3v64x8m81_0/w_n202_n86#
+ xpredec1_bot_3v64x8m81_2/alatch_3v64x8m81_0/enb nmos_5p04310591302056_3v64x8m81_1/D
+ vdd vdd nmos_5p04310591302056_3v64x8m81_1/D pmos_1p2$$47109164_3v64x8m81
Xnmos_1p2$$47342636_3v64x8m81_0 xpredec1_bot_3v64x8m81_2/alatch_3v64x8m81_0/enb vss
+ nmos_5p04310591302056_3v64x8m81_1/D vss nmos_1p2$$47342636_3v64x8m81
Xxpredec1_bot_3v64x8m81_0 xpredec1_bot_3v64x8m81_0/pmos_1p2$$47337516_3v64x8m81_0/pmos_5p04310591302070_3v64x8m81_0/D
+ xpredec1_bot_3v64x8m81_0/pmos_1p2$$47337516_3v64x8m81_0/pmos_5p04310591302070_3v64x8m81_0/D
+ xpredec1_bot_3v64x8m81_0/pmos_1p2$$47337516_3v64x8m81_1/pmos_5p04310591302070_3v64x8m81_0/D
+ xpredec1_bot_3v64x8m81_1/pmos_1p2$$47337516_3v64x8m81_1/pmos_5p04310591302070_3v64x8m81_0/D
+ xpredec1_bot_3v64x8m81_2/alatch_3v64x8m81_0/enb xpredec1_bot_3v64x8m81_0/pmos_1p2$$47337516_3v64x8m81_1/pmos_5p04310591302070_3v64x8m81_0/D
+ xpredec1_bot_3v64x8m81_2/alatch_3v64x8m81_0/vdd xpredec1_bot_3v64x8m81_2/pmos_1p2$$47337516_3v64x8m81_1/pmos_5p04310591302070_3v64x8m81_0/D
+ A[0] xpredec1_bot_3v64x8m81_1/pmos_1p2$$47337516_3v64x8m81_0/pmos_5p04310591302070_3v64x8m81_0/D
+ vdd_uq0 nmos_5p04310591302056_3v64x8m81_1/D xpredec1_bot_3v64x8m81_2/pmos_1p2$$47337516_3v64x8m81_0/pmos_5p04310591302070_3v64x8m81_0/D
+ vss xpredec1_bot_3v64x8m81
Xxpredec1_bot_3v64x8m81_1 xpredec1_bot_3v64x8m81_0/pmos_1p2$$47337516_3v64x8m81_0/pmos_5p04310591302070_3v64x8m81_0/D
+ xpredec1_bot_3v64x8m81_1/pmos_1p2$$47337516_3v64x8m81_0/pmos_5p04310591302070_3v64x8m81_0/D
+ xpredec1_bot_3v64x8m81_1/pmos_1p2$$47337516_3v64x8m81_1/pmos_5p04310591302070_3v64x8m81_0/D
+ xpredec1_bot_3v64x8m81_1/pmos_1p2$$47337516_3v64x8m81_1/pmos_5p04310591302070_3v64x8m81_0/D
+ xpredec1_bot_3v64x8m81_2/alatch_3v64x8m81_0/enb xpredec1_bot_3v64x8m81_0/pmos_1p2$$47337516_3v64x8m81_1/pmos_5p04310591302070_3v64x8m81_0/D
+ xpredec1_bot_3v64x8m81_2/alatch_3v64x8m81_0/vdd xpredec1_bot_3v64x8m81_2/pmos_1p2$$47337516_3v64x8m81_1/pmos_5p04310591302070_3v64x8m81_0/D
+ A[2] xpredec1_bot_3v64x8m81_1/pmos_1p2$$47337516_3v64x8m81_0/pmos_5p04310591302070_3v64x8m81_0/D
+ vdd_uq0 nmos_5p04310591302056_3v64x8m81_1/D xpredec1_bot_3v64x8m81_2/pmos_1p2$$47337516_3v64x8m81_0/pmos_5p04310591302070_3v64x8m81_0/D
+ vss xpredec1_bot_3v64x8m81
X0 a_5287_6723# men vdd w_5024_6624# pfet_03v3 ad=0.212p pd=1.46u as=0.5936p ps=3.24u w=1.06u l=0.28u
X1 a_5600_6723# clk nmos_5p04310591302056_3v64x8m81_1/D w_5024_6624# pfet_03v3 ad=0.19345p pd=1.425u as=0.32065p ps=1.665u w=1.06u l=0.28u
X2 nmos_5p04310591302056_3v64x8m81_1/D clk a_5287_6723# w_5024_6624# pfet_03v3 ad=0.32065p pd=1.665u as=0.212p ps=1.46u w=1.06u l=0.28u
X3 vdd men a_5600_6723# w_5024_6624# pfet_03v3 ad=0.5883p pd=3.23u as=0.19345p ps=1.425u w=1.06u l=0.28u
.ends

.subckt pmos_5p04310591302067_3v64x8m81 D a_0_n44# w_n174_n86# S
X0 D a_0_n44# S w_n174_n86# pfet_03v3 ad=3.1196p pd=15.06u as=3.1196p ps=15.06u w=7.09u l=0.28u
.ends

.subckt pmos_1p2$$47642668_3v64x8m81 pmos_5p04310591302067_3v64x8m81_0/D a_n14_n34#
+ w_n194_n66# pmos_5p04310591302067_3v64x8m81_0/S
Xpmos_5p04310591302067_3v64x8m81_0 pmos_5p04310591302067_3v64x8m81_0/D a_n14_n34#
+ w_n194_n66# pmos_5p04310591302067_3v64x8m81_0/S pmos_5p04310591302067_3v64x8m81
.ends

.subckt pmos_1p2$$47643692_3v64x8m81 w_n133_n66# pmos_5p04310591302067_3v64x8m81_0/D
+ a_n14_n34# pmos_5p04310591302067_3v64x8m81_0/S
Xpmos_5p04310591302067_3v64x8m81_0 pmos_5p04310591302067_3v64x8m81_0/D a_n14_n34#
+ w_n133_n66# pmos_5p04310591302067_3v64x8m81_0/S pmos_5p04310591302067_3v64x8m81
.ends

.subckt nmos_1p2$$47641644_3v64x8m81 nmos_5p04310591302057_3v64x8m81_0/S a_n14_n34#
+ nmos_5p04310591302057_3v64x8m81_0/D VSUBS
Xnmos_5p04310591302057_3v64x8m81_0 nmos_5p04310591302057_3v64x8m81_0/D a_n14_n34#
+ nmos_5p04310591302057_3v64x8m81_0/S VSUBS nmos_5p04310591302057_3v64x8m81
.ends

.subckt xpredec0_xa_3v64x8m81 m3_107_5938# m1_255_3759# a_612_1974# m1_255_3263# m1_255_3619#
+ pmos_1p2$$47643692_3v64x8m81_0/pmos_5p04310591302067_3v64x8m81_0/D m1_255_3901#
+ m3_598_2319# a_472_3898# M3_M2$$47644716_3v64x8m81_2/VSUBS nmos_1p2$$47641644_3v64x8m81_3/nmos_5p04310591302057_3v64x8m81_0/D
+ pmos_1p2$$47513644_3v64x8m81_3/pmos_5p04310591302068_3v64x8m81_0/D pmos_1p2$$47513644_3v64x8m81_3/pmos_5p04310591302068_3v64x8m81_0/S
Xpmos_1p2$$47642668_3v64x8m81_0 pmos_1p2$$47643692_3v64x8m81_0/pmos_5p04310591302067_3v64x8m81_0/S
+ a_612_1974# pmos_1p2$$47643692_3v64x8m81_0/pmos_5p04310591302067_3v64x8m81_0/D pmos_1p2$$47643692_3v64x8m81_0/pmos_5p04310591302067_3v64x8m81_0/D
+ pmos_1p2$$47642668_3v64x8m81
Xpmos_1p2$$47513644_3v64x8m81_0 pmos_1p2$$47513644_3v64x8m81_3/pmos_5p04310591302068_3v64x8m81_0/S
+ pmos_1p2$$47643692_3v64x8m81_0/pmos_5p04310591302067_3v64x8m81_0/S pmos_1p2$$47643692_3v64x8m81_0/pmos_5p04310591302067_3v64x8m81_0/D
+ pmos_1p2$$47513644_3v64x8m81_3/pmos_5p04310591302068_3v64x8m81_0/D pmos_1p2$$47513644_3v64x8m81
Xpmos_1p2$$47513644_3v64x8m81_1 pmos_1p2$$47513644_3v64x8m81_3/pmos_5p04310591302068_3v64x8m81_0/D
+ pmos_1p2$$47643692_3v64x8m81_0/pmos_5p04310591302067_3v64x8m81_0/S pmos_1p2$$47643692_3v64x8m81_0/pmos_5p04310591302067_3v64x8m81_0/D
+ pmos_1p2$$47513644_3v64x8m81_3/pmos_5p04310591302068_3v64x8m81_0/S pmos_1p2$$47513644_3v64x8m81
Xpmos_1p2$$47513644_3v64x8m81_2 pmos_1p2$$47513644_3v64x8m81_3/pmos_5p04310591302068_3v64x8m81_0/S
+ pmos_1p2$$47643692_3v64x8m81_0/pmos_5p04310591302067_3v64x8m81_0/S pmos_1p2$$47643692_3v64x8m81_0/pmos_5p04310591302067_3v64x8m81_0/D
+ pmos_1p2$$47513644_3v64x8m81_3/pmos_5p04310591302068_3v64x8m81_0/D pmos_1p2$$47513644_3v64x8m81
Xpmos_1p2$$47643692_3v64x8m81_0 pmos_1p2$$47643692_3v64x8m81_0/pmos_5p04310591302067_3v64x8m81_0/D
+ pmos_1p2$$47643692_3v64x8m81_0/pmos_5p04310591302067_3v64x8m81_0/D a_472_3898# pmos_1p2$$47643692_3v64x8m81_0/pmos_5p04310591302067_3v64x8m81_0/S
+ pmos_1p2$$47643692_3v64x8m81
Xnmos_1p2$$47641644_3v64x8m81_0 nmos_1p2$$47641644_3v64x8m81_3/nmos_5p04310591302057_3v64x8m81_0/D
+ pmos_1p2$$47643692_3v64x8m81_0/pmos_5p04310591302067_3v64x8m81_0/S pmos_1p2$$47513644_3v64x8m81_3/pmos_5p04310591302068_3v64x8m81_0/D
+ M3_M2$$47644716_3v64x8m81_2/VSUBS nmos_1p2$$47641644_3v64x8m81
Xpmos_1p2$$47513644_3v64x8m81_3 pmos_1p2$$47513644_3v64x8m81_3/pmos_5p04310591302068_3v64x8m81_0/D
+ pmos_1p2$$47643692_3v64x8m81_0/pmos_5p04310591302067_3v64x8m81_0/S pmos_1p2$$47643692_3v64x8m81_0/pmos_5p04310591302067_3v64x8m81_0/D
+ pmos_1p2$$47513644_3v64x8m81_3/pmos_5p04310591302068_3v64x8m81_0/S pmos_1p2$$47513644_3v64x8m81
Xnmos_1p2$$47641644_3v64x8m81_1 nmos_1p2$$47641644_3v64x8m81_3/nmos_5p04310591302057_3v64x8m81_0/D
+ pmos_1p2$$47643692_3v64x8m81_0/pmos_5p04310591302067_3v64x8m81_0/S pmos_1p2$$47513644_3v64x8m81_3/pmos_5p04310591302068_3v64x8m81_0/D
+ M3_M2$$47644716_3v64x8m81_2/VSUBS nmos_1p2$$47641644_3v64x8m81
Xnmos_1p2$$47641644_3v64x8m81_2 pmos_1p2$$47513644_3v64x8m81_3/pmos_5p04310591302068_3v64x8m81_0/D
+ pmos_1p2$$47643692_3v64x8m81_0/pmos_5p04310591302067_3v64x8m81_0/S nmos_1p2$$47641644_3v64x8m81_3/nmos_5p04310591302057_3v64x8m81_0/D
+ M3_M2$$47644716_3v64x8m81_2/VSUBS nmos_1p2$$47641644_3v64x8m81
Xnmos_1p2$$47641644_3v64x8m81_3 pmos_1p2$$47513644_3v64x8m81_3/pmos_5p04310591302068_3v64x8m81_0/D
+ pmos_1p2$$47643692_3v64x8m81_0/pmos_5p04310591302067_3v64x8m81_0/S nmos_1p2$$47641644_3v64x8m81_3/nmos_5p04310591302057_3v64x8m81_0/D
+ M3_M2$$47644716_3v64x8m81_2/VSUBS nmos_1p2$$47641644_3v64x8m81
X0 M3_M2$$47644716_3v64x8m81_2/VSUBS a_612_1974# a_539_2025# M3_M2$$47644716_3v64x8m81_2/VSUBS nfet_03v3 ad=3.1746p pd=12.55u as=1.0439p ps=6.085u w=5.72u l=0.28u
X1 a_539_2025# a_472_3898# pmos_1p2$$47643692_3v64x8m81_0/pmos_5p04310591302067_3v64x8m81_0/S M3_M2$$47644716_3v64x8m81_2/VSUBS nfet_03v3 ad=1.0439p pd=6.085u as=3.146p ps=12.54u w=5.72u l=0.28u
.ends

.subckt pmos_5p04310591302069_3v64x8m81 D a_n28_n44# a_132_n44# w_n202_n86# S_uq0
+ S
X0 D a_n28_n44# S w_n202_n86# pfet_03v3 ad=0.1378p pd=1.05u as=0.2332p ps=1.94u w=0.53u l=0.28u
X1 S_uq0 a_132_n44# D w_n202_n86# pfet_03v3 ad=0.2332p pd=1.94u as=0.1378p ps=1.05u w=0.53u l=0.28u
.ends

.subckt nmos_5p04310591302066_3v64x8m81 D a_0_n44# S VSUBS
X0 D a_0_n44# S VSUBS nfet_03v3 ad=1.4454p pd=7.45u as=1.4454p ps=7.45u w=3.285u l=0.28u
.ends

.subckt nmos_5p04310591302065_3v64x8m81 D a_0_n44# S VSUBS
X0 D a_0_n44# S VSUBS nfet_03v3 ad=1.0714p pd=5.75u as=1.0714p ps=5.75u w=2.435u l=0.28u
.ends

.subckt nmos_1p2$$47502380_3v64x8m81 nmos_5p04310591302065_3v64x8m81_0/S nmos_5p04310591302065_3v64x8m81_0/D
+ a_n14_n34# VSUBS
Xnmos_5p04310591302065_3v64x8m81_0 nmos_5p04310591302065_3v64x8m81_0/D a_n14_n34#
+ nmos_5p04310591302065_3v64x8m81_0/S VSUBS nmos_5p04310591302065_3v64x8m81
.ends

.subckt pmos_5p04310591302064_3v64x8m81 D a_0_n44# w_n174_n86# S
X0 D a_0_n44# S w_n174_n86# pfet_03v3 ad=3.6322p pd=17.39u as=3.6322p ps=17.39u w=8.255u l=0.28u
.ends

.subckt pmos_1p2$$47503404_3v64x8m81 a_n14_n34# pmos_5p04310591302064_3v64x8m81_0/S
+ pmos_5p04310591302064_3v64x8m81_0/D w_n133_n65#
Xpmos_5p04310591302064_3v64x8m81_0 pmos_5p04310591302064_3v64x8m81_0/D a_n14_n34#
+ w_n133_n65# pmos_5p04310591302064_3v64x8m81_0/S pmos_5p04310591302064_3v64x8m81
.ends

.subckt pmos_5p04310591302063_3v64x8m81 D a_0_n44# w_n174_n86# S
X0 D a_0_n44# S w_n174_n86# pfet_03v3 ad=2.7016p pd=13.16u as=2.7016p ps=13.16u w=6.14u l=0.28u
.ends

.subckt pmos_1p2$$47504428_3v64x8m81 pmos_5p04310591302063_3v64x8m81_0/S w_n133_n66#
+ a_n14_n34# pmos_5p04310591302063_3v64x8m81_0/D
Xpmos_5p04310591302063_3v64x8m81_0 pmos_5p04310591302063_3v64x8m81_0/D a_n14_n34#
+ w_n133_n66# pmos_5p04310591302063_3v64x8m81_0/S pmos_5p04310591302063_3v64x8m81
.ends

.subckt xpredec0_bot_3v64x8m81 nmos_1p2$$47502380_3v64x8m81_0/nmos_5p04310591302065_3v64x8m81_0/S
+ pmos_1p2$$47504428_3v64x8m81_0/pmos_5p04310591302063_3v64x8m81_0/S m1_n74_3354#
+ m1_n74_3071# pmos_1p2$$47504428_3v64x8m81_0/pmos_5p04310591302063_3v64x8m81_0/D
+ m1_n74_3213# alatch_3v64x8m81_0/vdd alatch_3v64x8m81_0/a nmos_5p04310591302066_3v64x8m81_0/D
+ m1_n74_2930# alatch_3v64x8m81_0/en alatch_3v64x8m81_0/enb pmos_1p2$$47503404_3v64x8m81_0/pmos_5p04310591302064_3v64x8m81_0/S
+ VSUBS
Xnmos_5p04310591302066_3v64x8m81_0 nmos_5p04310591302066_3v64x8m81_0/D alatch_3v64x8m81_0/ab
+ VSUBS VSUBS nmos_5p04310591302066_3v64x8m81
Xnmos_1p2$$47502380_3v64x8m81_0 nmos_1p2$$47502380_3v64x8m81_0/nmos_5p04310591302065_3v64x8m81_0/S
+ pmos_1p2$$47504428_3v64x8m81_0/pmos_5p04310591302063_3v64x8m81_0/D nmos_5p04310591302066_3v64x8m81_0/D
+ VSUBS nmos_1p2$$47502380_3v64x8m81
Xpmos_1p2$$47503404_3v64x8m81_0 alatch_3v64x8m81_0/ab pmos_1p2$$47503404_3v64x8m81_0/pmos_5p04310591302064_3v64x8m81_0/S
+ nmos_5p04310591302066_3v64x8m81_0/D pmos_1p2$$47503404_3v64x8m81_0/pmos_5p04310591302064_3v64x8m81_0/S
+ pmos_1p2$$47503404_3v64x8m81
Xpmos_1p2$$47504428_3v64x8m81_0 pmos_1p2$$47504428_3v64x8m81_0/pmos_5p04310591302063_3v64x8m81_0/S
+ pmos_1p2$$47503404_3v64x8m81_0/pmos_5p04310591302064_3v64x8m81_0/S nmos_5p04310591302066_3v64x8m81_0/D
+ pmos_1p2$$47504428_3v64x8m81_0/pmos_5p04310591302063_3v64x8m81_0/D pmos_1p2$$47504428_3v64x8m81
Xalatch_3v64x8m81_0 alatch_3v64x8m81_0/enb alatch_3v64x8m81_0/en alatch_3v64x8m81_0/ab
+ alatch_3v64x8m81_0/a alatch_3v64x8m81_0/vdd VSUBS alatch_3v64x8m81
.ends

.subckt nmos_5p04310591302040_3v64x8m81 D a_0_n44# S VSUBS
X0 D a_0_n44# S VSUBS nfet_03v3 ad=0.2794p pd=2.15u as=0.2794p ps=2.15u w=0.635u l=0.28u
.ends

.subckt xpredec0_3v64x8m81 vss x[0] x[1] x[2] x[3] clk vss_uq0 vdd_uq0 men A[1] vdd
+ vdd_uq2 VSUBS A[0]
Xxpredec0_xa_3v64x8m81_0 VSUBS xpredec0_bot_3v64x8m81_1/pmos_1p2$$47504428_3v64x8m81_0/pmos_5p04310591302063_3v64x8m81_0/D
+ xpredec0_bot_3v64x8m81_0/pmos_1p2$$47504428_3v64x8m81_0/pmos_5p04310591302063_3v64x8m81_0/D
+ xpredec0_bot_3v64x8m81_0/pmos_1p2$$47504428_3v64x8m81_0/pmos_5p04310591302063_3v64x8m81_0/D
+ xpredec0_bot_3v64x8m81_0/nmos_5p04310591302066_3v64x8m81_0/D vdd_uq2 xpredec0_bot_3v64x8m81_1/nmos_5p04310591302066_3v64x8m81_0/D
+ vdd xpredec0_bot_3v64x8m81_1/pmos_1p2$$47504428_3v64x8m81_0/pmos_5p04310591302063_3v64x8m81_0/D
+ VSUBS VSUBS x[0] vdd_uq2 xpredec0_xa_3v64x8m81
Xxpredec0_xa_3v64x8m81_1 VSUBS xpredec0_bot_3v64x8m81_1/pmos_1p2$$47504428_3v64x8m81_0/pmos_5p04310591302063_3v64x8m81_0/D
+ xpredec0_bot_3v64x8m81_0/pmos_1p2$$47504428_3v64x8m81_0/pmos_5p04310591302063_3v64x8m81_0/D
+ xpredec0_bot_3v64x8m81_0/pmos_1p2$$47504428_3v64x8m81_0/pmos_5p04310591302063_3v64x8m81_0/D
+ xpredec0_bot_3v64x8m81_0/nmos_5p04310591302066_3v64x8m81_0/D vdd_uq2 xpredec0_bot_3v64x8m81_1/nmos_5p04310591302066_3v64x8m81_0/D
+ vdd xpredec0_bot_3v64x8m81_1/nmos_5p04310591302066_3v64x8m81_0/D VSUBS VSUBS x[2]
+ vdd_uq2 xpredec0_xa_3v64x8m81
Xnmos_1p2$$46563372_3v64x8m81_0 pmos_5p04310591302069_3v64x8m81_0/D nmos_5p04310591302040_3v64x8m81_1/S
+ VSUBS VSUBS nmos_1p2$$46563372_3v64x8m81
Xxpredec0_xa_3v64x8m81_2 VSUBS xpredec0_bot_3v64x8m81_1/pmos_1p2$$47504428_3v64x8m81_0/pmos_5p04310591302063_3v64x8m81_0/D
+ xpredec0_bot_3v64x8m81_0/nmos_5p04310591302066_3v64x8m81_0/D xpredec0_bot_3v64x8m81_0/pmos_1p2$$47504428_3v64x8m81_0/pmos_5p04310591302063_3v64x8m81_0/D
+ xpredec0_bot_3v64x8m81_0/nmos_5p04310591302066_3v64x8m81_0/D vdd_uq2 xpredec0_bot_3v64x8m81_1/nmos_5p04310591302066_3v64x8m81_0/D
+ vdd xpredec0_bot_3v64x8m81_1/pmos_1p2$$47504428_3v64x8m81_0/pmos_5p04310591302063_3v64x8m81_0/D
+ VSUBS VSUBS x[1] vdd_uq2 xpredec0_xa_3v64x8m81
Xxpredec0_xa_3v64x8m81_3 VSUBS xpredec0_bot_3v64x8m81_1/pmos_1p2$$47504428_3v64x8m81_0/pmos_5p04310591302063_3v64x8m81_0/D
+ xpredec0_bot_3v64x8m81_0/nmos_5p04310591302066_3v64x8m81_0/D xpredec0_bot_3v64x8m81_0/pmos_1p2$$47504428_3v64x8m81_0/pmos_5p04310591302063_3v64x8m81_0/D
+ xpredec0_bot_3v64x8m81_0/nmos_5p04310591302066_3v64x8m81_0/D vdd_uq2 xpredec0_bot_3v64x8m81_1/nmos_5p04310591302066_3v64x8m81_0/D
+ vdd xpredec0_bot_3v64x8m81_1/nmos_5p04310591302066_3v64x8m81_0/D VSUBS VSUBS x[3]
+ vdd_uq2 xpredec0_xa_3v64x8m81
Xpmos_5p04310591302069_3v64x8m81_0 pmos_5p04310591302069_3v64x8m81_0/D nmos_5p04310591302040_3v64x8m81_1/S
+ nmos_5p04310591302040_3v64x8m81_1/S vdd_uq2 vdd_uq2 vdd_uq2 pmos_5p04310591302069_3v64x8m81
Xxpredec0_bot_3v64x8m81_0 VSUBS vdd_uq2 xpredec0_bot_3v64x8m81_1/nmos_5p04310591302066_3v64x8m81_0/D
+ xpredec0_bot_3v64x8m81_0/nmos_5p04310591302066_3v64x8m81_0/D xpredec0_bot_3v64x8m81_0/pmos_1p2$$47504428_3v64x8m81_0/pmos_5p04310591302063_3v64x8m81_0/D
+ xpredec0_bot_3v64x8m81_1/pmos_1p2$$47504428_3v64x8m81_0/pmos_5p04310591302063_3v64x8m81_0/D
+ vdd A[0] xpredec0_bot_3v64x8m81_0/nmos_5p04310591302066_3v64x8m81_0/D xpredec0_bot_3v64x8m81_0/pmos_1p2$$47504428_3v64x8m81_0/pmos_5p04310591302063_3v64x8m81_0/D
+ nmos_5p04310591302040_3v64x8m81_1/S pmos_5p04310591302069_3v64x8m81_0/D vdd_uq2
+ VSUBS xpredec0_bot_3v64x8m81
Xxpredec0_bot_3v64x8m81_1 VSUBS vdd_uq2 xpredec0_bot_3v64x8m81_1/nmos_5p04310591302066_3v64x8m81_0/D
+ xpredec0_bot_3v64x8m81_0/nmos_5p04310591302066_3v64x8m81_0/D xpredec0_bot_3v64x8m81_1/pmos_1p2$$47504428_3v64x8m81_0/pmos_5p04310591302063_3v64x8m81_0/D
+ xpredec0_bot_3v64x8m81_1/pmos_1p2$$47504428_3v64x8m81_0/pmos_5p04310591302063_3v64x8m81_0/D
+ vdd A[1] xpredec0_bot_3v64x8m81_1/nmos_5p04310591302066_3v64x8m81_0/D xpredec0_bot_3v64x8m81_0/pmos_1p2$$47504428_3v64x8m81_0/pmos_5p04310591302063_3v64x8m81_0/D
+ nmos_5p04310591302040_3v64x8m81_1/S pmos_5p04310591302069_3v64x8m81_0/D vdd_uq2
+ VSUBS xpredec0_bot_3v64x8m81
Xnmos_5p04310591302040_3v64x8m81_0 nmos_5p04310591302040_3v64x8m81_1/S men VSUBS VSUBS
+ nmos_5p04310591302040_3v64x8m81
Xnmos_5p04310591302040_3v64x8m81_1 VSUBS clk nmos_5p04310591302040_3v64x8m81_1/S VSUBS
+ nmos_5p04310591302040_3v64x8m81
X0 vdd_uq2 men a_3416_6773# vdd_uq2 pfet_03v3 ad=0.448p pd=2.72u as=0.162p ps=1.205u w=0.8u l=0.28u
X1 nmos_5p04310591302040_3v64x8m81_1/S clk a_3091_6773# vdd_uq2 pfet_03v3 ad=0.218p pd=1.345u as=0.208p ps=1.32u w=0.8u l=0.28u
X2 a_3091_6773# men vdd_uq2 vdd_uq2 pfet_03v3 ad=0.208p pd=1.32u as=0.364p ps=2.51u w=0.8u l=0.28u
X3 a_3416_6773# clk nmos_5p04310591302040_3v64x8m81_1/S vdd_uq2 pfet_03v3 ad=0.162p pd=1.205u as=0.218p ps=1.345u w=0.8u l=0.28u
.ends

.subckt prexdec_top_3v64x8m81 A[2] A[6] xb[3] xc[2] xc[3] xb[1] xb[2] xb[0] A[3] xa[0]
+ xa[1] xpredec1_3v64x8m81_0/pmos_1p2$$47109164_3v64x8m81_0/pmos_5p04310591302062_3v64x8m81_0/w_n202_n86#
+ xa[2] xa[3] xa[4] xa[5] xa[6] xpredec1_3v64x8m81_0/clk xa[7] A[4] A[0] A[1] A[5]
+ xpredec1_3v64x8m81_0/vdd men xpredec1_3v64x8m81_0/w_5024_6624# xpredec0_3v64x8m81_1/vdd
+ xpredec0_3v64x8m81_1/clk xc[0] xc[1] VSUBS
Xxpredec1_3v64x8m81_0 xpredec1_3v64x8m81_0/vdd men xa[7] xa[6] xa[5] xa[4] xa[2] xa[1]
+ xa[0] xpredec1_3v64x8m81_0/clk xpredec1_3v64x8m81_0/vdd xpredec1_3v64x8m81_0/w_5024_6624#
+ xpredec1_3v64x8m81_0/pmos_1p2$$47109164_3v64x8m81_0/pmos_5p04310591302062_3v64x8m81_0/w_n202_n86#
+ xpredec0_3v64x8m81_1/vdd A[2] xpredec0_3v64x8m81_1/vdd A[1] A[0] VSUBS xa[3] xpredec1_3v64x8m81
Xxpredec0_3v64x8m81_0 VSUBS xb[0] xb[1] xb[2] xb[3] xpredec0_3v64x8m81_1/clk VSUBS
+ xpredec0_3v64x8m81_1/vdd men A[4] xpredec0_3v64x8m81_1/vdd xpredec1_3v64x8m81_0/vdd
+ VSUBS A[3] xpredec0_3v64x8m81
Xxpredec0_3v64x8m81_1 VSUBS xc[0] xc[1] xc[2] xc[3] xpredec0_3v64x8m81_1/clk VSUBS
+ xpredec0_3v64x8m81_1/vdd men A[6] xpredec0_3v64x8m81_1/vdd xpredec1_3v64x8m81_0/vdd
+ VSUBS A[5] xpredec0_3v64x8m81
.ends

.subckt control_3v64x8_3v64x8m81 RYS[7] RYS[6] RYS[5] RYS[4] RYS[3] RYS[2] RYS[1]
+ RYS[0] LYS[0] LYS[1] LYS[2] LYS[3] LYS[6] LYS[5] LYS[4] LYS[7] tblhl IGWEN xb[3]
+ xb[2] xb[0] A[0] xb[1] xc[3] xc[1] xc[2] xc[0] A[9] A[7] CLK A[2] A[1] A[6] A[3]
+ A[4] A[5] A[8] GWEN VDD_uq2 CEN VDD_uq1 men gen_3v64x8_3v64x8m81_0/VDD_uq2 xa[3]
+ xa[4] xa[5] xa[6] GWE xa[7] xa[0] prexdec_top_3v64x8m81_0/xpredec0_3v64x8m81_1/vdd
+ xa[1] VDD VDD_uq3 xa[2] VSS VDD_uq5
Xypredec1_3v64x8m81_0 LYS[5] LYS[4] LYS[7] LYS[3] LYS[2] LYS[1] LYS[0] RYS[0] RYS[1]
+ RYS[2] RYS[3] RYS[4] RYS[5] RYS[6] RYS[7] LYS[6] men A[0] A[1] A[2] CLK VDD_uq1
+ VDD_uq1 VDD_uq2 VSS VDD_uq3 VDD ypredec1_3v64x8m81
Xgen_3v64x8_3v64x8m81_0 VSS tblhl IGWEN CEN CLK gen_3v64x8_3v64x8m81_0/WEN GWE GWEN
+ VDD gen_3v64x8_3v64x8m81_0/pmos_5p04310591302088_3v64x8m81_0/D men VDD_uq1 gen_3v64x8_3v64x8m81_0/VDD_uq2
+ gen_3v64x8_3v64x8m81
Xprexdec_top_3v64x8m81_0 A[5] A[9] xb[3] xc[2] xc[3] xb[1] xb[2] xb[0] A[6] xa[0]
+ xa[1] VDD_uq5 xa[2] xa[3] xa[4] xa[5] xa[6] CLK xa[7] A[7] A[3] A[4] A[8] VDD_uq5
+ men VDD_uq5 prexdec_top_3v64x8m81_0/xpredec0_3v64x8m81_1/vdd CLK xc[0] xc[1] VSS
+ prexdec_top_3v64x8m81
.ends

.subckt nmos_5p0431059130207_3v64x8m81 D a_0_n44# S VSUBS
X0 D a_0_n44# S VSUBS nfet_03v3 ad=2.794p pd=13.58u as=2.794p ps=13.58u w=6.35u l=0.28u
.ends

.subckt nmos_1p2$$46884908_3v64x8m81 nmos_5p0431059130207_3v64x8m81_0/S nmos_5p0431059130207_3v64x8m81_0/D
+ a_n14_n34# VSUBS
Xnmos_5p0431059130207_3v64x8m81_0 nmos_5p0431059130207_3v64x8m81_0/D a_n14_n34# nmos_5p0431059130207_3v64x8m81_0/S
+ VSUBS nmos_5p0431059130207_3v64x8m81
.ends

.subckt nmos_5p04310591302011_3v64x8m81 D a_n28_n44# a_132_n44# S_uq0 S VSUBS
X0 D a_n28_n44# S VSUBS nfet_03v3 ad=0.1157p pd=0.965u as=0.1958p ps=1.77u w=0.445u l=0.28u
X1 S_uq0 a_132_n44# D VSUBS nfet_03v3 ad=0.1958p pd=1.77u as=0.1157p ps=0.965u w=0.445u l=0.28u
.ends

.subckt nmos_5p0431059130205_3v64x8m81 D a_0_n44# S VSUBS
X0 D a_0_n44# S VSUBS nfet_03v3 ad=2.3276p pd=11.46u as=2.3276p ps=11.46u w=5.29u l=0.28u
.ends

.subckt nmos_1p2$$46883884_3v64x8m81 nmos_5p0431059130205_3v64x8m81_0/S a_n14_n34#
+ nmos_5p0431059130205_3v64x8m81_0/D VSUBS
Xnmos_5p0431059130205_3v64x8m81_0 nmos_5p0431059130205_3v64x8m81_0/D a_n14_n34# nmos_5p0431059130205_3v64x8m81_0/S
+ VSUBS nmos_5p0431059130205_3v64x8m81
.ends

.subckt pmos_5p0431059130209_3v64x8m81 D a_0_n44# w_n174_n86# S
X0 D a_0_n44# S w_n174_n86# pfet_03v3 ad=2.3276p pd=11.46u as=2.3276p ps=11.46u w=5.29u l=0.28u
.ends

.subckt pmos_5p0431059130206_3v64x8m81 D a_n28_n44# a_132_n44# w_n202_n86# S_uq0 S
X0 D a_n28_n44# S w_n202_n86# pfet_03v3 ad=0.1157p pd=0.965u as=0.1958p ps=1.77u w=0.445u l=0.28u
X1 S_uq0 a_132_n44# D w_n202_n86# pfet_03v3 ad=0.1958p pd=1.77u as=0.1157p ps=0.965u w=0.445u l=0.28u
.ends

.subckt pmos_5p0431059130201_3v64x8m81 D a_0_n44# w_n174_n86# S
X0 D a_0_n44# S w_n174_n86# pfet_03v3 ad=1.397p pd=7.23u as=1.397p ps=7.23u w=3.175u l=0.28u
.ends

.subckt pmos_1p2$$46889004_3v64x8m81 pmos_5p0431059130201_3v64x8m81_0/S a_n14_n34#
+ pmos_5p0431059130201_3v64x8m81_0/D w_n133_n66#
Xpmos_5p0431059130201_3v64x8m81_0 pmos_5p0431059130201_3v64x8m81_0/D a_n14_n34# w_n133_n66#
+ pmos_5p0431059130201_3v64x8m81_0/S pmos_5p0431059130201_3v64x8m81
.ends

.subckt pmos_1p2$$46885932_3v64x8m81 pmos_5p0431059130206_3v64x8m81_0/S_uq0 pmos_5p0431059130206_3v64x8m81_0/S
+ a_118_89# pmos_5p0431059130206_3v64x8m81_0/D a_n42_89# w_n133_n65#
Xpmos_5p0431059130206_3v64x8m81_0 pmos_5p0431059130206_3v64x8m81_0/D a_n42_89# a_118_89#
+ w_n133_n65# pmos_5p0431059130206_3v64x8m81_0/S_uq0 pmos_5p0431059130206_3v64x8m81_0/S
+ pmos_5p0431059130206_3v64x8m81
.ends

.subckt din_3v64x8m81 vss datain men vdd_uq0 db d vdd wep m1_114_5647# VSUBS
Xnmos_1p2$$46884908_3v64x8m81_0 VSUBS pmos_1p2$$46889004_3v64x8m81_0/pmos_5p0431059130201_3v64x8m81_0/D
+ pmos_5p0431059130201_3v64x8m81_0/S VSUBS nmos_1p2$$46884908_3v64x8m81
Xnmos_5p04310591302011_3v64x8m81_0 VSUBS datain pmos_5p0431059130206_3v64x8m81_0/S
+ nmos_5p04310591302011_3v64x8m81_1/S pmos_5p0431059130206_3v64x8m81_0/S VSUBS nmos_5p04310591302011_3v64x8m81
Xnmos_5p04310591302010_3v64x8m81_0 VSUBS nmos_5p04310591302011_3v64x8m81_1/D pmos_5p0431059130201_3v64x8m81_0/S
+ VSUBS nmos_5p04310591302010_3v64x8m81
Xnmos_5p04310591302011_3v64x8m81_1 nmos_5p04310591302011_3v64x8m81_1/D pmos_1p2$$46273580_3v64x8m81_0/pmos_5p0431059130203_3v64x8m81_0/D
+ men nmos_5p04310591302011_3v64x8m81_1/S_uq0 nmos_5p04310591302011_3v64x8m81_1/S
+ VSUBS nmos_5p04310591302011_3v64x8m81
Xnmos_1p2$$46883884_3v64x8m81_0 db wep pmos_5p0431059130209_3v64x8m81_0/S VSUBS nmos_1p2$$46883884_3v64x8m81
Xnmos_1p2$$46883884_3v64x8m81_1 pmos_5p0431059130209_3v64x8m81_0/S pmos_1p2$$46889004_3v64x8m81_0/pmos_5p0431059130201_3v64x8m81_0/D
+ VSUBS VSUBS nmos_1p2$$46883884_3v64x8m81
Xpmos_1p2$$46273580_3v64x8m81_0 vdd_uq0 men vdd_uq0 vdd_uq0 men pmos_1p2$$46273580_3v64x8m81_0/pmos_5p0431059130203_3v64x8m81_0/D
+ pmos_1p2$$46273580_3v64x8m81
Xnmos_1p2$$46883884_3v64x8m81_2 d wep pmos_1p2$$46889004_3v64x8m81_0/pmos_5p0431059130201_3v64x8m81_0/D
+ VSUBS nmos_1p2$$46883884_3v64x8m81
Xpmos_1p2$$46273580_3v64x8m81_1 vdd_uq0 pmos_5p0431059130201_3v64x8m81_0/S vdd_uq0
+ vdd_uq0 pmos_5p0431059130201_3v64x8m81_0/S nmos_5p04310591302011_3v64x8m81_1/S_uq0
+ pmos_1p2$$46273580_3v64x8m81
Xpmos_1p2$$46887980_3v64x8m81_0 vdd pmos_1p2$$46889004_3v64x8m81_0/pmos_5p0431059130201_3v64x8m81_0/D
+ vdd pmos_5p0431059130201_3v64x8m81_0/S pmos_1p2$$46887980_3v64x8m81
Xpmos_5p0431059130209_3v64x8m81_0 vdd pmos_1p2$$46889004_3v64x8m81_0/pmos_5p0431059130201_3v64x8m81_0/D
+ vdd pmos_5p0431059130209_3v64x8m81_0/S pmos_5p0431059130209_3v64x8m81
Xnmos_1p2$$46563372_3v64x8m81_0 VSUBS pmos_5p0431059130201_3v64x8m81_0/S nmos_5p04310591302011_3v64x8m81_1/S_uq0
+ VSUBS nmos_1p2$$46563372_3v64x8m81
Xnmos_1p2$$46563372_3v64x8m81_1 VSUBS men pmos_1p2$$46273580_3v64x8m81_0/pmos_5p0431059130203_3v64x8m81_0/D
+ VSUBS nmos_1p2$$46563372_3v64x8m81
Xpmos_5p0431059130206_3v64x8m81_0 vdd_uq0 datain pmos_5p0431059130206_3v64x8m81_0/S
+ vdd_uq0 nmos_5p04310591302011_3v64x8m81_1/S pmos_5p0431059130206_3v64x8m81_0/S pmos_5p0431059130206_3v64x8m81
Xpmos_1p2$$46889004_3v64x8m81_0 d a_507_5030# pmos_1p2$$46889004_3v64x8m81_0/pmos_5p0431059130201_3v64x8m81_0/D
+ vdd pmos_1p2$$46889004_3v64x8m81
Xpmos_1p2$$46889004_3v64x8m81_1 db a_507_5030# pmos_5p0431059130209_3v64x8m81_0/S
+ vdd pmos_1p2$$46889004_3v64x8m81
Xpmos_5p0431059130201_3v64x8m81_0 vdd_uq0 nmos_5p04310591302011_3v64x8m81_1/D vdd_uq0
+ pmos_5p0431059130201_3v64x8m81_0/S pmos_5p0431059130201_3v64x8m81
Xpmos_1p2$$46885932_3v64x8m81_0 nmos_5p04310591302011_3v64x8m81_1/S_uq0 nmos_5p04310591302011_3v64x8m81_1/S
+ pmos_1p2$$46273580_3v64x8m81_0/pmos_5p0431059130203_3v64x8m81_0/D nmos_5p04310591302011_3v64x8m81_1/D
+ men vdd_uq0 pmos_1p2$$46885932_3v64x8m81
X0 vdd wep a_507_5030# vdd pfet_03v3 ad=0.38572p pd=2.5u as=0.1859p ps=1.23u w=0.695u l=0.28u
X1 a_507_5030# wep vdd vdd pfet_03v3 ad=0.1859p pd=1.23u as=0.38572p ps=2.5u w=0.695u l=0.28u
X2 a_507_5030# wep vss VSUBS nfet_03v3 ad=0.28355p pd=2.13u as=0.3103p ps=2.23u w=0.535u l=0.28u
.ends

.subckt pmos_5p04310591302035_3v64x8m81 D a_n28_n44# a_132_n44# w_n202_n86# S_uq0
+ S
X0 D a_n28_n44# S w_n202_n86# pfet_03v3 ad=0.2067p pd=1.315u as=0.3498p ps=2.47u w=0.795u l=0.28u
X1 S_uq0 a_132_n44# D w_n202_n86# pfet_03v3 ad=0.3498p pd=2.47u as=0.2067p ps=1.315u w=0.795u l=0.28u
.ends

.subckt pmos_1p2$$202584108_3v64x8m81 pmos_5p04310591302014_3v64x8m81_0/S a_n14_n34#
+ pmos_5p04310591302014_3v64x8m81_0/D w_n133_n65#
Xpmos_5p04310591302014_3v64x8m81_0 pmos_5p04310591302014_3v64x8m81_0/D a_n14_n34#
+ w_n133_n65# pmos_5p04310591302014_3v64x8m81_0/S pmos_5p04310591302014_3v64x8m81
.ends

.subckt pmos_5p04310591302043_3v64x8m81 D_uq0 D a_265_n44# S_uq0 S a_n56_n44# a_104_n44#
+ w_n230_n86#
X0 D_uq0 a_265_n44# S_uq0 w_n230_n86# pfet_03v3 ad=0.4092p pd=2.74u as=0.24412p ps=1.455u w=0.93u l=0.28u
X1 D a_n56_n44# S w_n230_n86# pfet_03v3 ad=0.2418p pd=1.45u as=0.4092p ps=2.74u w=0.93u l=0.28u
X2 S_uq0 a_104_n44# D w_n230_n86# pfet_03v3 ad=0.24412p pd=1.455u as=0.2418p ps=1.45u w=0.93u l=0.28u
.ends

.subckt nmos_1p2$$202598444_3v64x8m81 nmos_5p04310591302010_3v64x8m81_0/D a_n14_n34#
+ nmos_5p04310591302010_3v64x8m81_0/S VSUBS
Xnmos_5p04310591302010_3v64x8m81_0 nmos_5p04310591302010_3v64x8m81_0/D a_n14_n34#
+ nmos_5p04310591302010_3v64x8m81_0/S VSUBS nmos_5p04310591302010_3v64x8m81
.ends

.subckt pmos_1p2$$202583084_3v64x8m81 a_n42_n34# pmos_5p04310591302035_3v64x8m81_0/S
+ pmos_5p04310591302035_3v64x8m81_0/S_uq0 pmos_5p04310591302035_3v64x8m81_0/D a_118_n34#
+ w_n133_n66#
Xpmos_5p04310591302035_3v64x8m81_0 pmos_5p04310591302035_3v64x8m81_0/D a_n42_n34#
+ a_118_n34# w_n133_n66# pmos_5p04310591302035_3v64x8m81_0/S_uq0 pmos_5p04310591302035_3v64x8m81_0/S
+ pmos_5p04310591302035_3v64x8m81
.ends

.subckt pmos_1p2$$202585132_3v64x8m81 pmos_5p04310591302014_3v64x8m81_0/S a_n14_n34#
+ pmos_5p04310591302014_3v64x8m81_0/D w_n119_n65#
Xpmos_5p04310591302014_3v64x8m81_0 pmos_5p04310591302014_3v64x8m81_0/D a_n14_n34#
+ w_n119_n65# pmos_5p04310591302014_3v64x8m81_0/S pmos_5p04310591302014_3v64x8m81
.ends

.subckt nmos_1p2$$202594348_3v64x8m81 nmos_5p04310591302040_3v64x8m81_0/D nmos_5p04310591302040_3v64x8m81_0/S
+ a_n14_n44# VSUBS
Xnmos_5p04310591302040_3v64x8m81_0 nmos_5p04310591302040_3v64x8m81_0/D a_n14_n44#
+ nmos_5p04310591302040_3v64x8m81_0/S VSUBS nmos_5p04310591302040_3v64x8m81
.ends

.subckt nmos_5p04310591302042_3v64x8m81 D_uq0 D a_265_n44# S_uq0 S a_n56_n44# a_104_n44#
+ VSUBS
X0 D_uq0 a_265_n44# S_uq0 VSUBS nfet_03v3 ad=0.1628p pd=1.62u as=97.125f ps=0.895u w=0.37u l=0.28u
X1 D a_n56_n44# S VSUBS nfet_03v3 ad=96.2f pd=0.89u as=0.1628p ps=1.62u w=0.37u l=0.28u
X2 S_uq0 a_104_n44# D VSUBS nfet_03v3 ad=97.125f pd=0.895u as=96.2f ps=0.89u w=0.37u l=0.28u
.ends

.subckt wen_wm1_3v64x8m81 GWEN men wep wen vss vdd vdd_uq0
Xpmos_5p04310591302020_3v64x8m81_0 men nmos_1p2$$202596396_3v64x8m81_0/nmos_5p0431059130208_3v64x8m81_0/D
+ nmos_1p2$$202596396_3v64x8m81_0/nmos_5p0431059130208_3v64x8m81_0/D vdd pmos_5p04310591302020_3v64x8m81_0/S
+ pmos_5p04310591302020_3v64x8m81_0/S pmos_5p04310591302020_3v64x8m81
Xpmos_5p04310591302035_3v64x8m81_0 pmos_5p04310591302035_3v64x8m81_0/D pmos_5p04310591302020_3v64x8m81_0/S
+ pmos_5p04310591302020_3v64x8m81_0/S vdd_uq0 vdd_uq0 vdd_uq0 pmos_5p04310591302035_3v64x8m81
Xpmos_1p2$$202584108_3v64x8m81_0 nmos_1p2$$202595372_3v64x8m81_1/nmos_5p0431059130208_3v64x8m81_0/S
+ pmos_5p04310591302041_3v64x8m81_0/S vdd vdd pmos_1p2$$202584108_3v64x8m81
Xnmos_1p2$$202595372_3v64x8m81_0 pmos_5p04310591302041_3v64x8m81_0/S nmos_5p0431059130208_3v64x8m81_3/D
+ pmos_5p04310591302041_3v64x8m81_0/D vss nmos_1p2$$202595372_3v64x8m81
Xpmos_1p2$$202587180_3v64x8m81_0 nmos_5p0431059130208_3v64x8m81_1/D nmos_5p0431059130208_3v64x8m81_3/D
+ pmos_5p04310591302041_3v64x8m81_0/S vdd pmos_1p2$$202587180_3v64x8m81
Xnmos_1p2$$202595372_3v64x8m81_1 nmos_1p2$$202595372_3v64x8m81_1/nmos_5p0431059130208_3v64x8m81_0/S
+ pmos_5p04310591302041_3v64x8m81_0/S vss vss nmos_1p2$$202595372_3v64x8m81
Xnmos_1p2$$202596396_3v64x8m81_0 vss nmos_1p2$$202595372_3v64x8m81_1/nmos_5p0431059130208_3v64x8m81_0/S
+ nmos_1p2$$202596396_3v64x8m81_0/nmos_5p0431059130208_3v64x8m81_0/D vss nmos_1p2$$202596396_3v64x8m81
Xnmos_1p2$$202596396_3v64x8m81_1 pmos_5p04310591302041_3v64x8m81_0/D nmos_1p2$$202595372_3v64x8m81_1/nmos_5p0431059130208_3v64x8m81_0/S
+ vss vss nmos_1p2$$202596396_3v64x8m81
Xnmos_5p04310591302010_3v64x8m81_0 vss nmos_1p2$$202596396_3v64x8m81_0/nmos_5p0431059130208_3v64x8m81_0/D
+ pmos_5p04310591302020_3v64x8m81_0/S vss nmos_5p04310591302010_3v64x8m81
Xnmos_5p0431059130208_3v64x8m81_0 vss GWEN nmos_5p0431059130208_3v64x8m81_2/D vss
+ nmos_5p0431059130208_3v64x8m81
Xnmos_5p0431059130208_3v64x8m81_1 nmos_5p0431059130208_3v64x8m81_1/D nmos_5p0431059130208_3v64x8m81_2/D
+ vss vss nmos_5p0431059130208_3v64x8m81
Xpmos_5p04310591302043_3v64x8m81_0 wep wep pmos_5p04310591302035_3v64x8m81_0/D vdd_uq0
+ vdd_uq0 pmos_5p04310591302035_3v64x8m81_0/D pmos_5p04310591302035_3v64x8m81_0/D
+ vdd_uq0 pmos_5p04310591302043_3v64x8m81
Xnmos_1p2$$202598444_3v64x8m81_0 pmos_5p04310591302041_3v64x8m81_0/S pmos_5p04310591302014_3v64x8m81_5/D
+ nmos_5p0431059130208_3v64x8m81_1/D vss nmos_1p2$$202598444_3v64x8m81
Xnmos_5p0431059130208_3v64x8m81_2 nmos_5p0431059130208_3v64x8m81_2/D wen vss vss nmos_5p0431059130208_3v64x8m81
Xpmos_5p04310591302041_3v64x8m81_0 pmos_5p04310591302041_3v64x8m81_0/D pmos_5p04310591302014_3v64x8m81_5/D
+ vdd pmos_5p04310591302041_3v64x8m81_0/S pmos_5p04310591302041_3v64x8m81
Xnmos_5p0431059130208_3v64x8m81_3 nmos_5p0431059130208_3v64x8m81_3/D pmos_5p04310591302014_3v64x8m81_5/D
+ vss vss nmos_5p0431059130208_3v64x8m81
Xnmos_5p04310591302039_3v64x8m81_0 men pmos_1p2$$202583084_3v64x8m81_0/pmos_5p04310591302035_3v64x8m81_0/D
+ pmos_1p2$$202583084_3v64x8m81_0/pmos_5p04310591302035_3v64x8m81_0/D pmos_5p04310591302020_3v64x8m81_0/S
+ pmos_5p04310591302020_3v64x8m81_0/S vss nmos_5p04310591302039_3v64x8m81
Xpmos_1p2$$202583084_3v64x8m81_0 nmos_1p2$$202596396_3v64x8m81_0/nmos_5p0431059130208_3v64x8m81_0/D
+ vdd vdd pmos_1p2$$202583084_3v64x8m81_0/pmos_5p04310591302035_3v64x8m81_0/D nmos_1p2$$202596396_3v64x8m81_0/nmos_5p0431059130208_3v64x8m81_0/D
+ vdd pmos_1p2$$202583084_3v64x8m81
Xpmos_1p2$$202585132_3v64x8m81_0 vdd nmos_1p2$$202595372_3v64x8m81_1/nmos_5p0431059130208_3v64x8m81_0/S
+ nmos_1p2$$202596396_3v64x8m81_0/nmos_5p0431059130208_3v64x8m81_0/D vdd pmos_1p2$$202585132_3v64x8m81
Xnmos_1p2$$202594348_3v64x8m81_0 vss pmos_1p2$$202583084_3v64x8m81_0/pmos_5p04310591302035_3v64x8m81_0/D
+ nmos_1p2$$202596396_3v64x8m81_0/nmos_5p0431059130208_3v64x8m81_0/D vss nmos_1p2$$202594348_3v64x8m81
Xpmos_1p2$$202586156_3v64x8m81_0 pmos_5p04310591302041_3v64x8m81_0/D nmos_1p2$$202595372_3v64x8m81_1/nmos_5p0431059130208_3v64x8m81_0/S
+ vdd vdd pmos_1p2$$202586156_3v64x8m81
Xpmos_5p04310591302014_3v64x8m81_0 pmos_5p04310591302014_3v64x8m81_2/S wen vdd_uq0
+ vdd_uq0 pmos_5p04310591302014_3v64x8m81
Xpmos_5p04310591302014_3v64x8m81_1 nmos_5p0431059130208_3v64x8m81_1/D nmos_5p0431059130208_3v64x8m81_2/D
+ vdd_uq0 vdd_uq0 pmos_5p04310591302014_3v64x8m81
Xpmos_5p04310591302014_3v64x8m81_2 nmos_5p0431059130208_3v64x8m81_2/D GWEN vdd_uq0
+ pmos_5p04310591302014_3v64x8m81_2/S pmos_5p04310591302014_3v64x8m81
Xpmos_5p04310591302014_3v64x8m81_3 pmos_5p04310591302014_3v64x8m81_5/S men vdd vdd
+ pmos_5p04310591302014_3v64x8m81
Xpmos_5p04310591302014_3v64x8m81_4 nmos_5p0431059130208_3v64x8m81_3/D pmos_5p04310591302014_3v64x8m81_5/D
+ vdd vdd pmos_5p04310591302014_3v64x8m81
Xnmos_5p04310591302042_3v64x8m81_0 wep wep pmos_5p04310591302035_3v64x8m81_0/D vss
+ vss pmos_5p04310591302035_3v64x8m81_0/D pmos_5p04310591302035_3v64x8m81_0/D vss
+ nmos_5p04310591302042_3v64x8m81
Xpmos_5p04310591302014_3v64x8m81_5 pmos_5p04310591302014_3v64x8m81_5/D vss vdd pmos_5p04310591302014_3v64x8m81_5/S
+ pmos_5p04310591302014_3v64x8m81
Xnmos_5p04310591302040_3v64x8m81_0 pmos_5p04310591302035_3v64x8m81_0/D pmos_5p04310591302020_3v64x8m81_0/S
+ vss vss nmos_5p04310591302040_3v64x8m81
Xnmos_5p04310591302040_3v64x8m81_1 pmos_5p04310591302014_3v64x8m81_5/D men vss vss
+ nmos_5p04310591302040_3v64x8m81
Xnmos_5p04310591302040_3v64x8m81_2 vss vss pmos_5p04310591302014_3v64x8m81_5/D vss
+ nmos_5p04310591302040_3v64x8m81
.ends

.subckt pmos_5p04310591302038_3v64x8m81 D a_0_n44# w_n174_n86# S
X0 D a_0_n44# S w_n174_n86# pfet_03v3 ad=0.2464p pd=2u as=0.2464p ps=2u w=0.56u l=0.28u
.ends

.subckt pmos_5p04310591302025_3v64x8m81 D_uq0 D a_265_n44# S_uq0 S a_n56_n44# a_104_n44#
+ w_n230_n85#
X0 D_uq0 a_265_n44# S_uq0 w_n230_n85# pfet_03v3 ad=0.9306p pd=5.11u as=0.55518p ps=2.64u w=2.115u l=0.28u
X1 D a_n56_n44# S w_n230_n85# pfet_03v3 ad=0.5499p pd=2.635u as=0.9306p ps=5.11u w=2.115u l=0.28u
X2 S_uq0 a_104_n44# D w_n230_n85# pfet_03v3 ad=0.55518p pd=2.64u as=0.5499p ps=2.635u w=2.115u l=0.28u
.ends

.subckt pmos_1p2$$46281772_3v64x8m81 w_n133_n66# pmos_5p04310591302025_3v64x8m81_0/D
+ pmos_5p04310591302025_3v64x8m81_0/D_uq0 a_251_n34# a_n70_n34# pmos_5p04310591302025_3v64x8m81_0/S
+ a_90_n34# pmos_5p04310591302025_3v64x8m81_0/S_uq0
Xpmos_5p04310591302025_3v64x8m81_0 pmos_5p04310591302025_3v64x8m81_0/D_uq0 pmos_5p04310591302025_3v64x8m81_0/D
+ a_251_n34# pmos_5p04310591302025_3v64x8m81_0/S_uq0 pmos_5p04310591302025_3v64x8m81_0/S
+ a_n70_n34# a_90_n34# w_n133_n66# pmos_5p04310591302025_3v64x8m81
.ends

.subckt nmos_5p04310591302029_3v64x8m81 D a_n28_n44# a_132_n44# S_uq0 S VSUBS
X0 D a_n28_n44# S VSUBS nfet_03v3 ad=0.3159p pd=1.735u as=0.5346p ps=3.31u w=1.215u l=0.28u
X1 S_uq0 a_132_n44# D VSUBS nfet_03v3 ad=0.54067p pd=3.32u as=0.3159p ps=1.735u w=1.215u l=0.28u
.ends

.subckt nmos_1p2$$45100076_3v64x8m81 nmos_5p04310591302029_3v64x8m81_0/S a_118_n34#
+ a_n41_n34# nmos_5p04310591302029_3v64x8m81_0/S_uq0 nmos_5p04310591302029_3v64x8m81_0/D
+ VSUBS
Xnmos_5p04310591302029_3v64x8m81_0 nmos_5p04310591302029_3v64x8m81_0/D a_n41_n34#
+ a_118_n34# nmos_5p04310591302029_3v64x8m81_0/S_uq0 nmos_5p04310591302029_3v64x8m81_0/S
+ VSUBS nmos_5p04310591302029_3v64x8m81
.ends

.subckt pmos_5p04310591302024_3v64x8m81 w_n286_n86# D_uq1 D_uq0 a_530_n44# D a_n112_n44#
+ a_209_n44# a_369_n44# a_48_n44# S_uq1 S_uq0 S
X0 D_uq1 a_n112_n44# S_uq1 w_n286_n86# pfet_03v3 ad=0.2743p pd=1.575u as=0.4642p ps=2.99u w=1.055u l=0.28u
X1 S_uq0 a_369_n44# D w_n286_n86# pfet_03v3 ad=0.27692p pd=1.58u as=0.2743p ps=1.575u w=1.055u l=0.28u
X2 D a_209_n44# S w_n286_n86# pfet_03v3 ad=0.2743p pd=1.575u as=0.27692p ps=1.58u w=1.055u l=0.28u
X3 D_uq0 a_530_n44# S_uq0 w_n286_n86# pfet_03v3 ad=0.4642p pd=2.99u as=0.27692p ps=1.58u w=1.055u l=0.28u
X4 S a_48_n44# D_uq1 w_n286_n86# pfet_03v3 ad=0.27692p pd=1.58u as=0.2743p ps=1.575u w=1.055u l=0.28u
.ends

.subckt pmos_1p2$$46282796_3v64x8m81 a_n126_n34# a_195_n34# pmos_5p04310591302024_3v64x8m81_0/S_uq1
+ pmos_5p04310591302024_3v64x8m81_0/S_uq0 pmos_5p04310591302024_3v64x8m81_0/S a_516_n34#
+ w_163_n66# a_355_n34# pmos_5p04310591302024_3v64x8m81_0/D_uq1 pmos_5p04310591302024_3v64x8m81_0/D_uq0
+ pmos_5p04310591302024_3v64x8m81_0/D a_34_n34#
Xpmos_5p04310591302024_3v64x8m81_0 w_163_n66# pmos_5p04310591302024_3v64x8m81_0/D_uq1
+ pmos_5p04310591302024_3v64x8m81_0/D_uq0 a_516_n34# pmos_5p04310591302024_3v64x8m81_0/D
+ a_n126_n34# a_195_n34# a_355_n34# a_34_n34# pmos_5p04310591302024_3v64x8m81_0/S_uq1
+ pmos_5p04310591302024_3v64x8m81_0/S_uq0 pmos_5p04310591302024_3v64x8m81_0/S pmos_5p04310591302024_3v64x8m81
.ends

.subckt nmos_5p04310591302036_3v64x8m81 D_uq1 D_uq0 a_530_n44# D a_n112_n44# a_209_n44#
+ a_369_n44# a_48_n44# S_uq1 S_uq0 S VSUBS
X0 D_uq1 a_n112_n44# S_uq1 VSUBS nfet_03v3 ad=0.1378p pd=1.05u as=0.2332p ps=1.94u w=0.53u l=0.28u
X1 S_uq0 a_369_n44# D VSUBS nfet_03v3 ad=0.13913p pd=1.055u as=0.1378p ps=1.05u w=0.53u l=0.28u
X2 D a_209_n44# S VSUBS nfet_03v3 ad=0.1378p pd=1.05u as=0.13913p ps=1.055u w=0.53u l=0.28u
X3 D_uq0 a_530_n44# S_uq0 VSUBS nfet_03v3 ad=0.2332p pd=1.94u as=0.13913p ps=1.055u w=0.53u l=0.28u
X4 S a_48_n44# D_uq1 VSUBS nfet_03v3 ad=0.13913p pd=1.055u as=0.1378p ps=1.05u w=0.53u l=0.28u
.ends

.subckt nmos_1p2$$45101100_3v64x8m81 nmos_5p04310591302036_3v64x8m81_0/D nmos_5p04310591302036_3v64x8m81_0/S_uq1
+ a_195_n34# nmos_5p04310591302036_3v64x8m81_0/S_uq0 a_35_n34# a_516_n34# nmos_5p04310591302036_3v64x8m81_0/D_uq1
+ nmos_5p04310591302036_3v64x8m81_0/D_uq0 nmos_5p04310591302036_3v64x8m81_0/S a_n125_n34#
+ a_356_n34# VSUBS
Xnmos_5p04310591302036_3v64x8m81_0 nmos_5p04310591302036_3v64x8m81_0/D_uq1 nmos_5p04310591302036_3v64x8m81_0/D_uq0
+ a_516_n34# nmos_5p04310591302036_3v64x8m81_0/D a_n125_n34# a_195_n34# a_356_n34#
+ a_35_n34# nmos_5p04310591302036_3v64x8m81_0/S_uq1 nmos_5p04310591302036_3v64x8m81_0/S_uq0
+ nmos_5p04310591302036_3v64x8m81_0/S VSUBS nmos_5p04310591302036_3v64x8m81
.ends

.subckt pmos_5p04310591302022_3v64x8m81 D_uq2 D_uq1 D_uq0 D a_n252_n44# a_550_n44#
+ a_229_n44# w_n426_n86# S_uq4 S_uq2 S_uq3 S_uq1 a_390_n44# S_uq0 S a_n92_n44# a_1032_n44#
+ a_1192_n44# a_711_n44# a_69_n44# D_uq3 a_871_n44#
X0 D_uq1 a_390_n44# S_uq2 w_n426_n86# pfet_03v3 ad=0.4953p pd=2.425u as=0.50005p ps=2.43u w=1.905u l=0.28u
X1 D_uq3 a_n252_n44# S_uq4 w_n426_n86# pfet_03v3 ad=0.4953p pd=2.425u as=0.8382p ps=4.69u w=1.905u l=0.28u
X2 D_uq2 a_69_n44# S_uq3 w_n426_n86# pfet_03v3 ad=0.4953p pd=2.425u as=0.50005p ps=2.43u w=1.905u l=0.28u
X3 S_uq2 a_229_n44# D_uq2 w_n426_n86# pfet_03v3 ad=0.50005p pd=2.43u as=0.4953p ps=2.425u w=1.905u l=0.28u
X4 S_uq1 a_550_n44# D_uq1 w_n426_n86# pfet_03v3 ad=0.50005p pd=2.43u as=0.4953p ps=2.425u w=1.905u l=0.28u
X5 S_uq0 a_1192_n44# D_uq0 w_n426_n86# pfet_03v3 ad=0.8382p pd=4.69u as=0.4953p ps=2.425u w=1.905u l=0.28u
X6 D_uq0 a_1032_n44# S w_n426_n86# pfet_03v3 ad=0.4953p pd=2.425u as=0.50005p ps=2.43u w=1.905u l=0.28u
X7 S_uq3 a_n92_n44# D_uq3 w_n426_n86# pfet_03v3 ad=0.50005p pd=2.43u as=0.4953p ps=2.425u w=1.905u l=0.28u
X8 S a_871_n44# D w_n426_n86# pfet_03v3 ad=0.50005p pd=2.43u as=0.4953p ps=2.425u w=1.905u l=0.28u
X9 D a_711_n44# S_uq1 w_n426_n86# pfet_03v3 ad=0.4953p pd=2.425u as=0.50005p ps=2.43u w=1.905u l=0.28u
.ends

.subckt pmos_1p2$$46283820_3v64x8m81 pmos_5p04310591302022_3v64x8m81_0/S_uq3 a_536_n34#
+ pmos_5p04310591302022_3v64x8m81_0/S_uq2 pmos_5p04310591302022_3v64x8m81_0/S_uq1
+ pmos_5p04310591302022_3v64x8m81_0/D pmos_5p04310591302022_3v64x8m81_0/S_uq0 a_215_n34#
+ a_697_n34# pmos_5p04310591302022_3v64x8m81_0/D_uq2 pmos_5p04310591302022_3v64x8m81_0/D_uq3
+ a_n106_n34# pmos_5p04310591302022_3v64x8m81_0/D_uq1 a_n266_n34# pmos_5p04310591302022_3v64x8m81_0/D_uq0
+ a_376_n34# w_984_n66# a_1018_n34# pmos_5p04310591302022_3v64x8m81_0/S a_1178_n34#
+ a_55_n34# a_857_n34# pmos_5p04310591302022_3v64x8m81_0/S_uq4
Xpmos_5p04310591302022_3v64x8m81_0 pmos_5p04310591302022_3v64x8m81_0/D_uq2 pmos_5p04310591302022_3v64x8m81_0/D_uq1
+ pmos_5p04310591302022_3v64x8m81_0/D_uq0 pmos_5p04310591302022_3v64x8m81_0/D a_n266_n34#
+ a_536_n34# a_215_n34# w_984_n66# pmos_5p04310591302022_3v64x8m81_0/S_uq4 pmos_5p04310591302022_3v64x8m81_0/S_uq2
+ pmos_5p04310591302022_3v64x8m81_0/S_uq3 pmos_5p04310591302022_3v64x8m81_0/S_uq1
+ a_376_n34# pmos_5p04310591302022_3v64x8m81_0/S_uq0 pmos_5p04310591302022_3v64x8m81_0/S
+ a_n106_n34# a_1018_n34# a_1178_n34# a_697_n34# a_55_n34# pmos_5p04310591302022_3v64x8m81_0/D_uq3
+ a_857_n34# pmos_5p04310591302022_3v64x8m81
.ends

.subckt nmos_5p04310591302012_3v64x8m81 a_n83_n44# D_uq0 D a_77_n44# S_uq1 S_uq0 S
+ a_237_n44# a_397_n44# VSUBS
X0 S a_77_n44# D VSUBS nfet_03v3 ad=0.2743p pd=1.575u as=0.2743p ps=1.575u w=1.055u l=0.28u
X1 S_uq0 a_397_n44# D_uq0 VSUBS nfet_03v3 ad=0.4642p pd=2.99u as=0.2743p ps=1.575u w=1.055u l=0.28u
X2 D_uq0 a_237_n44# S VSUBS nfet_03v3 ad=0.2743p pd=1.575u as=0.2743p ps=1.575u w=1.055u l=0.28u
X3 D a_n83_n44# S_uq1 VSUBS nfet_03v3 ad=0.2743p pd=1.575u as=0.4642p ps=2.99u w=1.055u l=0.28u
.ends

.subckt nmos_5p04310591302026_3v64x8m81 D_uq2 D_uq1 D_uq0 a_154_n44# D a_n168_n44#
+ a_476_n44# a_798_n44# a_314_n44# S_uq2 S_uq1 a_n8_n44# S_uq0 S a_636_n44# VSUBS
X0 S_uq0 a_636_n44# D VSUBS nfet_03v3 ad=0.27957p pd=1.585u as=0.2743p ps=1.575u w=1.055u l=0.28u
X1 S a_314_n44# D_uq1 VSUBS nfet_03v3 ad=0.27957p pd=1.585u as=0.2743p ps=1.575u w=1.055u l=0.28u
X2 D_uq2 a_n168_n44# S_uq2 VSUBS nfet_03v3 ad=0.2743p pd=1.575u as=0.4642p ps=2.99u w=1.055u l=0.28u
X3 S_uq1 a_n8_n44# D_uq2 VSUBS nfet_03v3 ad=0.27957p pd=1.585u as=0.2743p ps=1.575u w=1.055u l=0.28u
X4 D_uq0 a_798_n44# S_uq0 VSUBS nfet_03v3 ad=0.4642p pd=2.99u as=0.27957p ps=1.585u w=1.055u l=0.28u
X5 D a_476_n44# S VSUBS nfet_03v3 ad=0.2743p pd=1.575u as=0.27957p ps=1.585u w=1.055u l=0.28u
X6 D_uq1 a_154_n44# S_uq1 VSUBS nfet_03v3 ad=0.2743p pd=1.575u as=0.27957p ps=1.585u w=1.055u l=0.28u
.ends

.subckt nmos_1p2$$45102124_3v64x8m81 a_140_n34# nmos_5p04310591302026_3v64x8m81_0/D_uq2
+ nmos_5p04310591302026_3v64x8m81_0/D_uq1 nmos_5p04310591302026_3v64x8m81_0/D_uq0
+ nmos_5p04310591302026_3v64x8m81_0/S a_462_n34# a_n181_n34# a_784_n34# a_300_n34#
+ nmos_5p04310591302026_3v64x8m81_0/D nmos_5p04310591302026_3v64x8m81_0/S_uq2 a_622_n34#
+ a_n22_n34# nmos_5p04310591302026_3v64x8m81_0/S_uq1 nmos_5p04310591302026_3v64x8m81_0/S_uq0
+ VSUBS
Xnmos_5p04310591302026_3v64x8m81_0 nmos_5p04310591302026_3v64x8m81_0/D_uq2 nmos_5p04310591302026_3v64x8m81_0/D_uq1
+ nmos_5p04310591302026_3v64x8m81_0/D_uq0 a_140_n34# nmos_5p04310591302026_3v64x8m81_0/D
+ a_n181_n34# a_462_n34# a_784_n34# a_300_n34# nmos_5p04310591302026_3v64x8m81_0/S_uq2
+ nmos_5p04310591302026_3v64x8m81_0/S_uq1 a_n22_n34# nmos_5p04310591302026_3v64x8m81_0/S_uq0
+ nmos_5p04310591302026_3v64x8m81_0/S a_622_n34# VSUBS nmos_5p04310591302026_3v64x8m81
.ends

.subckt pmos_1p2$$46284844_3v64x8m81 w_n133_n66# pmos_5p04310591302035_3v64x8m81_0/S
+ pmos_5p04310591302035_3v64x8m81_0/S_uq0 pmos_5p04310591302035_3v64x8m81_0/D a_118_n34#
+ a_n42_n34#
Xpmos_5p04310591302035_3v64x8m81_0 pmos_5p04310591302035_3v64x8m81_0/D a_n42_n34#
+ a_118_n34# w_n133_n66# pmos_5p04310591302035_3v64x8m81_0/S_uq0 pmos_5p04310591302035_3v64x8m81_0/S
+ pmos_5p04310591302035_3v64x8m81
.ends

.subckt nmos_5p04310591302037_3v64x8m81 a_20_n44# D a_181_n44# a_502_n44# S_uq2 a_662_n44#
+ a_n140_n44# S_uq0 a_341_n44# VSUBS
X0 S a_341_n44# D VSUBS nfet_03v3 ad=0.34912p pd=1.855u as=0.3458p ps=1.85u w=1.33u l=0.28u
X1 S_uq0 a_662_n44# D_uq0 VSUBS nfet_03v3 ad=0.5852p pd=3.54u as=0.3458p ps=1.85u w=1.33u l=0.28u
X2 D_uq0 a_502_n44# S VSUBS nfet_03v3 ad=0.3458p pd=1.85u as=0.34912p ps=1.855u w=1.33u l=0.28u
X3 S_uq1 a_20_n44# D_uq1 VSUBS nfet_03v3 ad=0.34912p pd=1.855u as=0.3458p ps=1.85u w=1.33u l=0.28u
X4 D a_181_n44# S_uq1 VSUBS nfet_03v3 ad=0.3458p pd=1.85u as=0.34912p ps=1.855u w=1.33u l=0.28u
X5 D_uq1 a_n140_n44# S_uq2 VSUBS nfet_03v3 ad=0.3458p pd=1.85u as=0.5852p ps=3.54u w=1.33u l=0.28u
.ends

.subckt nmos_1p2$$45103148_3v64x8m81 a_327_n34# a_n153_n34# a_488_n34# nmos_5p04310591302037_3v64x8m81_0/D
+ a_167_n34# nmos_5p04310591302037_3v64x8m81_0/S_uq2 nmos_5p04310591302037_3v64x8m81_0/S_uq0
+ a_6_n34# a_648_n34# VSUBS
Xnmos_5p04310591302037_3v64x8m81_0 a_6_n34# nmos_5p04310591302037_3v64x8m81_0/D a_167_n34#
+ a_488_n34# nmos_5p04310591302037_3v64x8m81_0/S_uq2 a_648_n34# a_n153_n34# nmos_5p04310591302037_3v64x8m81_0/S_uq0
+ a_327_n34# VSUBS nmos_5p04310591302037_3v64x8m81
.ends

.subckt nmos_5p04310591302028_3v64x8m81 D_uq1 D_uq0 D a_64_n44# a_226_n44# a_386_n44#
+ a_548_n44# S_uq1 S_uq0 S a_n96_n44# VSUBS
X0 D_uq0 a_548_n44# S_uq0 VSUBS nfet_03v3 ad=0.4642p pd=2.99u as=0.27957p ps=1.585u w=1.055u l=0.28u
X1 S_uq0 a_386_n44# D VSUBS nfet_03v3 ad=0.27957p pd=1.585u as=0.2743p ps=1.575u w=1.055u l=0.28u
X2 D a_226_n44# S VSUBS nfet_03v3 ad=0.2743p pd=1.575u as=0.27957p ps=1.585u w=1.055u l=0.28u
X3 D_uq1 a_n96_n44# S_uq1 VSUBS nfet_03v3 ad=0.2743p pd=1.575u as=0.4642p ps=2.99u w=1.055u l=0.28u
X4 S a_64_n44# D_uq1 VSUBS nfet_03v3 ad=0.27957p pd=1.585u as=0.2743p ps=1.575u w=1.055u l=0.28u
.ends

.subckt nmos_5p04310591302023_3v64x8m81 D a_n32_n44# a_136_n44# S_uq0 S VSUBS
X0 D a_n32_n44# S VSUBS nfet_03v3 ad=92.8f pd=0.92u as=0.1576p ps=1.64u w=0.28u l=0.28u
X1 S_uq0 a_136_n44# D VSUBS nfet_03v3 ad=0.159p pd=1.65u as=92.8f ps=0.92u w=0.28u l=0.28u
.ends

.subckt pmos_5p04310591302031_3v64x8m81 D a_n28_n44# a_132_n44# w_n202_n86# S_uq0
+ S
X0 D a_n28_n44# S w_n202_n86# pfet_03v3 ad=0.4134p pd=2.11u as=0.6996p ps=4.06u w=1.59u l=0.28u
X1 S_uq0 a_132_n44# D w_n202_n86# pfet_03v3 ad=0.6996p pd=4.06u as=0.4134p ps=2.11u w=1.59u l=0.28u
.ends

.subckt pmos_1p2$$46287916_3v64x8m81 w_n133_n66# pmos_5p04310591302031_3v64x8m81_0/D
+ a_n42_n34# pmos_5p04310591302031_3v64x8m81_0/S pmos_5p04310591302031_3v64x8m81_0/S_uq0
+ a_118_n34#
Xpmos_5p04310591302031_3v64x8m81_0 pmos_5p04310591302031_3v64x8m81_0/D a_n42_n34#
+ a_118_n34# w_n133_n66# pmos_5p04310591302031_3v64x8m81_0/S_uq0 pmos_5p04310591302031_3v64x8m81_0/S
+ pmos_5p04310591302031_3v64x8m81
.ends

.subckt pmos_5p04310591302030_3v64x8m81 D_uq2 a_871_n45# D_uq1 D_uq0 D a_n252_n45#
+ a_550_n45# a_229_n45# w_n426_n86# S_uq4 S_uq2 S_uq3 S_uq1 S_uq0 a_390_n45# S a_n92_n45#
+ a_1032_n45# a_1192_n45# D_uq3 a_711_n45# a_69_n45#
X0 D_uq1 a_390_n45# S_uq2 w_n426_n86# pfet_03v3 ad=0.3289p pd=1.785u as=0.33205p ps=1.79u w=1.265u l=0.28u
X1 D_uq3 a_n252_n45# S_uq4 w_n426_n86# pfet_03v3 ad=0.3289p pd=1.785u as=0.5566p ps=3.41u w=1.265u l=0.28u
X2 D_uq2 a_69_n45# S_uq3 w_n426_n86# pfet_03v3 ad=0.3289p pd=1.785u as=0.33205p ps=1.79u w=1.265u l=0.28u
X3 S_uq2 a_229_n45# D_uq2 w_n426_n86# pfet_03v3 ad=0.33205p pd=1.79u as=0.3289p ps=1.785u w=1.265u l=0.28u
X4 S_uq1 a_550_n45# D_uq1 w_n426_n86# pfet_03v3 ad=0.33205p pd=1.79u as=0.3289p ps=1.785u w=1.265u l=0.28u
X5 S_uq0 a_1192_n45# D_uq0 w_n426_n86# pfet_03v3 ad=0.5566p pd=3.41u as=0.3289p ps=1.785u w=1.265u l=0.28u
X6 D_uq0 a_1032_n45# S w_n426_n86# pfet_03v3 ad=0.3289p pd=1.785u as=0.33205p ps=1.79u w=1.265u l=0.28u
X7 S_uq3 a_n92_n45# D_uq3 w_n426_n86# pfet_03v3 ad=0.33205p pd=1.79u as=0.3289p ps=1.785u w=1.265u l=0.28u
X8 S a_871_n45# D w_n426_n86# pfet_03v3 ad=0.33205p pd=1.79u as=0.3289p ps=1.785u w=1.265u l=0.28u
X9 D a_711_n45# S_uq1 w_n426_n86# pfet_03v3 ad=0.3289p pd=1.785u as=0.33205p ps=1.79u w=1.265u l=0.28u
.ends

.subckt pmos_1p2$$45095980_3v64x8m81 a_697_n34# a_n106_n34# pmos_5p04310591302030_3v64x8m81_0/S
+ a_n266_n34# a_376_n34# pmos_5p04310591302030_3v64x8m81_0/D_uq2 pmos_5p04310591302030_3v64x8m81_0/D_uq3
+ pmos_5p04310591302030_3v64x8m81_0/D_uq1 pmos_5p04310591302030_3v64x8m81_0/D_uq0
+ a_1018_n34# a_1178_n34# a_55_n34# w_987_n66# a_857_n34# pmos_5p04310591302030_3v64x8m81_0/D
+ a_536_n34# pmos_5p04310591302030_3v64x8m81_0/S_uq4 pmos_5p04310591302030_3v64x8m81_0/S_uq3
+ a_215_n34# pmos_5p04310591302030_3v64x8m81_0/S_uq2 pmos_5p04310591302030_3v64x8m81_0/S_uq0
+ pmos_5p04310591302030_3v64x8m81_0/S_uq1
Xpmos_5p04310591302030_3v64x8m81_0 pmos_5p04310591302030_3v64x8m81_0/D_uq2 a_857_n34#
+ pmos_5p04310591302030_3v64x8m81_0/D_uq1 pmos_5p04310591302030_3v64x8m81_0/D_uq0
+ pmos_5p04310591302030_3v64x8m81_0/D a_n266_n34# a_536_n34# a_215_n34# w_987_n66#
+ pmos_5p04310591302030_3v64x8m81_0/S_uq4 pmos_5p04310591302030_3v64x8m81_0/S_uq2
+ pmos_5p04310591302030_3v64x8m81_0/S_uq3 pmos_5p04310591302030_3v64x8m81_0/S_uq1
+ pmos_5p04310591302030_3v64x8m81_0/S_uq0 a_376_n34# pmos_5p04310591302030_3v64x8m81_0/S
+ a_n106_n34# a_1018_n34# a_1178_n34# pmos_5p04310591302030_3v64x8m81_0/D_uq3 a_697_n34#
+ a_55_n34# pmos_5p04310591302030_3v64x8m81
.ends

.subckt nmos_5p04310591302034_3v64x8m81 D a_0_n44# S VSUBS
X0 D a_0_n44# S VSUBS nfet_03v3 ad=0.2948p pd=2.22u as=0.2948p ps=2.22u w=0.67u l=0.28u
.ends

.subckt nmos_5p04310591302033_3v64x8m81 D a_0_n44# S VSUBS
X0 D a_0_n44# S VSUBS nfet_03v3 ad=0.1576p pd=1.64u as=0.1576p ps=1.64u w=0.28u l=0.28u
.ends

.subckt nmos_5p04310591302032_3v64x8m81 D a_n28_n44# a_132_n44# S_uq0 S VSUBS
X0 D a_n28_n44# S VSUBS nfet_03v3 ad=0.1378p pd=1.05u as=0.2332p ps=1.94u w=0.53u l=0.28u
X1 S_uq0 a_132_n44# D VSUBS nfet_03v3 ad=0.23585p pd=1.95u as=0.1378p ps=1.05u w=0.53u l=0.28u
.ends

.subckt pmos_5p04310591302013_3v64x8m81 D_uq0 D a_265_n44# S_uq0 S a_n56_n44# a_104_n44#
+ w_n230_n86#
X0 D_uq0 a_265_n44# S_uq0 w_n230_n86# pfet_03v3 ad=0.4642p pd=2.99u as=0.27692p ps=1.58u w=1.055u l=0.28u
X1 D a_n56_n44# S w_n230_n86# pfet_03v3 ad=0.2743p pd=1.575u as=0.4642p ps=2.99u w=1.055u l=0.28u
X2 S_uq0 a_104_n44# D w_n230_n86# pfet_03v3 ad=0.27692p pd=1.58u as=0.2743p ps=1.575u w=1.055u l=0.28u
.ends

.subckt pmos_1p2$$46286892_3v64x8m81 w_n133_n66# pmos_5p04310591302013_3v64x8m81_0/D
+ pmos_5p04310591302013_3v64x8m81_0/S_uq0 a_251_n34# a_n70_n34# pmos_5p04310591302013_3v64x8m81_0/S
+ a_90_n34# pmos_5p04310591302013_3v64x8m81_0/D_uq0
Xpmos_5p04310591302013_3v64x8m81_0 pmos_5p04310591302013_3v64x8m81_0/D_uq0 pmos_5p04310591302013_3v64x8m81_0/D
+ a_251_n34# pmos_5p04310591302013_3v64x8m81_0/S_uq0 pmos_5p04310591302013_3v64x8m81_0/S
+ a_n70_n34# a_90_n34# w_n133_n66# pmos_5p04310591302013_3v64x8m81
.ends

.subckt pmos_5p04310591302027_3v64x8m81 D a_n28_n44# a_132_n44# w_n202_n86# S_uq0
+ S
X0 D a_n28_n44# S w_n202_n86# pfet_03v3 ad=0.1456p pd=1.08u as=0.2464p ps=2u w=0.56u l=0.28u
X1 S_uq0 a_132_n44# D w_n202_n86# pfet_03v3 ad=0.2464p pd=2u as=0.1456p ps=1.08u w=0.56u l=0.28u
.ends

.subckt sacntl_2_3v64x8m81 pcb se pmos_5p04310591302027_3v64x8m81_1/S_uq0 pmos_5p04310591302027_3v64x8m81_2/S_uq0
+ men vdd_uq0 vss vdd
Xpmos_5p04310591302038_3v64x8m81_0 vdd_uq0 pmos_5p04310591302027_3v64x8m81_0/S_uq0
+ vdd_uq0 pmos_5p04310591302038_3v64x8m81_0/S pmos_5p04310591302038_3v64x8m81
Xpmos_1p2$$46281772_3v64x8m81_0 vdd vdd vdd pmos_1p2$$46281772_3v64x8m81_1/pmos_5p04310591302025_3v64x8m81_0/S
+ pmos_1p2$$46281772_3v64x8m81_1/pmos_5p04310591302025_3v64x8m81_0/S pmos_1p2$$46281772_3v64x8m81_0/pmos_5p04310591302025_3v64x8m81_0/S
+ pmos_1p2$$46281772_3v64x8m81_1/pmos_5p04310591302025_3v64x8m81_0/S pmos_1p2$$46281772_3v64x8m81_0/pmos_5p04310591302025_3v64x8m81_0/S
+ pmos_1p2$$46281772_3v64x8m81
Xpmos_1p2$$46281772_3v64x8m81_1 vdd vdd vdd nmos_5p04310591302028_3v64x8m81_1/S pmos_1p2$$46282796_3v64x8m81_0/pmos_5p04310591302024_3v64x8m81_0/D
+ pmos_1p2$$46281772_3v64x8m81_1/pmos_5p04310591302025_3v64x8m81_0/S nmos_5p04310591302034_3v64x8m81_0/D
+ pmos_1p2$$46281772_3v64x8m81_1/pmos_5p04310591302025_3v64x8m81_0/S pmos_1p2$$46281772_3v64x8m81
Xnmos_1p2$$45100076_3v64x8m81_0 vss pmos_1p2$$46281772_3v64x8m81_1/pmos_5p04310591302025_3v64x8m81_0/S
+ pmos_1p2$$46281772_3v64x8m81_1/pmos_5p04310591302025_3v64x8m81_0/S vss pmos_1p2$$46281772_3v64x8m81_0/pmos_5p04310591302025_3v64x8m81_0/S
+ vss nmos_1p2$$45100076_3v64x8m81
Xpmos_1p2$$46282796_3v64x8m81_0 men men vdd_uq0 vdd_uq0 vdd_uq0 men vdd_uq0 men pmos_1p2$$46282796_3v64x8m81_0/pmos_5p04310591302024_3v64x8m81_0/D
+ pmos_1p2$$46282796_3v64x8m81_0/pmos_5p04310591302024_3v64x8m81_0/D pmos_1p2$$46282796_3v64x8m81_0/pmos_5p04310591302024_3v64x8m81_0/D
+ men pmos_1p2$$46282796_3v64x8m81
Xnmos_1p2$$45101100_3v64x8m81_0 pmos_1p2$$46282796_3v64x8m81_0/pmos_5p04310591302024_3v64x8m81_0/D
+ vss men vss men men pmos_1p2$$46282796_3v64x8m81_0/pmos_5p04310591302024_3v64x8m81_0/D
+ pmos_1p2$$46282796_3v64x8m81_0/pmos_5p04310591302024_3v64x8m81_0/D vss men men vss
+ nmos_1p2$$45101100_3v64x8m81
Xpmos_1p2$$46283820_3v64x8m81_0 vdd pmos_1p2$$46281772_3v64x8m81_0/pmos_5p04310591302025_3v64x8m81_0/S
+ vdd vdd pcb vdd pmos_1p2$$46281772_3v64x8m81_0/pmos_5p04310591302025_3v64x8m81_0/S
+ pmos_1p2$$46281772_3v64x8m81_0/pmos_5p04310591302025_3v64x8m81_0/S pcb pcb pmos_1p2$$46281772_3v64x8m81_0/pmos_5p04310591302025_3v64x8m81_0/S
+ pcb pmos_1p2$$46281772_3v64x8m81_0/pmos_5p04310591302025_3v64x8m81_0/S pcb pmos_1p2$$46281772_3v64x8m81_0/pmos_5p04310591302025_3v64x8m81_0/S
+ vdd pmos_1p2$$46281772_3v64x8m81_0/pmos_5p04310591302025_3v64x8m81_0/S vdd pmos_1p2$$46281772_3v64x8m81_0/pmos_5p04310591302025_3v64x8m81_0/S
+ pmos_1p2$$46281772_3v64x8m81_0/pmos_5p04310591302025_3v64x8m81_0/S pmos_1p2$$46281772_3v64x8m81_0/pmos_5p04310591302025_3v64x8m81_0/S
+ vdd pmos_1p2$$46283820_3v64x8m81
Xnmos_5p04310591302012_3v64x8m81_0 nmos_5p04310591302028_3v64x8m81_1/S se se nmos_5p04310591302028_3v64x8m81_1/S
+ vss vss vss nmos_5p04310591302028_3v64x8m81_1/S nmos_5p04310591302028_3v64x8m81_1/S
+ vss nmos_5p04310591302012_3v64x8m81
Xnmos_1p2$$45102124_3v64x8m81_0 pmos_1p2$$46281772_3v64x8m81_0/pmos_5p04310591302025_3v64x8m81_0/S
+ pcb pcb pcb vss pmos_1p2$$46281772_3v64x8m81_0/pmos_5p04310591302025_3v64x8m81_0/S
+ pmos_1p2$$46281772_3v64x8m81_0/pmos_5p04310591302025_3v64x8m81_0/S pmos_1p2$$46281772_3v64x8m81_0/pmos_5p04310591302025_3v64x8m81_0/S
+ pmos_1p2$$46281772_3v64x8m81_0/pmos_5p04310591302025_3v64x8m81_0/S pcb vss pmos_1p2$$46281772_3v64x8m81_0/pmos_5p04310591302025_3v64x8m81_0/S
+ pmos_1p2$$46281772_3v64x8m81_0/pmos_5p04310591302025_3v64x8m81_0/S vss vss vss nmos_1p2$$45102124_3v64x8m81
Xpmos_1p2$$46284844_3v64x8m81_0 vdd_uq0 vdd_uq0 vdd_uq0 nmos_5p04310591302034_3v64x8m81_0/D
+ pmos_5p04310591302027_3v64x8m81_1/S pmos_5p04310591302027_3v64x8m81_1/S pmos_1p2$$46284844_3v64x8m81
Xnmos_1p2$$45103148_3v64x8m81_0 nmos_5p04310591302028_3v64x8m81_1/S pmos_1p2$$46282796_3v64x8m81_0/pmos_5p04310591302024_3v64x8m81_0/D
+ nmos_5p04310591302034_3v64x8m81_0/D pmos_1p2$$46281772_3v64x8m81_1/pmos_5p04310591302025_3v64x8m81_0/S
+ nmos_5p04310591302028_3v64x8m81_1/S vss vss nmos_5p04310591302034_3v64x8m81_0/D
+ pmos_1p2$$46282796_3v64x8m81_0/pmos_5p04310591302024_3v64x8m81_0/D vss nmos_1p2$$45103148_3v64x8m81
Xnmos_5p04310591302028_3v64x8m81_0 nmos_5p04310591302028_3v64x8m81_1/D nmos_5p04310591302028_3v64x8m81_1/D
+ nmos_5p04310591302028_3v64x8m81_1/D nmos_5p04310591302032_3v64x8m81_0/D nmos_5p04310591302032_3v64x8m81_0/D
+ nmos_5p04310591302032_3v64x8m81_0/D nmos_5p04310591302032_3v64x8m81_0/D vss vss
+ vss nmos_5p04310591302032_3v64x8m81_0/D vss nmos_5p04310591302028_3v64x8m81
Xpmos_1p2$$46285868_3v64x8m81_0 vdd nmos_5p04310591302028_3v64x8m81_1/S vdd pmos_1p2$$46282796_3v64x8m81_0/pmos_5p04310591302024_3v64x8m81_0/D
+ pmos_1p2$$46285868_3v64x8m81
Xnmos_5p04310591302028_3v64x8m81_1 nmos_5p04310591302028_3v64x8m81_1/D nmos_5p04310591302028_3v64x8m81_1/D
+ nmos_5p04310591302028_3v64x8m81_1/D pmos_1p2$$46282796_3v64x8m81_0/pmos_5p04310591302024_3v64x8m81_0/D
+ pmos_1p2$$46282796_3v64x8m81_0/pmos_5p04310591302024_3v64x8m81_0/D pmos_1p2$$46282796_3v64x8m81_0/pmos_5p04310591302024_3v64x8m81_0/D
+ pmos_1p2$$46282796_3v64x8m81_0/pmos_5p04310591302024_3v64x8m81_0/D nmos_5p04310591302028_3v64x8m81_1/S
+ nmos_5p04310591302028_3v64x8m81_1/S nmos_5p04310591302028_3v64x8m81_1/S pmos_1p2$$46282796_3v64x8m81_0/pmos_5p04310591302024_3v64x8m81_0/D
+ vss nmos_5p04310591302028_3v64x8m81
Xnmos_5p04310591302023_3v64x8m81_0 vss pmos_5p04310591302027_3v64x8m81_2/S_uq0 pmos_5p04310591302027_3v64x8m81_0/S
+ pmos_5p04310591302027_3v64x8m81_0/S_uq0 pmos_5p04310591302027_3v64x8m81_0/S vss
+ nmos_5p04310591302023_3v64x8m81
Xpmos_1p2$$46287916_3v64x8m81_0 vdd nmos_5p04310591302032_3v64x8m81_0/D nmos_5p04310591302034_3v64x8m81_0/D
+ vdd vdd nmos_5p04310591302034_3v64x8m81_0/D pmos_1p2$$46287916_3v64x8m81
Xnmos_5p04310591302023_3v64x8m81_1 vss pmos_1p2$$46282796_3v64x8m81_0/pmos_5p04310591302024_3v64x8m81_0/D
+ vss pmos_5p04310591302027_3v64x8m81_1/S_uq0 pmos_5p04310591302027_3v64x8m81_1/S
+ vss nmos_5p04310591302023_3v64x8m81
Xnmos_5p04310591302023_3v64x8m81_2 vss pmos_5p04310591302027_3v64x8m81_1/S_uq0 pmos_5p04310591302027_3v64x8m81_2/S
+ pmos_5p04310591302027_3v64x8m81_2/S_uq0 pmos_5p04310591302027_3v64x8m81_2/S vss
+ nmos_5p04310591302023_3v64x8m81
Xpmos_1p2$$45095980_3v64x8m81_0 nmos_5p04310591302028_3v64x8m81_1/S nmos_5p04310591302028_3v64x8m81_1/S
+ vdd nmos_5p04310591302028_3v64x8m81_1/S nmos_5p04310591302028_3v64x8m81_1/S se se
+ se se nmos_5p04310591302028_3v64x8m81_1/S nmos_5p04310591302028_3v64x8m81_1/S nmos_5p04310591302028_3v64x8m81_1/S
+ vdd nmos_5p04310591302028_3v64x8m81_1/S se nmos_5p04310591302028_3v64x8m81_1/S vdd
+ vdd nmos_5p04310591302028_3v64x8m81_1/S vdd vdd vdd pmos_1p2$$45095980_3v64x8m81
Xnmos_5p04310591302034_3v64x8m81_0 nmos_5p04310591302034_3v64x8m81_0/D pmos_5p04310591302027_3v64x8m81_1/S
+ vss vss nmos_5p04310591302034_3v64x8m81
Xnmos_5p04310591302033_3v64x8m81_0 vss pmos_5p04310591302027_3v64x8m81_0/S_uq0 pmos_5p04310591302038_3v64x8m81_0/S
+ vss nmos_5p04310591302033_3v64x8m81
Xnmos_5p04310591302032_3v64x8m81_0 nmos_5p04310591302032_3v64x8m81_0/D nmos_5p04310591302034_3v64x8m81_0/D
+ nmos_5p04310591302034_3v64x8m81_0/D vss vss vss nmos_5p04310591302032_3v64x8m81
Xpmos_1p2$$46286892_3v64x8m81_0 vdd nmos_5p04310591302028_3v64x8m81_1/S vdd nmos_5p04310591302032_3v64x8m81_0/D
+ nmos_5p04310591302032_3v64x8m81_0/D vdd nmos_5p04310591302032_3v64x8m81_0/D nmos_5p04310591302028_3v64x8m81_1/S
+ pmos_1p2$$46286892_3v64x8m81
Xpmos_5p04310591302027_3v64x8m81_0 vdd_uq0 pmos_5p04310591302027_3v64x8m81_2/S_uq0
+ pmos_5p04310591302027_3v64x8m81_0/S vdd_uq0 pmos_5p04310591302027_3v64x8m81_0/S_uq0
+ pmos_5p04310591302027_3v64x8m81_0/S pmos_5p04310591302027_3v64x8m81
Xpmos_5p04310591302027_3v64x8m81_1 vdd_uq0 pmos_1p2$$46282796_3v64x8m81_0/pmos_5p04310591302024_3v64x8m81_0/D
+ vss vdd_uq0 pmos_5p04310591302027_3v64x8m81_1/S_uq0 pmos_5p04310591302027_3v64x8m81_1/S
+ pmos_5p04310591302027_3v64x8m81
Xpmos_5p04310591302027_3v64x8m81_2 vdd_uq0 pmos_5p04310591302027_3v64x8m81_1/S_uq0
+ pmos_5p04310591302027_3v64x8m81_2/S vdd_uq0 pmos_5p04310591302027_3v64x8m81_2/S_uq0
+ pmos_5p04310591302027_3v64x8m81_2/S pmos_5p04310591302027_3v64x8m81
.ends

.subckt nmos_5p04310591302017_3v64x8m81 D_uq2 D_uq1 a_n37_n44# D_uq0 D a_929_n44#
+ a_125_n44# a_285_n44# a_447_n44# a_769_n44# S_uq2 S_uq3 S_uq1 S_uq0 S a_607_n44#
+ a_n197_n44# VSUBS
X0 D_uq0 a_769_n44# S VSUBS nfet_03v3 ad=0.3445p pd=1.845u as=0.35112p ps=1.855u w=1.325u l=0.28u
X1 D a_447_n44# S_uq1 VSUBS nfet_03v3 ad=0.3445p pd=1.845u as=0.35112p ps=1.855u w=1.325u l=0.28u
X2 D_uq2 a_n197_n44# S_uq3 VSUBS nfet_03v3 ad=0.3445p pd=1.845u as=0.583p ps=3.53u w=1.325u l=0.28u
X3 S_uq2 a_n37_n44# D_uq2 VSUBS nfet_03v3 ad=0.35112p pd=1.855u as=0.3445p ps=1.845u w=1.325u l=0.28u
X4 S_uq1 a_285_n44# D_uq1 VSUBS nfet_03v3 ad=0.35112p pd=1.855u as=0.3445p ps=1.845u w=1.325u l=0.28u
X5 D_uq1 a_125_n44# S_uq2 VSUBS nfet_03v3 ad=0.3445p pd=1.845u as=0.35112p ps=1.855u w=1.325u l=0.28u
X6 S_uq0 a_929_n44# D_uq0 VSUBS nfet_03v3 ad=0.58963p pd=3.54u as=0.3445p ps=1.845u w=1.325u l=0.28u
X7 S a_607_n44# D VSUBS nfet_03v3 ad=0.35112p pd=1.855u as=0.3445p ps=1.845u w=1.325u l=0.28u
.ends

.subckt nmos_1p2$$46550060_3v64x8m81 a_915_n34# nmos_5p04310591302017_3v64x8m81_0/S_uq3
+ nmos_5p04310591302017_3v64x8m81_0/S_uq1 nmos_5p04310591302017_3v64x8m81_0/S_uq2
+ nmos_5p04310591302017_3v64x8m81_0/S_uq0 a_111_n34# nmos_5p04310591302017_3v64x8m81_0/S
+ a_271_n34# a_433_n34# a_593_n34# a_n51_n34# a_755_n34# nmos_5p04310591302017_3v64x8m81_0/D_uq2
+ a_n210_n34# nmos_5p04310591302017_3v64x8m81_0/D_uq1 nmos_5p04310591302017_3v64x8m81_0/D_uq0
+ nmos_5p04310591302017_3v64x8m81_0/D VSUBS
Xnmos_5p04310591302017_3v64x8m81_0 nmos_5p04310591302017_3v64x8m81_0/D_uq2 nmos_5p04310591302017_3v64x8m81_0/D_uq1
+ a_n51_n34# nmos_5p04310591302017_3v64x8m81_0/D_uq0 nmos_5p04310591302017_3v64x8m81_0/D
+ a_915_n34# a_111_n34# a_271_n34# a_433_n34# a_755_n34# nmos_5p04310591302017_3v64x8m81_0/S_uq2
+ nmos_5p04310591302017_3v64x8m81_0/S_uq3 nmos_5p04310591302017_3v64x8m81_0/S_uq1
+ nmos_5p04310591302017_3v64x8m81_0/S_uq0 nmos_5p04310591302017_3v64x8m81_0/S a_593_n34#
+ a_n210_n34# VSUBS nmos_5p04310591302017_3v64x8m81
.ends

.subckt pmos_5p04310591302018_3v64x8m81 D_uq1 a_20_n45# D_uq0 D a_181_n45# S_uq2 a_502_n45#
+ S_uq1 a_662_n45# a_n140_n45# S_uq0 S a_341_n45# w_n314_n86#
X0 S a_341_n45# D w_n314_n86# pfet_03v3 ad=0.27692p pd=1.58u as=0.2743p ps=1.575u w=1.055u l=0.28u
X1 S_uq0 a_662_n45# D_uq0 w_n314_n86# pfet_03v3 ad=0.4642p pd=2.99u as=0.2743p ps=1.575u w=1.055u l=0.28u
X2 D_uq0 a_502_n45# S w_n314_n86# pfet_03v3 ad=0.2743p pd=1.575u as=0.27692p ps=1.58u w=1.055u l=0.28u
X3 S_uq1 a_20_n45# D_uq1 w_n314_n86# pfet_03v3 ad=0.27692p pd=1.58u as=0.2743p ps=1.575u w=1.055u l=0.28u
X4 D a_181_n45# S_uq1 w_n314_n86# pfet_03v3 ad=0.2743p pd=1.575u as=0.27692p ps=1.58u w=1.055u l=0.28u
X5 D_uq1 a_n140_n45# S_uq2 w_n314_n86# pfet_03v3 ad=0.2743p pd=1.575u as=0.4642p ps=2.99u w=1.055u l=0.28u
.ends

.subckt pmos_1p2$$46549036_3v64x8m81 a_327_n34# w_n188_n50# pmos_5p04310591302018_3v64x8m81_0/D_uq1
+ pmos_5p04310591302018_3v64x8m81_0/D_uq0 pmos_5p04310591302018_3v64x8m81_0/D a_488_n34#
+ a_n154_n34# a_167_n34# pmos_5p04310591302018_3v64x8m81_0/S_uq2 pmos_5p04310591302018_3v64x8m81_0/S
+ pmos_5p04310591302018_3v64x8m81_0/S_uq1 pmos_5p04310591302018_3v64x8m81_0/S_uq0
+ a_6_n34# a_648_n34#
Xpmos_5p04310591302018_3v64x8m81_0 pmos_5p04310591302018_3v64x8m81_0/D_uq1 a_6_n34#
+ pmos_5p04310591302018_3v64x8m81_0/D_uq0 pmos_5p04310591302018_3v64x8m81_0/D a_167_n34#
+ pmos_5p04310591302018_3v64x8m81_0/S_uq2 a_488_n34# pmos_5p04310591302018_3v64x8m81_0/S_uq1
+ a_648_n34# a_n154_n34# pmos_5p04310591302018_3v64x8m81_0/S_uq0 pmos_5p04310591302018_3v64x8m81_0/S
+ a_327_n34# w_n188_n50# pmos_5p04310591302018_3v64x8m81
.ends

.subckt nmos_5p04310591302015_3v64x8m81 D a_0_n44# S VSUBS
X0 D a_0_n44# S VSUBS nfet_03v3 ad=0.6996p pd=4.06u as=0.6996p ps=4.06u w=1.59u l=0.28u
.ends

.subckt nmos_1p2$$46553132_3v64x8m81 nmos_5p04310591302015_3v64x8m81_0/D a_n14_n34#
+ nmos_5p04310591302015_3v64x8m81_0/S VSUBS
Xnmos_5p04310591302015_3v64x8m81_0 nmos_5p04310591302015_3v64x8m81_0/D a_n14_n34#
+ nmos_5p04310591302015_3v64x8m81_0/S VSUBS nmos_5p04310591302015_3v64x8m81
.ends

.subckt pmos_5p04310591302021_3v64x8m81 a_76_n44# D_uq0 D a_n84_n44# w_n258_n86# S_uq1
+ S_uq0 S a_237_n44# a_397_n44#
X0 S_uq0 a_397_n44# D_uq0 w_n258_n86# pfet_03v3 ad=0.1848p pd=1.72u as=0.1092p ps=0.94u w=0.42u l=0.28u
X1 D_uq0 a_237_n44# S w_n258_n86# pfet_03v3 ad=0.1092p pd=0.94u as=0.11025p ps=0.945u w=0.42u l=0.28u
X2 D a_n84_n44# S_uq1 w_n258_n86# pfet_03v3 ad=0.1092p pd=0.94u as=0.1848p ps=1.72u w=0.42u l=0.28u
X3 S a_76_n44# D w_n258_n86# pfet_03v3 ad=0.11025p pd=0.945u as=0.1092p ps=0.94u w=0.42u l=0.28u
.ends

.subckt pmos_1p2$$46896172_3v64x8m81 w_n133_n66# pmos_5p04310591302021_3v64x8m81_0/a_237_n44#
+ pmos_5p04310591302021_3v64x8m81_0/S pmos_5p04310591302021_3v64x8m81_0/a_397_n44#
+ pmos_5p04310591302021_3v64x8m81_0/S_uq1 pmos_5p04310591302021_3v64x8m81_0/S_uq0
+ pmos_5p04310591302021_3v64x8m81_0/D pmos_5p04310591302021_3v64x8m81_0/D_uq0 pmos_5p04310591302021_3v64x8m81_0/a_76_n44#
+ pmos_5p04310591302021_3v64x8m81_0/a_n84_n44#
Xpmos_5p04310591302021_3v64x8m81_0 pmos_5p04310591302021_3v64x8m81_0/a_76_n44# pmos_5p04310591302021_3v64x8m81_0/D_uq0
+ pmos_5p04310591302021_3v64x8m81_0/D pmos_5p04310591302021_3v64x8m81_0/a_n84_n44#
+ w_n133_n66# pmos_5p04310591302021_3v64x8m81_0/S_uq1 pmos_5p04310591302021_3v64x8m81_0/S_uq0
+ pmos_5p04310591302021_3v64x8m81_0/S pmos_5p04310591302021_3v64x8m81_0/a_237_n44#
+ pmos_5p04310591302021_3v64x8m81_0/a_397_n44# pmos_5p04310591302021_3v64x8m81
.ends

.subckt pmos_1p2$$46897196_3v64x8m81 w_n133_n66# a_n42_n34# pmos_5p04310591302020_3v64x8m81_0/D
+ a_118_n34# pmos_5p04310591302020_3v64x8m81_0/S_uq0 pmos_5p04310591302020_3v64x8m81_0/S
Xpmos_5p04310591302020_3v64x8m81_0 pmos_5p04310591302020_3v64x8m81_0/D a_n42_n34#
+ a_118_n34# w_n133_n66# pmos_5p04310591302020_3v64x8m81_0/S_uq0 pmos_5p04310591302020_3v64x8m81_0/S
+ pmos_5p04310591302020_3v64x8m81
.ends

.subckt nmos_5p04310591302016_3v64x8m81 D_uq2 a_124_n45# D_uq1 a_284_n45# D_uq0 D
+ a_446_n45# a_768_n45# a_n198_n45# a_n38_n45# S_uq2 S_uq3 S_uq1 S_uq0 a_606_n45#
+ S a_928_n45# VSUBS
X0 S_uq0 a_928_n45# D_uq0 VSUBS nfet_03v3 ad=0.7155p pd=4.08u as=0.4134p ps=2.11u w=1.59u l=0.28u
X1 D_uq2 a_n198_n45# S_uq3 VSUBS nfet_03v3 ad=0.4134p pd=2.11u as=0.70755p ps=4.07u w=1.59u l=0.28u
X2 S_uq2 a_n38_n45# D_uq2 VSUBS nfet_03v3 ad=0.42135p pd=2.12u as=0.4134p ps=2.11u w=1.59u l=0.28u
X3 S a_606_n45# D VSUBS nfet_03v3 ad=0.42135p pd=2.12u as=0.4134p ps=2.11u w=1.59u l=0.28u
X4 D_uq0 a_768_n45# S VSUBS nfet_03v3 ad=0.4134p pd=2.11u as=0.42135p ps=2.12u w=1.59u l=0.28u
X5 D a_446_n45# S_uq1 VSUBS nfet_03v3 ad=0.4134p pd=2.11u as=0.42135p ps=2.12u w=1.59u l=0.28u
X6 S_uq1 a_284_n45# D_uq1 VSUBS nfet_03v3 ad=0.42135p pd=2.12u as=0.4134p ps=2.11u w=1.59u l=0.28u
X7 D_uq1 a_124_n45# S_uq2 VSUBS nfet_03v3 ad=0.4134p pd=2.11u as=0.42135p ps=2.12u w=1.59u l=0.28u
.ends

.subckt nmos_1p2$$46552108_3v64x8m81 nmos_5p04310591302016_3v64x8m81_0/a_606_n45#
+ nmos_5p04310591302016_3v64x8m81_0/S nmos_5p04310591302016_3v64x8m81_0/D_uq2 nmos_5p04310591302016_3v64x8m81_0/D_uq1
+ nmos_5p04310591302016_3v64x8m81_0/a_928_n45# nmos_5p04310591302016_3v64x8m81_0/D_uq0
+ nmos_5p04310591302016_3v64x8m81_0/a_124_n45# nmos_5p04310591302016_3v64x8m81_0/a_284_n45#
+ nmos_5p04310591302016_3v64x8m81_0/a_n198_n45# nmos_5p04310591302016_3v64x8m81_0/D
+ nmos_5p04310591302016_3v64x8m81_0/a_446_n45# nmos_5p04310591302016_3v64x8m81_0/a_768_n45#
+ nmos_5p04310591302016_3v64x8m81_0/S_uq3 nmos_5p04310591302016_3v64x8m81_0/S_uq2
+ nmos_5p04310591302016_3v64x8m81_0/a_n38_n45# nmos_5p04310591302016_3v64x8m81_0/S_uq1
+ nmos_5p04310591302016_3v64x8m81_0/S_uq0 VSUBS
Xnmos_5p04310591302016_3v64x8m81_0 nmos_5p04310591302016_3v64x8m81_0/D_uq2 nmos_5p04310591302016_3v64x8m81_0/a_124_n45#
+ nmos_5p04310591302016_3v64x8m81_0/D_uq1 nmos_5p04310591302016_3v64x8m81_0/a_284_n45#
+ nmos_5p04310591302016_3v64x8m81_0/D_uq0 nmos_5p04310591302016_3v64x8m81_0/D nmos_5p04310591302016_3v64x8m81_0/a_446_n45#
+ nmos_5p04310591302016_3v64x8m81_0/a_768_n45# nmos_5p04310591302016_3v64x8m81_0/a_n198_n45#
+ nmos_5p04310591302016_3v64x8m81_0/a_n38_n45# nmos_5p04310591302016_3v64x8m81_0/S_uq2
+ nmos_5p04310591302016_3v64x8m81_0/S_uq3 nmos_5p04310591302016_3v64x8m81_0/S_uq1
+ nmos_5p04310591302016_3v64x8m81_0/S_uq0 nmos_5p04310591302016_3v64x8m81_0/a_606_n45#
+ nmos_5p04310591302016_3v64x8m81_0/S nmos_5p04310591302016_3v64x8m81_0/a_928_n45#
+ VSUBS nmos_5p04310591302016_3v64x8m81
.ends

.subckt pmos_5p04310591302019_3v64x8m81 D a_0_n44# w_n174_n86# S
X0 D a_0_n44# S w_n174_n86# pfet_03v3 ad=0.1848p pd=1.72u as=0.1848p ps=1.72u w=0.42u l=0.28u
.ends

.subckt pmos_1p2$$46898220_3v64x8m81 w_n133_n66# pmos_5p04310591302019_3v64x8m81_0/S
+ pmos_5p04310591302019_3v64x8m81_0/D a_n14_84#
Xpmos_5p04310591302019_3v64x8m81_0 pmos_5p04310591302019_3v64x8m81_0/D a_n14_84# w_n133_n66#
+ pmos_5p04310591302019_3v64x8m81_0/S pmos_5p04310591302019_3v64x8m81
.ends

.subckt nmos_1p2$$45107244_3v64x8m81 nmos_5p04310591302012_3v64x8m81_0/D a_223_n34#
+ a_383_n34# nmos_5p04310591302012_3v64x8m81_0/S_uq1 nmos_5p04310591302012_3v64x8m81_0/S_uq0
+ a_n96_n34# nmos_5p04310591302012_3v64x8m81_0/S nmos_5p04310591302012_3v64x8m81_0/D_uq0
+ a_63_n34# VSUBS
Xnmos_5p04310591302012_3v64x8m81_0 a_n96_n34# nmos_5p04310591302012_3v64x8m81_0/D_uq0
+ nmos_5p04310591302012_3v64x8m81_0/D a_63_n34# nmos_5p04310591302012_3v64x8m81_0/S_uq1
+ nmos_5p04310591302012_3v64x8m81_0/S_uq0 nmos_5p04310591302012_3v64x8m81_0/S a_223_n34#
+ a_383_n34# VSUBS nmos_5p04310591302012_3v64x8m81
.ends

.subckt sa_3v64x8m81 qp qn wep se pcb db vdd pmos_1p2$$46898220_3v64x8m81_1/pmos_5p04310591302019_3v64x8m81_0/D
+ d vss
Xnmos_1p2$$46550060_3v64x8m81_0 se vss vss vss vss se vss se se se se se nmos_1p2$$46552108_3v64x8m81_0/nmos_5p04310591302016_3v64x8m81_0/D
+ se nmos_1p2$$46552108_3v64x8m81_0/nmos_5p04310591302016_3v64x8m81_0/D nmos_1p2$$46552108_3v64x8m81_0/nmos_5p04310591302016_3v64x8m81_0/D
+ nmos_1p2$$46552108_3v64x8m81_0/nmos_5p04310591302016_3v64x8m81_0/D vss nmos_1p2$$46550060_3v64x8m81
Xnmos_1p2$$46551084_3v64x8m81_0 vss pmos_1p2$$46898220_3v64x8m81_1/pmos_5p04310591302019_3v64x8m81_0/S
+ nmos_1p2$$46551084_3v64x8m81_0/nmos_5p04310591302010_3v64x8m81_0/S vss nmos_1p2$$46551084_3v64x8m81
Xpmos_1p2$$46549036_3v64x8m81_0 nmos_1p2$$46551084_3v64x8m81_0/nmos_5p04310591302010_3v64x8m81_0/S
+ vdd qn nmos_1p2$$46551084_3v64x8m81_0/nmos_5p04310591302010_3v64x8m81_0/S qp pmos_1p2$$46898220_3v64x8m81_1/pmos_5p04310591302019_3v64x8m81_0/S
+ pmos_1p2$$46897196_3v64x8m81_2/pmos_5p04310591302020_3v64x8m81_0/D nmos_1p2$$46551084_3v64x8m81_0/nmos_5p04310591302010_3v64x8m81_0/S
+ vdd vdd vdd vdd pmos_1p2$$46897196_3v64x8m81_2/pmos_5p04310591302020_3v64x8m81_0/D
+ pmos_1p2$$46898220_3v64x8m81_1/pmos_5p04310591302019_3v64x8m81_0/S pmos_1p2$$46549036_3v64x8m81
Xnmos_1p2$$46553132_3v64x8m81_0 vss vss pmos_1p2$$46897196_3v64x8m81_2/pmos_5p04310591302020_3v64x8m81_0/D
+ vss nmos_1p2$$46553132_3v64x8m81
Xnmos_1p2$$46553132_3v64x8m81_1 pmos_1p2$$46897196_3v64x8m81_2/pmos_5p04310591302020_3v64x8m81_0/D
+ vss vss vss nmos_1p2$$46553132_3v64x8m81
Xpmos_1p2$$46285868_3v64x8m81_0 pmos_1p2$$46898220_3v64x8m81_1/pmos_5p04310591302019_3v64x8m81_0/D
+ pmos_1p2$$46897196_3v64x8m81_2/pmos_5p04310591302020_3v64x8m81_0/D pmos_1p2$$46898220_3v64x8m81_1/pmos_5p04310591302019_3v64x8m81_0/S
+ pcb pmos_1p2$$46285868_3v64x8m81
Xpmos_1p2$$46896172_3v64x8m81_0 pmos_1p2$$46898220_3v64x8m81_1/pmos_5p04310591302019_3v64x8m81_0/D
+ pmos_1p2$$46898220_3v64x8m81_1/pmos_5p04310591302019_3v64x8m81_0/S pmos_1p2$$46897196_3v64x8m81_2/pmos_5p04310591302020_3v64x8m81_0/D
+ pmos_1p2$$46897196_3v64x8m81_2/pmos_5p04310591302020_3v64x8m81_0/D pmos_1p2$$46898220_3v64x8m81_1/pmos_5p04310591302019_3v64x8m81_0/S
+ pmos_1p2$$46898220_3v64x8m81_1/pmos_5p04310591302019_3v64x8m81_0/S pmos_1p2$$46898220_3v64x8m81_1/pmos_5p04310591302019_3v64x8m81_0/D
+ pmos_1p2$$46898220_3v64x8m81_1/pmos_5p04310591302019_3v64x8m81_0/D pmos_1p2$$46898220_3v64x8m81_1/pmos_5p04310591302019_3v64x8m81_0/S
+ pmos_1p2$$46897196_3v64x8m81_2/pmos_5p04310591302020_3v64x8m81_0/D pmos_1p2$$46896172_3v64x8m81
Xpmos_1p2$$46897196_3v64x8m81_0 pmos_1p2$$46898220_3v64x8m81_1/pmos_5p04310591302019_3v64x8m81_0/D
+ se pmos_1p2$$46898220_3v64x8m81_1/pmos_5p04310591302019_3v64x8m81_0/S se d d pmos_1p2$$46897196_3v64x8m81
Xpmos_1p2$$46897196_3v64x8m81_1 pmos_1p2$$46898220_3v64x8m81_1/pmos_5p04310591302019_3v64x8m81_0/D
+ se pmos_1p2$$46897196_3v64x8m81_2/pmos_5p04310591302020_3v64x8m81_0/D se db db pmos_1p2$$46897196_3v64x8m81
Xpmos_1p2$$46897196_3v64x8m81_2 pmos_1p2$$46898220_3v64x8m81_1/pmos_5p04310591302019_3v64x8m81_0/D
+ se pmos_1p2$$46897196_3v64x8m81_2/pmos_5p04310591302020_3v64x8m81_0/D se db db pmos_1p2$$46897196_3v64x8m81
Xnmos_1p2$$46552108_3v64x8m81_0 pmos_1p2$$46897196_3v64x8m81_2/pmos_5p04310591302020_3v64x8m81_0/D
+ pmos_1p2$$46898220_3v64x8m81_1/pmos_5p04310591302019_3v64x8m81_0/S nmos_1p2$$46552108_3v64x8m81_0/nmos_5p04310591302016_3v64x8m81_0/D
+ nmos_1p2$$46552108_3v64x8m81_0/nmos_5p04310591302016_3v64x8m81_0/D pmos_1p2$$46898220_3v64x8m81_1/pmos_5p04310591302019_3v64x8m81_0/S
+ nmos_1p2$$46552108_3v64x8m81_0/nmos_5p04310591302016_3v64x8m81_0/D pmos_1p2$$46897196_3v64x8m81_2/pmos_5p04310591302020_3v64x8m81_0/D
+ pmos_1p2$$46898220_3v64x8m81_1/pmos_5p04310591302019_3v64x8m81_0/S pmos_1p2$$46898220_3v64x8m81_1/pmos_5p04310591302019_3v64x8m81_0/S
+ nmos_1p2$$46552108_3v64x8m81_0/nmos_5p04310591302016_3v64x8m81_0/D pmos_1p2$$46898220_3v64x8m81_1/pmos_5p04310591302019_3v64x8m81_0/S
+ pmos_1p2$$46897196_3v64x8m81_2/pmos_5p04310591302020_3v64x8m81_0/D pmos_1p2$$46897196_3v64x8m81_2/pmos_5p04310591302020_3v64x8m81_0/D
+ pmos_1p2$$46898220_3v64x8m81_1/pmos_5p04310591302019_3v64x8m81_0/S pmos_1p2$$46897196_3v64x8m81_2/pmos_5p04310591302020_3v64x8m81_0/D
+ pmos_1p2$$46897196_3v64x8m81_2/pmos_5p04310591302020_3v64x8m81_0/D pmos_1p2$$46897196_3v64x8m81_2/pmos_5p04310591302020_3v64x8m81_0/D
+ vss nmos_1p2$$46552108_3v64x8m81
Xpmos_1p2$$46898220_3v64x8m81_0 pmos_1p2$$46898220_3v64x8m81_1/pmos_5p04310591302019_3v64x8m81_0/D
+ pmos_1p2$$46898220_3v64x8m81_1/pmos_5p04310591302019_3v64x8m81_0/D pmos_1p2$$46898220_3v64x8m81_1/pmos_5p04310591302019_3v64x8m81_0/S
+ pmos_1p2$$46898220_3v64x8m81_1/pmos_5p04310591302019_3v64x8m81_0/D pmos_1p2$$46898220_3v64x8m81
Xpmos_1p2$$46897196_3v64x8m81_3 pmos_1p2$$46898220_3v64x8m81_1/pmos_5p04310591302019_3v64x8m81_0/D
+ se pmos_1p2$$46898220_3v64x8m81_1/pmos_5p04310591302019_3v64x8m81_0/S se d d pmos_1p2$$46897196_3v64x8m81
Xpmos_1p2$$46898220_3v64x8m81_1 pmos_1p2$$46898220_3v64x8m81_1/pmos_5p04310591302019_3v64x8m81_0/D
+ pmos_1p2$$46898220_3v64x8m81_1/pmos_5p04310591302019_3v64x8m81_0/S pmos_1p2$$46898220_3v64x8m81_1/pmos_5p04310591302019_3v64x8m81_0/D
+ pmos_1p2$$46898220_3v64x8m81_1/pmos_5p04310591302019_3v64x8m81_0/D pmos_1p2$$46898220_3v64x8m81
Xpmos_1p2$$46286892_3v64x8m81_0 pmos_1p2$$46898220_3v64x8m81_1/pmos_5p04310591302019_3v64x8m81_0/D
+ d db pcb pcb pmos_1p2$$46898220_3v64x8m81_1/pmos_5p04310591302019_3v64x8m81_0/D
+ pcb pmos_1p2$$46898220_3v64x8m81_1/pmos_5p04310591302019_3v64x8m81_0/D pmos_1p2$$46286892_3v64x8m81
Xnmos_1p2$$45107244_3v64x8m81_0 vss nmos_1p2$$46551084_3v64x8m81_0/nmos_5p04310591302010_3v64x8m81_0/S
+ nmos_1p2$$46551084_3v64x8m81_0/nmos_5p04310591302010_3v64x8m81_0/S qn qp pmos_1p2$$46897196_3v64x8m81_2/pmos_5p04310591302020_3v64x8m81_0/D
+ qp vss nmos_1p2$$46551084_3v64x8m81_0/nmos_5p04310591302010_3v64x8m81_0/S vss nmos_1p2$$45107244_3v64x8m81
.ends

.subckt nmos_5p04310591302052_3v64x8m81 D a_0_n44# S VSUBS
X0 D a_0_n44# S VSUBS nfet_03v3 ad=0.3278p pd=2.37u as=0.3278p ps=2.37u w=0.745u l=0.28u
.ends

.subckt nmos_5p04310591302050_3v64x8m81 D_uq0 D a_265_n44# S_uq0 S a_n56_n44# a_104_n44#
+ VSUBS
X0 D_uq0 a_265_n44# S_uq0 VSUBS nfet_03v3 ad=0.4642p pd=2.99u as=0.27692p ps=1.58u w=1.055u l=0.28u
X1 D a_n56_n44# S VSUBS nfet_03v3 ad=0.2743p pd=1.575u as=0.4642p ps=2.99u w=1.055u l=0.28u
X2 S_uq0 a_104_n44# D VSUBS nfet_03v3 ad=0.27692p pd=1.58u as=0.2743p ps=1.575u w=1.055u l=0.28u
.ends

.subckt pmos_5p04310591302049_3v64x8m81 a_20_n44# D_uq1 D_uq0 D a_181_n44# S_uq2 S_uq1
+ a_n140_n44# S_uq0 S a_341_n44# a_503_n44# a_663_n44# w_n314_n86#
X0 S a_341_n44# D w_n314_n86# pfet_03v3 ad=0.4664p pd=2.29u as=0.4576p ps=2.28u w=1.76u l=0.28u
X1 S_uq1 a_20_n44# D_uq1 w_n314_n86# pfet_03v3 ad=0.462p pd=2.285u as=0.4576p ps=2.28u w=1.76u l=0.28u
X2 D a_181_n44# S_uq1 w_n314_n86# pfet_03v3 ad=0.4576p pd=2.28u as=0.462p ps=2.285u w=1.76u l=0.28u
X3 D_uq1 a_n140_n44# S_uq2 w_n314_n86# pfet_03v3 ad=0.4576p pd=2.28u as=0.7744p ps=4.4u w=1.76u l=0.28u
X4 S_uq0 a_663_n44# D_uq0 w_n314_n86# pfet_03v3 ad=0.7832p pd=4.41u as=0.4576p ps=2.28u w=1.76u l=0.28u
X5 D_uq0 a_503_n44# S w_n314_n86# pfet_03v3 ad=0.4576p pd=2.28u as=0.4664p ps=2.29u w=1.76u l=0.28u
.ends

.subckt pmos_5p04310591302048_3v64x8m81 D a_0_n44# w_n174_n86# S
X0 D a_0_n44# S w_n174_n86# pfet_03v3 ad=0.924p pd=5.08u as=0.924p ps=5.08u w=2.1u l=0.28u
.ends

.subckt pmos_5p04310591302047_3v64x8m81 D a_0_n44# w_n174_n86# S
X0 D a_0_n44# S w_n174_n86# pfet_03v3 ad=0.8206p pd=4.61u as=0.8206p ps=4.61u w=1.865u l=0.28u
.ends

.subckt pmos_1p2$$171625516_3v64x8m81 a_n42_n34# pmos_5p0431059130203_3v64x8m81_0/S_uq0
+ pmos_5p0431059130203_3v64x8m81_0/S pmos_5p0431059130203_3v64x8m81_0/w_n202_n86#
+ a_118_n34# pmos_5p0431059130203_3v64x8m81_0/D
Xpmos_5p0431059130203_3v64x8m81_0 pmos_5p0431059130203_3v64x8m81_0/D a_n42_n34# a_118_n34#
+ pmos_5p0431059130203_3v64x8m81_0/w_n202_n86# pmos_5p0431059130203_3v64x8m81_0/S_uq0
+ pmos_5p0431059130203_3v64x8m81_0/S pmos_5p0431059130203_3v64x8m81
.ends

.subckt nmos_5p04310591302046_3v64x8m81 a_20_n44# D_uq1 D_uq0 D a_181_n44# a_502_n44#
+ S_uq2 a_662_n44# S_uq1 a_n140_n44# S_uq0 S a_341_n44# VSUBS
X0 S a_341_n44# D VSUBS nfet_03v3 ad=0.25855p pd=1.51u as=0.2561p ps=1.505u w=0.985u l=0.28u
X1 S_uq0 a_662_n44# D_uq0 VSUBS nfet_03v3 ad=0.4334p pd=2.85u as=0.2561p ps=1.505u w=0.985u l=0.28u
X2 D_uq0 a_502_n44# S VSUBS nfet_03v3 ad=0.2561p pd=1.505u as=0.25855p ps=1.51u w=0.985u l=0.28u
X3 S_uq1 a_20_n44# D_uq1 VSUBS nfet_03v3 ad=0.25855p pd=1.51u as=0.2561p ps=1.505u w=0.985u l=0.28u
X4 D a_181_n44# S_uq1 VSUBS nfet_03v3 ad=0.2561p pd=1.505u as=0.25855p ps=1.51u w=0.985u l=0.28u
X5 D_uq1 a_n140_n44# S_uq2 VSUBS nfet_03v3 ad=0.2561p pd=1.505u as=0.4334p ps=2.85u w=0.985u l=0.28u
.ends

.subckt nmos_5p04310591302045_3v64x8m81 D a_n28_n44# a_132_n44# S_uq0 S VSUBS
X0 D a_n28_n44# S VSUBS nfet_03v3 ad=0.3445p pd=1.845u as=0.583p ps=3.53u w=1.325u l=0.28u
X1 S_uq0 a_132_n44# D VSUBS nfet_03v3 ad=0.583p pd=3.53u as=0.3445p ps=1.845u w=1.325u l=0.28u
.ends

.subckt nmos_5p04310591302044_3v64x8m81 D a_0_n44# S VSUBS
X0 D a_0_n44# S VSUBS nfet_03v3 ad=0.451p pd=2.93u as=0.451p ps=2.93u w=1.025u l=0.28u
.ends

.subckt outbuf_oe_3v64x8m81 qp qn se q GWE vdd vss
Xnmos_5p04310591302052_3v64x8m81_0 vss GWE pmos_5p04310591302047_3v64x8m81_0/S vss
+ nmos_5p04310591302052_3v64x8m81
Xpmos_5p04310591302038_3v64x8m81_0 pmos_5p04310591302038_3v64x8m81_0/D pmos_5p04310591302051_3v64x8m81_0/D
+ vdd vdd pmos_5p04310591302038_3v64x8m81
Xnmos_5p04310591302050_3v64x8m81_0 nmos_5p0431059130208_3v64x8m81_1/S nmos_5p0431059130208_3v64x8m81_1/S
+ nmos_5p0431059130208_3v64x8m81_0/D pmos_5p04310591302051_3v64x8m81_0/D pmos_5p04310591302051_3v64x8m81_0/D
+ nmos_5p0431059130208_3v64x8m81_0/D nmos_5p0431059130208_3v64x8m81_0/D vss nmos_5p04310591302050_3v64x8m81
Xpmos_5p04310591302049_3v64x8m81_0 pmos_5p04310591302051_3v64x8m81_0/D vdd vdd vdd
+ pmos_5p04310591302051_3v64x8m81_0/D q q pmos_5p04310591302051_3v64x8m81_0/D q q
+ pmos_5p04310591302051_3v64x8m81_0/D pmos_5p04310591302051_3v64x8m81_0/D pmos_5p04310591302051_3v64x8m81_0/D
+ vdd pmos_5p04310591302049_3v64x8m81
Xpmos_5p04310591302048_3v64x8m81_0 vdd pmos_5p04310591302047_3v64x8m81_0/S vdd pmos_5p04310591302048_3v64x8m81_0/S
+ pmos_5p04310591302048_3v64x8m81
Xpmos_5p04310591302047_3v64x8m81_0 vdd GWE vdd pmos_5p04310591302047_3v64x8m81_0/S
+ pmos_5p04310591302047_3v64x8m81
Xnmos_5p0431059130208_3v64x8m81_0 nmos_5p0431059130208_3v64x8m81_0/D se vss vss nmos_5p0431059130208_3v64x8m81
Xnmos_5p0431059130208_3v64x8m81_1 vss pmos_5p04310591302038_3v64x8m81_0/D nmos_5p0431059130208_3v64x8m81_1/S
+ vss nmos_5p0431059130208_3v64x8m81
Xpmos_1p2$$171625516_3v64x8m81_0 pmos_5p04310591302038_3v64x8m81_0/D vdd vdd vdd pmos_5p04310591302038_3v64x8m81_0/D
+ nmos_5p0431059130208_3v64x8m81_1/S pmos_1p2$$171625516_3v64x8m81
Xnmos_5p04310591302033_3v64x8m81_0 pmos_5p04310591302038_3v64x8m81_0/D pmos_5p04310591302051_3v64x8m81_0/D
+ vss vss nmos_5p04310591302033_3v64x8m81
Xpmos_5p04310591302051_3v64x8m81_0 pmos_5p04310591302051_3v64x8m81_0/D qp qp vdd pmos_5p04310591302051_3v64x8m81_1/S
+ pmos_5p04310591302051_3v64x8m81_1/S pmos_5p04310591302051_3v64x8m81
Xpmos_5p04310591302051_3v64x8m81_1 vdd pmos_5p04310591302048_3v64x8m81_0/S pmos_5p04310591302048_3v64x8m81_0/S
+ vdd pmos_5p04310591302051_3v64x8m81_1/S pmos_5p04310591302051_3v64x8m81_1/S pmos_5p04310591302051_3v64x8m81
Xpmos_5p04310591302014_3v64x8m81_0 nmos_5p0431059130208_3v64x8m81_0/D se vdd vdd pmos_5p04310591302014_3v64x8m81
Xnmos_5p04310591302046_3v64x8m81_0 pmos_5p04310591302051_3v64x8m81_0/D vss vss vss
+ pmos_5p04310591302051_3v64x8m81_0/D pmos_5p04310591302051_3v64x8m81_0/D q pmos_5p04310591302051_3v64x8m81_0/D
+ q pmos_5p04310591302051_3v64x8m81_0/D q q pmos_5p04310591302051_3v64x8m81_0/D vss
+ nmos_5p04310591302046_3v64x8m81
Xpmos_5p04310591302013_3v64x8m81_0 nmos_5p0431059130208_3v64x8m81_1/S nmos_5p0431059130208_3v64x8m81_1/S
+ se pmos_5p04310591302051_3v64x8m81_0/D pmos_5p04310591302051_3v64x8m81_0/D se se
+ vdd pmos_5p04310591302013_3v64x8m81
Xnmos_5p04310591302045_3v64x8m81_0 vss pmos_5p04310591302047_3v64x8m81_0/S pmos_5p04310591302047_3v64x8m81_0/S
+ nmos_5p04310591302045_3v64x8m81_1/S nmos_5p04310591302045_3v64x8m81_1/S vss nmos_5p04310591302045_3v64x8m81
Xnmos_5p04310591302044_3v64x8m81_0 vss pmos_5p04310591302047_3v64x8m81_0/S pmos_5p04310591302048_3v64x8m81_0/S
+ vss nmos_5p04310591302044_3v64x8m81
Xnmos_5p04310591302045_3v64x8m81_1 pmos_5p04310591302051_3v64x8m81_0/D qn qn nmos_5p04310591302045_3v64x8m81_1/S
+ nmos_5p04310591302045_3v64x8m81_1/S vss nmos_5p04310591302045_3v64x8m81
.ends

.subckt nmos_5p0431059130202_3v64x8m81 D a_n32_n44# a_136_n44# S_uq0 S VSUBS
X0 D a_n32_n44# S VSUBS nfet_03v3 ad=91.3f pd=0.92u as=0.1561p ps=1.64u w=0.265u l=0.28u
X1 S_uq0 a_136_n44# D VSUBS nfet_03v3 ad=0.15742p pd=1.65u as=91.3f ps=0.92u w=0.265u l=0.28u
.ends

.subckt nmos_5p0431059130200_3v64x8m81 D a_0_n44# S VSUBS
X0 D a_0_n44# S VSUBS nfet_03v3 ad=1.397p pd=7.23u as=1.397p ps=7.23u w=3.175u l=0.28u
.ends

.subckt nmos_1p2$$47119404_3v64x8m81 a_n14_n34# nmos_5p0431059130200_3v64x8m81_0/S
+ VSUBS nmos_5p0431059130200_3v64x8m81_0/D
Xnmos_5p0431059130200_3v64x8m81_0 nmos_5p0431059130200_3v64x8m81_0/D a_n14_n34# nmos_5p0431059130200_3v64x8m81_0/S
+ VSUBS nmos_5p0431059130200_3v64x8m81
.ends

.subckt ypass_gate_a_3v64x8m81 vss b bb ypass pcb vdd_uq0 m3_n41_6881# pmos_5p0431059130201_3v64x8m81_1/D
+ m3_n41_5924# m3_n41_6639# m3_n41_4610# m3_n41_5682# VSUBS vdd m3_n41_5198# m3_n41_5440#
+ m3_n41_6156# pmos_1p2$$46889004_3v64x8m81_1/pmos_5p0431059130201_3v64x8m81_0/D
Xnmos_5p0431059130202_3v64x8m81_0 ypassb ypass ypass VSUBS VSUBS VSUBS nmos_5p0431059130202_3v64x8m81
Xpmos_1p2$$46889004_3v64x8m81_1 b ypassb pmos_1p2$$46889004_3v64x8m81_1/pmos_5p0431059130201_3v64x8m81_0/D
+ vdd_uq0 pmos_1p2$$46889004_3v64x8m81
Xpmos_5p0431059130201_3v64x8m81_0 b pcb vdd bb pmos_5p0431059130201_3v64x8m81
Xpmos_5p0431059130201_3v64x8m81_1 pmos_5p0431059130201_3v64x8m81_1/D ypassb vdd bb
+ pmos_5p0431059130201_3v64x8m81
Xnmos_1p2$$47119404_3v64x8m81_1 ypass b VSUBS pmos_1p2$$46889004_3v64x8m81_1/pmos_5p0431059130201_3v64x8m81_0/D
+ nmos_1p2$$47119404_3v64x8m81
Xnmos_1p2$$47119404_3v64x8m81_3 ypass bb VSUBS pmos_5p0431059130201_3v64x8m81_1/D
+ nmos_1p2$$47119404_3v64x8m81
X0 vdd pcb b vdd pfet_03v3 ad=1.06988p pd=4.52u as=0.4121p ps=2.105u w=1.585u l=0.28u
X1 b pcb vdd vdd pfet_03v3 ad=0.4121p pd=2.105u as=0.99855p ps=4.43u w=1.585u l=0.28u
X2 vdd_uq0 ypass ypassb vdd_uq0 pfet_03v3 ad=0.5143p pd=2.87u as=0.34055p ps=1.675u w=0.695u l=0.28u
X3 vdd pcb bb vdd pfet_03v3 ad=1.07325p pd=4.53u as=0.4134p ps=2.11u w=1.59u l=0.28u
X4 bb pcb vdd vdd pfet_03v3 ad=0.4134p pd=2.11u as=1.0017p ps=4.44u w=1.59u l=0.28u
X5 ypassb ypass vdd_uq0 vdd_uq0 pfet_03v3 ad=0.34055p pd=1.675u as=0.38572p ps=2.5u w=0.695u l=0.28u
.ends

.subckt ypass_gate_3v64x8m81 vdd b bb ypass pcb vdd_uq0 m3_n41_6881# m3_n41_5924#
+ m3_n41_6639# m3_n41_4610# m3_n41_5682# m3_n41_6398# db m3_n41_5198# m3_n41_5440#
+ m3_n41_6156# VSUBS pmos_1p2$$46889004_3v64x8m81_1/pmos_5p0431059130201_3v64x8m81_0/D
Xnmos_5p0431059130202_3v64x8m81_0 ypassb ypass ypass VSUBS VSUBS VSUBS nmos_5p0431059130202_3v64x8m81
Xpmos_1p2$$46889004_3v64x8m81_1 b ypassb pmos_1p2$$46889004_3v64x8m81_1/pmos_5p0431059130201_3v64x8m81_0/D
+ vdd_uq0 pmos_1p2$$46889004_3v64x8m81
Xpmos_5p0431059130201_3v64x8m81_0 b pcb vdd bb pmos_5p0431059130201_3v64x8m81
Xpmos_5p0431059130201_3v64x8m81_1 db ypassb vdd bb pmos_5p0431059130201_3v64x8m81
Xnmos_1p2$$47119404_3v64x8m81_1 ypass b VSUBS pmos_1p2$$46889004_3v64x8m81_1/pmos_5p0431059130201_3v64x8m81_0/D
+ nmos_1p2$$47119404_3v64x8m81
Xnmos_1p2$$47119404_3v64x8m81_3 ypass bb VSUBS db nmos_1p2$$47119404_3v64x8m81
X0 vdd pcb b vdd pfet_03v3 ad=0.92722p pd=4.34u as=0.4121p ps=2.105u w=1.585u l=0.28u
X1 b pcb vdd vdd pfet_03v3 ad=0.4121p pd=2.105u as=0.93515p ps=4.35u w=1.585u l=0.28u
X2 ypassb ypass vdd_uq0 vdd_uq0 pfet_03v3 ad=0.26235p pd=1.45u as=0.46218p ps=2.72u w=0.695u l=0.28u
X3 vdd_uq0 ypass ypassb vdd_uq0 pfet_03v3 ad=0.39963p pd=2.54u as=0.26235p ps=1.45u w=0.695u l=0.28u
X4 vdd pcb bb vdd pfet_03v3 ad=0.93015p pd=4.35u as=0.4134p ps=2.11u w=1.59u l=0.28u
X5 bb pcb vdd vdd pfet_03v3 ad=0.4134p pd=2.11u as=0.9381p ps=4.36u w=1.59u l=0.28u
.ends

.subckt mux821_3v64x8m81 bb[4] b[6] b[2] bb[7] bb[0] bb[5] ypass_gate_3v64x8m81_4/pmos_1p2$$46889004_3v64x8m81_1/pmos_5p0431059130201_3v64x8m81_0/D
+ bb[6] ypass_gate_3v64x8m81_4/db b[3] ypass_gate_3v64x8m81_1/db ypass[6] b[0] ypass_gate_3v64x8m81_3/pmos_1p2$$46889004_3v64x8m81_1/pmos_5p0431059130201_3v64x8m81_0/D
+ ypass[4] ypass[3] ypass[7] ypass_gate_3v64x8m81_5/pmos_1p2$$46889004_3v64x8m81_1/pmos_5p0431059130201_3v64x8m81_0/D
+ bb[1] bb[2] ypass_gate_3v64x8m81_7/db ypass_gate_3v64x8m81_5/db ypass_gate_3v64x8m81_6/pmos_1p2$$46889004_3v64x8m81_1/pmos_5p0431059130201_3v64x8m81_0/D
+ ypass_gate_3v64x8m81_2/pmos_1p2$$46889004_3v64x8m81_1/pmos_5p0431059130201_3v64x8m81_0/D
+ ypass_gate_3v64x8m81_7/m3_n41_5924# b[4] b[7] ypass_gate_3v64x8m81_7/pmos_1p2$$46889004_3v64x8m81_1/pmos_5p0431059130201_3v64x8m81_0/D
+ ypass[0] ypass_gate_a_3v64x8m81_0/pmos_1p2$$46889004_3v64x8m81_1/pmos_5p0431059130201_3v64x8m81_0/D
+ b[5] ypass[1] ypass_gate_3v64x8m81_7/m3_n41_5440# ypass[2] ypass_gate_3v64x8m81_7/m3_n41_6156#
+ ypass_gate_3v64x8m81_7/pcb ypass_gate_3v64x8m81_7/vdd b[1] ypass_gate_3v64x8m81_1/pmos_1p2$$46889004_3v64x8m81_1/pmos_5p0431059130201_3v64x8m81_0/D
+ ypass_gate_3v64x8m81_7/m3_n41_6639# ypass_gate_3v64x8m81_7/m3_n41_6881# ypass[5]
+ ypass_gate_3v64x8m81_7/m3_n41_5682# ypass_gate_3v64x8m81_7/m3_n41_5198# bb[3] ypass_gate_a_3v64x8m81_0/vss
+ ypass_gate_3v64x8m81_7/vdd_uq0 VSUBS
Xypass_gate_a_3v64x8m81_0 ypass_gate_a_3v64x8m81_0/vss b[7] bb[7] ypass[7] ypass_gate_3v64x8m81_7/pcb
+ ypass_gate_3v64x8m81_7/vdd_uq0 ypass_gate_3v64x8m81_7/m3_n41_6881# ypass_gate_3v64x8m81_1/db
+ ypass_gate_3v64x8m81_7/m3_n41_5924# ypass_gate_3v64x8m81_7/m3_n41_6639# ypass_gate_3v64x8m81_7/vdd_uq0
+ ypass_gate_3v64x8m81_7/m3_n41_5682# VSUBS ypass_gate_3v64x8m81_7/vdd ypass_gate_3v64x8m81_7/m3_n41_5198#
+ ypass_gate_3v64x8m81_7/m3_n41_5440# ypass_gate_3v64x8m81_7/m3_n41_6156# ypass_gate_a_3v64x8m81_0/pmos_1p2$$46889004_3v64x8m81_1/pmos_5p0431059130201_3v64x8m81_0/D
+ ypass_gate_a_3v64x8m81
Xypass_gate_3v64x8m81_1 ypass_gate_3v64x8m81_7/vdd b[6] bb[6] ypass[6] ypass_gate_3v64x8m81_7/pcb
+ ypass_gate_3v64x8m81_7/vdd_uq0 ypass_gate_3v64x8m81_7/m3_n41_6881# ypass_gate_3v64x8m81_7/m3_n41_5924#
+ ypass_gate_3v64x8m81_7/m3_n41_6639# ypass_gate_3v64x8m81_7/vdd_uq0 ypass_gate_3v64x8m81_7/m3_n41_5682#
+ ypass_gate_a_3v64x8m81_0/vss ypass_gate_3v64x8m81_1/db ypass_gate_3v64x8m81_7/m3_n41_5198#
+ ypass_gate_3v64x8m81_7/m3_n41_5440# ypass_gate_3v64x8m81_7/m3_n41_6156# VSUBS ypass_gate_3v64x8m81_1/pmos_1p2$$46889004_3v64x8m81_1/pmos_5p0431059130201_3v64x8m81_0/D
+ ypass_gate_3v64x8m81
Xypass_gate_3v64x8m81_2 ypass_gate_3v64x8m81_7/vdd b[4] bb[4] ypass[4] ypass_gate_3v64x8m81_7/pcb
+ ypass_gate_3v64x8m81_7/vdd_uq0 ypass_gate_3v64x8m81_7/m3_n41_6881# ypass_gate_3v64x8m81_7/m3_n41_5924#
+ ypass_gate_3v64x8m81_7/m3_n41_6639# ypass_gate_3v64x8m81_7/vdd_uq0 ypass_gate_3v64x8m81_7/m3_n41_5682#
+ ypass_gate_a_3v64x8m81_0/vss ypass_gate_3v64x8m81_4/db ypass_gate_3v64x8m81_7/m3_n41_5198#
+ ypass_gate_3v64x8m81_7/m3_n41_5440# ypass_gate_3v64x8m81_7/m3_n41_6156# VSUBS ypass_gate_3v64x8m81_2/pmos_1p2$$46889004_3v64x8m81_1/pmos_5p0431059130201_3v64x8m81_0/D
+ ypass_gate_3v64x8m81
Xypass_gate_3v64x8m81_3 ypass_gate_3v64x8m81_7/vdd b[2] bb[2] ypass[2] ypass_gate_3v64x8m81_7/pcb
+ ypass_gate_3v64x8m81_7/vdd_uq0 ypass_gate_3v64x8m81_7/m3_n41_6881# ypass_gate_3v64x8m81_7/m3_n41_5924#
+ ypass_gate_3v64x8m81_7/m3_n41_6639# ypass_gate_3v64x8m81_7/vdd_uq0 ypass_gate_3v64x8m81_7/m3_n41_5682#
+ ypass_gate_a_3v64x8m81_0/vss ypass_gate_3v64x8m81_5/db ypass_gate_3v64x8m81_7/m3_n41_5198#
+ ypass_gate_3v64x8m81_7/m3_n41_5440# ypass_gate_3v64x8m81_7/m3_n41_6156# VSUBS ypass_gate_3v64x8m81_3/pmos_1p2$$46889004_3v64x8m81_1/pmos_5p0431059130201_3v64x8m81_0/D
+ ypass_gate_3v64x8m81
Xypass_gate_3v64x8m81_4 ypass_gate_3v64x8m81_7/vdd b[5] bb[5] ypass[5] ypass_gate_3v64x8m81_7/pcb
+ ypass_gate_3v64x8m81_7/vdd_uq0 ypass_gate_3v64x8m81_7/m3_n41_6881# ypass_gate_3v64x8m81_7/m3_n41_5924#
+ ypass_gate_3v64x8m81_7/m3_n41_6639# ypass_gate_3v64x8m81_7/vdd_uq0 ypass_gate_3v64x8m81_7/m3_n41_5682#
+ ypass_gate_a_3v64x8m81_0/vss ypass_gate_3v64x8m81_4/db ypass_gate_3v64x8m81_7/m3_n41_5198#
+ ypass_gate_3v64x8m81_7/m3_n41_5440# ypass_gate_3v64x8m81_7/m3_n41_6156# VSUBS ypass_gate_3v64x8m81_4/pmos_1p2$$46889004_3v64x8m81_1/pmos_5p0431059130201_3v64x8m81_0/D
+ ypass_gate_3v64x8m81
Xypass_gate_3v64x8m81_5 ypass_gate_3v64x8m81_7/vdd b[3] bb[3] ypass[3] ypass_gate_3v64x8m81_7/pcb
+ ypass_gate_3v64x8m81_7/vdd_uq0 ypass_gate_3v64x8m81_7/m3_n41_6881# ypass_gate_3v64x8m81_7/m3_n41_5924#
+ ypass_gate_3v64x8m81_7/m3_n41_6639# ypass_gate_3v64x8m81_7/vdd_uq0 ypass_gate_3v64x8m81_7/m3_n41_5682#
+ ypass_gate_a_3v64x8m81_0/vss ypass_gate_3v64x8m81_5/db ypass_gate_3v64x8m81_7/m3_n41_5198#
+ ypass_gate_3v64x8m81_7/m3_n41_5440# ypass_gate_3v64x8m81_7/m3_n41_6156# VSUBS ypass_gate_3v64x8m81_5/pmos_1p2$$46889004_3v64x8m81_1/pmos_5p0431059130201_3v64x8m81_0/D
+ ypass_gate_3v64x8m81
Xypass_gate_3v64x8m81_6 ypass_gate_3v64x8m81_7/vdd b[1] bb[1] ypass[1] ypass_gate_3v64x8m81_7/pcb
+ ypass_gate_3v64x8m81_7/vdd_uq0 ypass_gate_3v64x8m81_7/m3_n41_6881# ypass_gate_3v64x8m81_7/m3_n41_5924#
+ ypass_gate_3v64x8m81_7/m3_n41_6639# ypass_gate_3v64x8m81_7/vdd_uq0 ypass_gate_3v64x8m81_7/m3_n41_5682#
+ ypass_gate_a_3v64x8m81_0/vss ypass_gate_3v64x8m81_7/db ypass_gate_3v64x8m81_7/m3_n41_5198#
+ ypass_gate_3v64x8m81_7/m3_n41_5440# ypass_gate_3v64x8m81_7/m3_n41_6156# VSUBS ypass_gate_3v64x8m81_6/pmos_1p2$$46889004_3v64x8m81_1/pmos_5p0431059130201_3v64x8m81_0/D
+ ypass_gate_3v64x8m81
Xypass_gate_3v64x8m81_7 ypass_gate_3v64x8m81_7/vdd b[0] bb[0] ypass[0] ypass_gate_3v64x8m81_7/pcb
+ ypass_gate_3v64x8m81_7/vdd_uq0 ypass_gate_3v64x8m81_7/m3_n41_6881# ypass_gate_3v64x8m81_7/m3_n41_5924#
+ ypass_gate_3v64x8m81_7/m3_n41_6639# ypass_gate_3v64x8m81_7/vdd_uq0 ypass_gate_3v64x8m81_7/m3_n41_5682#
+ ypass_gate_a_3v64x8m81_0/vss ypass_gate_3v64x8m81_7/db ypass_gate_3v64x8m81_7/m3_n41_5198#
+ ypass_gate_3v64x8m81_7/m3_n41_5440# ypass_gate_3v64x8m81_7/m3_n41_6156# VSUBS ypass_gate_3v64x8m81_7/pmos_1p2$$46889004_3v64x8m81_1/pmos_5p0431059130201_3v64x8m81_0/D
+ ypass_gate_3v64x8m81
.ends

.subckt saout_m2_3v64x8m81 ypass[4] ypass[5] men GWEN datain q pcb b[0] b[3] vdd_uq3
+ vss_uq0 bb[1] b[2] bb[5] b[5] bb[0] bb[6] b[6] WEN bb[2] b[7] GWE bb[4] b[4] ypass[0]
+ vdd ypass[1] ypass[7] vdd_uq5 ypass[2] din_3v64x8m81_0/men ypass[6] vdd_uq6 vdd_uq4
+ vdd_uq0 vdd_uq7 vdd_uq2 vss bb[3] bb[7] b[1] ypass[3]
Xdin_3v64x8m81_0 vss datain din_3v64x8m81_0/men vdd_uq3 sa_3v64x8m81_0/db sa_3v64x8m81_0/d
+ vdd sa_3v64x8m81_0/wep pcb vss din_3v64x8m81
Xwen_wm1_3v64x8m81_0 GWEN din_3v64x8m81_0/men sa_3v64x8m81_0/wep WEN vss vdd_uq5 vdd_uq6
+ wen_wm1_3v64x8m81
Xsacntl_2_3v64x8m81_0 pcb sa_3v64x8m81_0/se sacntl_2_3v64x8m81_0/pmos_5p04310591302027_3v64x8m81_1/S_uq0
+ sacntl_2_3v64x8m81_0/pmos_5p04310591302027_3v64x8m81_2/S_uq0 din_3v64x8m81_0/men
+ vdd_uq7 vss vdd_uq4 sacntl_2_3v64x8m81
Xsa_3v64x8m81_0 sa_3v64x8m81_0/qp sa_3v64x8m81_0/qn sa_3v64x8m81_0/wep sa_3v64x8m81_0/se
+ pcb sa_3v64x8m81_0/db vdd_uq3 vdd sa_3v64x8m81_0/d vss sa_3v64x8m81
Xoutbuf_oe_3v64x8m81_0 sa_3v64x8m81_0/qp sa_3v64x8m81_0/qn sa_3v64x8m81_0/se q GWE
+ vdd_uq3 vss outbuf_oe_3v64x8m81
Xmux821_3v64x8m81_0 bb[3] b[1] b[5] bb[0] bb[7] bb[2] sa_3v64x8m81_0/d bb[1] sa_3v64x8m81_0/db
+ b[4] sa_3v64x8m81_0/db ypass[1] b[7] sa_3v64x8m81_0/d ypass[3] ypass[4] ypass[0]
+ sa_3v64x8m81_0/d bb[6] bb[5] sa_3v64x8m81_0/db sa_3v64x8m81_0/db sa_3v64x8m81_0/d
+ sa_3v64x8m81_0/d ypass[3] b[3] b[0] sa_3v64x8m81_0/d ypass[7] sa_3v64x8m81_0/d b[2]
+ ypass[6] ypass[1] ypass[5] ypass[4] pcb vdd_uq0 b[6] sa_3v64x8m81_0/d ypass[6] ypass[7]
+ ypass[2] ypass[2] ypass[0] bb[4] ypass[5] vdd_uq2 vss mux821_3v64x8m81
.ends

.subckt saout_R_m2_3v64x8m81 ypass[1] ypass[3] ypass[4] ypass[5] ypass[0] GWEN datain
+ b[4] b[0] bb[7] q pcb vss_uq6 vdd_uq1 pcb_uq0 datain_uq0 b[2] b[5] bb[1] bb[6] b[1]
+ b[7] GWE bb[5] bb[2] ypass[7] ypass[6] bb[3] b[3] WEN vdd_uq4 vdd_uq3 vdd_uq2 men
+ ypass[2] sa_3v64x8m81_0/pcb vdd vdd_uq5 vdd_uq0 mux821_3v64x8m81_0/ypass_gate_3v64x8m81_7/vdd_uq0
+ bb[4] bb[0] b[6] vss
Xdin_3v64x8m81_0 vss datain men vdd_uq3 sa_3v64x8m81_0/db sa_3v64x8m81_0/d vdd_uq4
+ sa_3v64x8m81_0/wep sa_3v64x8m81_0/pcb vss din_3v64x8m81
Xwen_wm1_3v64x8m81_0 GWEN men sa_3v64x8m81_0/wep WEN vss vdd_uq1 vdd_uq2 wen_wm1_3v64x8m81
Xsacntl_2_3v64x8m81_0 sa_3v64x8m81_0/pcb sa_3v64x8m81_0/se sacntl_2_3v64x8m81_0/pmos_5p04310591302027_3v64x8m81_1/S_uq0
+ sacntl_2_3v64x8m81_0/pmos_5p04310591302027_3v64x8m81_2/S_uq0 men vdd_uq0 vss vdd
+ sacntl_2_3v64x8m81
Xsa_3v64x8m81_0 sa_3v64x8m81_0/qp sa_3v64x8m81_0/qn sa_3v64x8m81_0/wep sa_3v64x8m81_0/se
+ sa_3v64x8m81_0/pcb sa_3v64x8m81_0/db vdd_uq3 vdd_uq4 sa_3v64x8m81_0/d vss sa_3v64x8m81
Xoutbuf_oe_3v64x8m81_0 sa_3v64x8m81_0/qp sa_3v64x8m81_0/qn sa_3v64x8m81_0/se q GWE
+ vdd_uq3 vss outbuf_oe_3v64x8m81
Xmux821_3v64x8m81_0 bb[4] b[6] b[2] bb[7] bb[0] bb[5] sa_3v64x8m81_0/d bb[6] sa_3v64x8m81_0/db
+ b[3] sa_3v64x8m81_0/db ypass[6] b[0] sa_3v64x8m81_0/d ypass[4] ypass[3] ypass[7]
+ sa_3v64x8m81_0/d bb[1] bb[2] sa_3v64x8m81_0/db sa_3v64x8m81_0/db sa_3v64x8m81_0/d
+ sa_3v64x8m81_0/d ypass[3] b[4] b[7] sa_3v64x8m81_0/d ypass[0] sa_3v64x8m81_0/d b[5]
+ ypass[1] ypass[1] ypass[2] ypass[4] sa_3v64x8m81_0/pcb vdd_uq5 b[1] sa_3v64x8m81_0/d
+ ypass[6] ypass[7] ypass[5] ypass[2] ypass[0] bb[3] ypass[5] mux821_3v64x8m81_0/ypass_gate_3v64x8m81_7/vdd_uq0
+ vss mux821_3v64x8m81
.ends

.subckt x018SRAM_cell1_3v64x8m81 m3_82_330# a_248_342# a_248_592# a_62_178# w_30_512#
+ a_430_96# a_110_96# VSUBS
X0 a_248_592# a_192_298# a_110_250# w_30_512# pfet_03v3 ad=0.1613p pd=1.39u as=0.1238p ps=1.44u w=0.28u l=0.28u
X1 a_248_342# a_192_298# a_110_250# VSUBS nfet_03v3 ad=0.171p pd=1.33u as=0.15665p ps=1.32u w=0.45u l=0.28u
X2 a_192_298# a_110_250# a_248_592# w_30_512# pfet_03v3 ad=0.1238p pd=1.44u as=0.1613p ps=1.39u w=0.28u l=0.28u
X3 a_192_298# a_110_250# a_248_342# VSUBS nfet_03v3 ad=0.15665p pd=1.32u as=0.171p ps=1.33u w=0.45u l=0.28u
X4 a_110_250# a_62_178# a_110_96# VSUBS nfet_03v3 ad=0.15665p pd=1.32u as=0.1208p ps=1.42u w=0.28u l=0.36u
X5 a_192_298# a_62_178# a_430_96# VSUBS nfet_03v3 ad=0.15665p pd=1.32u as=0.1208p ps=1.42u w=0.28u l=0.36u
.ends

.subckt x018SRAM_cell1_2x_3v64x8m81 018SRAM_cell1_3v64x8m81_0/a_62_178# 018SRAM_cell1_3v64x8m81_0/w_30_512#
+ 018SRAM_cell1_3v64x8m81_0/m3_82_330# 018SRAM_cell1_3v64x8m81_0/a_248_342# 018SRAM_cell1_3v64x8m81_0/a_248_592#
+ 018SRAM_cell1_3v64x8m81_1/a_62_178# 018SRAM_cell1_3v64x8m81_1/m3_82_330# 018SRAM_cell1_3v64x8m81_1/a_248_342#
+ 018SRAM_cell1_3v64x8m81_1/w_30_512# 018SRAM_cell1_3v64x8m81_1/a_248_592# 018SRAM_cell1_3v64x8m81_1/a_430_96#
+ VSUBS 018SRAM_cell1_3v64x8m81_1/a_110_96#
X018SRAM_cell1_3v64x8m81_0 018SRAM_cell1_3v64x8m81_0/m3_82_330# 018SRAM_cell1_3v64x8m81_0/a_248_342#
+ 018SRAM_cell1_3v64x8m81_0/a_248_592# 018SRAM_cell1_3v64x8m81_0/a_62_178# 018SRAM_cell1_3v64x8m81_0/w_30_512#
+ 018SRAM_cell1_3v64x8m81_1/a_430_96# 018SRAM_cell1_3v64x8m81_1/a_110_96# VSUBS x018SRAM_cell1_3v64x8m81
X018SRAM_cell1_3v64x8m81_1 018SRAM_cell1_3v64x8m81_1/m3_82_330# 018SRAM_cell1_3v64x8m81_1/a_248_342#
+ 018SRAM_cell1_3v64x8m81_1/a_248_592# 018SRAM_cell1_3v64x8m81_1/a_62_178# 018SRAM_cell1_3v64x8m81_1/w_30_512#
+ 018SRAM_cell1_3v64x8m81_1/a_430_96# 018SRAM_cell1_3v64x8m81_1/a_110_96# VSUBS x018SRAM_cell1_3v64x8m81
.ends

.subckt Cell_array8x8_3v64x8m81 bb[19] b[20] bb[17] b[7] bb[6] bb[8] b[26] b[5] b[24]
+ bb[4] b[28] b[29] b[3] bb[2] b[27] b[1] bb[7] bb[25] bb[0] bb[26] b[6] b[25] bb[27]
+ bb[5] bb[28] bb[24] b[23] bb[29] b[4] b[10] b[12] bb[22] bb[3] b[30] bb[9] b[14]
+ b[21] b[31] b[2] b[15] b[8] bb[20] b[16] bb[1] b[13] wl[0] b[18] wl[6] wl[3] b[19]
+ bb[18] bb[11] b[11] wl[1] bb[12] b[17] bb[23] wl[7] bb[13] bb[30] bb[10] bb[14]
+ b[22] bb[31] 018SRAM_strap1_2x_3v64x8m81_3[3]/018SRAM_strap1_3v64x8m81_1/w_91_512#
+ b[9] bb[15] wl[4] wl[5] bb[21] wl[2] bb[16] b[0] VSUBS
X018SRAM_cell1_2x_3v64x8m81_0[0|0] wl[0] 018SRAM_strap1_2x_3v64x8m81_3[3]/018SRAM_strap1_3v64x8m81_1/w_91_512#
+ wl[0] VSUBS 018SRAM_strap1_2x_3v64x8m81_3[3]/018SRAM_strap1_3v64x8m81_1/w_91_512#
+ wl[1] wl[1] VSUBS 018SRAM_strap1_2x_3v64x8m81_3[3]/018SRAM_strap1_3v64x8m81_1/w_91_512#
+ 018SRAM_strap1_2x_3v64x8m81_3[3]/018SRAM_strap1_3v64x8m81_1/w_91_512# b[7] VSUBS
+ bb[7] x018SRAM_cell1_2x_3v64x8m81
X018SRAM_cell1_2x_3v64x8m81_0[1|0] wl[2] 018SRAM_strap1_2x_3v64x8m81_3[3]/018SRAM_strap1_3v64x8m81_1/w_91_512#
+ wl[2] VSUBS 018SRAM_strap1_2x_3v64x8m81_3[3]/018SRAM_strap1_3v64x8m81_1/w_91_512#
+ wl[3] wl[3] VSUBS 018SRAM_strap1_2x_3v64x8m81_3[3]/018SRAM_strap1_3v64x8m81_1/w_91_512#
+ 018SRAM_strap1_2x_3v64x8m81_3[3]/018SRAM_strap1_3v64x8m81_1/w_91_512# b[7] VSUBS
+ bb[7] x018SRAM_cell1_2x_3v64x8m81
X018SRAM_cell1_2x_3v64x8m81_0[2|0] wl[4] 018SRAM_strap1_2x_3v64x8m81_3[3]/018SRAM_strap1_3v64x8m81_1/w_91_512#
+ wl[4] VSUBS 018SRAM_strap1_2x_3v64x8m81_3[3]/018SRAM_strap1_3v64x8m81_1/w_91_512#
+ wl[5] wl[5] VSUBS 018SRAM_strap1_2x_3v64x8m81_3[3]/018SRAM_strap1_3v64x8m81_1/w_91_512#
+ 018SRAM_strap1_2x_3v64x8m81_3[3]/018SRAM_strap1_3v64x8m81_1/w_91_512# b[7] VSUBS
+ bb[7] x018SRAM_cell1_2x_3v64x8m81
X018SRAM_cell1_2x_3v64x8m81_0[3|0] wl[6] 018SRAM_strap1_2x_3v64x8m81_3[3]/018SRAM_strap1_3v64x8m81_1/w_91_512#
+ wl[6] VSUBS 018SRAM_strap1_2x_3v64x8m81_3[3]/018SRAM_strap1_3v64x8m81_1/w_91_512#
+ wl[7] wl[7] VSUBS 018SRAM_strap1_2x_3v64x8m81_3[3]/018SRAM_strap1_3v64x8m81_1/w_91_512#
+ 018SRAM_strap1_2x_3v64x8m81_3[3]/018SRAM_strap1_3v64x8m81_1/w_91_512# b[7] VSUBS
+ bb[7] x018SRAM_cell1_2x_3v64x8m81
X018SRAM_cell1_2x_3v64x8m81_0[0|1] wl[0] 018SRAM_strap1_2x_3v64x8m81_3[3]/018SRAM_strap1_3v64x8m81_1/w_91_512#
+ wl[0] VSUBS 018SRAM_strap1_2x_3v64x8m81_3[3]/018SRAM_strap1_3v64x8m81_1/w_91_512#
+ wl[1] wl[1] VSUBS 018SRAM_strap1_2x_3v64x8m81_3[3]/018SRAM_strap1_3v64x8m81_1/w_91_512#
+ 018SRAM_strap1_2x_3v64x8m81_3[3]/018SRAM_strap1_3v64x8m81_1/w_91_512# bb[6] VSUBS
+ b[6] x018SRAM_cell1_2x_3v64x8m81
X018SRAM_cell1_2x_3v64x8m81_0[1|1] wl[2] 018SRAM_strap1_2x_3v64x8m81_3[3]/018SRAM_strap1_3v64x8m81_1/w_91_512#
+ wl[2] VSUBS 018SRAM_strap1_2x_3v64x8m81_3[3]/018SRAM_strap1_3v64x8m81_1/w_91_512#
+ wl[3] wl[3] VSUBS 018SRAM_strap1_2x_3v64x8m81_3[3]/018SRAM_strap1_3v64x8m81_1/w_91_512#
+ 018SRAM_strap1_2x_3v64x8m81_3[3]/018SRAM_strap1_3v64x8m81_1/w_91_512# bb[6] VSUBS
+ b[6] x018SRAM_cell1_2x_3v64x8m81
X018SRAM_cell1_2x_3v64x8m81_0[2|1] wl[4] 018SRAM_strap1_2x_3v64x8m81_3[3]/018SRAM_strap1_3v64x8m81_1/w_91_512#
+ wl[4] VSUBS 018SRAM_strap1_2x_3v64x8m81_3[3]/018SRAM_strap1_3v64x8m81_1/w_91_512#
+ wl[5] wl[5] VSUBS 018SRAM_strap1_2x_3v64x8m81_3[3]/018SRAM_strap1_3v64x8m81_1/w_91_512#
+ 018SRAM_strap1_2x_3v64x8m81_3[3]/018SRAM_strap1_3v64x8m81_1/w_91_512# bb[6] VSUBS
+ b[6] x018SRAM_cell1_2x_3v64x8m81
X018SRAM_cell1_2x_3v64x8m81_0[3|1] wl[6] 018SRAM_strap1_2x_3v64x8m81_3[3]/018SRAM_strap1_3v64x8m81_1/w_91_512#
+ wl[6] VSUBS 018SRAM_strap1_2x_3v64x8m81_3[3]/018SRAM_strap1_3v64x8m81_1/w_91_512#
+ wl[7] wl[7] VSUBS 018SRAM_strap1_2x_3v64x8m81_3[3]/018SRAM_strap1_3v64x8m81_1/w_91_512#
+ 018SRAM_strap1_2x_3v64x8m81_3[3]/018SRAM_strap1_3v64x8m81_1/w_91_512# bb[6] VSUBS
+ b[6] x018SRAM_cell1_2x_3v64x8m81
X018SRAM_cell1_2x_3v64x8m81_0[0|2] wl[0] 018SRAM_strap1_2x_3v64x8m81_3[3]/018SRAM_strap1_3v64x8m81_1/w_91_512#
+ wl[0] VSUBS 018SRAM_strap1_2x_3v64x8m81_3[3]/018SRAM_strap1_3v64x8m81_1/w_91_512#
+ wl[1] wl[1] VSUBS 018SRAM_strap1_2x_3v64x8m81_3[3]/018SRAM_strap1_3v64x8m81_1/w_91_512#
+ 018SRAM_strap1_2x_3v64x8m81_3[3]/018SRAM_strap1_3v64x8m81_1/w_91_512# b[5] VSUBS
+ bb[5] x018SRAM_cell1_2x_3v64x8m81
X018SRAM_cell1_2x_3v64x8m81_0[1|2] wl[2] 018SRAM_strap1_2x_3v64x8m81_3[3]/018SRAM_strap1_3v64x8m81_1/w_91_512#
+ wl[2] VSUBS 018SRAM_strap1_2x_3v64x8m81_3[3]/018SRAM_strap1_3v64x8m81_1/w_91_512#
+ wl[3] wl[3] VSUBS 018SRAM_strap1_2x_3v64x8m81_3[3]/018SRAM_strap1_3v64x8m81_1/w_91_512#
+ 018SRAM_strap1_2x_3v64x8m81_3[3]/018SRAM_strap1_3v64x8m81_1/w_91_512# b[5] VSUBS
+ bb[5] x018SRAM_cell1_2x_3v64x8m81
X018SRAM_cell1_2x_3v64x8m81_0[2|2] wl[4] 018SRAM_strap1_2x_3v64x8m81_3[3]/018SRAM_strap1_3v64x8m81_1/w_91_512#
+ wl[4] VSUBS 018SRAM_strap1_2x_3v64x8m81_3[3]/018SRAM_strap1_3v64x8m81_1/w_91_512#
+ wl[5] wl[5] VSUBS 018SRAM_strap1_2x_3v64x8m81_3[3]/018SRAM_strap1_3v64x8m81_1/w_91_512#
+ 018SRAM_strap1_2x_3v64x8m81_3[3]/018SRAM_strap1_3v64x8m81_1/w_91_512# b[5] VSUBS
+ bb[5] x018SRAM_cell1_2x_3v64x8m81
X018SRAM_cell1_2x_3v64x8m81_0[3|2] wl[6] 018SRAM_strap1_2x_3v64x8m81_3[3]/018SRAM_strap1_3v64x8m81_1/w_91_512#
+ wl[6] VSUBS 018SRAM_strap1_2x_3v64x8m81_3[3]/018SRAM_strap1_3v64x8m81_1/w_91_512#
+ wl[7] wl[7] VSUBS 018SRAM_strap1_2x_3v64x8m81_3[3]/018SRAM_strap1_3v64x8m81_1/w_91_512#
+ 018SRAM_strap1_2x_3v64x8m81_3[3]/018SRAM_strap1_3v64x8m81_1/w_91_512# b[5] VSUBS
+ bb[5] x018SRAM_cell1_2x_3v64x8m81
X018SRAM_cell1_2x_3v64x8m81_0[0|3] wl[0] 018SRAM_strap1_2x_3v64x8m81_3[3]/018SRAM_strap1_3v64x8m81_1/w_91_512#
+ wl[0] VSUBS 018SRAM_strap1_2x_3v64x8m81_3[3]/018SRAM_strap1_3v64x8m81_1/w_91_512#
+ wl[1] wl[1] VSUBS 018SRAM_strap1_2x_3v64x8m81_3[3]/018SRAM_strap1_3v64x8m81_1/w_91_512#
+ 018SRAM_strap1_2x_3v64x8m81_3[3]/018SRAM_strap1_3v64x8m81_1/w_91_512# bb[4] VSUBS
+ b[4] x018SRAM_cell1_2x_3v64x8m81
X018SRAM_cell1_2x_3v64x8m81_0[1|3] wl[2] 018SRAM_strap1_2x_3v64x8m81_3[3]/018SRAM_strap1_3v64x8m81_1/w_91_512#
+ wl[2] VSUBS 018SRAM_strap1_2x_3v64x8m81_3[3]/018SRAM_strap1_3v64x8m81_1/w_91_512#
+ wl[3] wl[3] VSUBS 018SRAM_strap1_2x_3v64x8m81_3[3]/018SRAM_strap1_3v64x8m81_1/w_91_512#
+ 018SRAM_strap1_2x_3v64x8m81_3[3]/018SRAM_strap1_3v64x8m81_1/w_91_512# bb[4] VSUBS
+ b[4] x018SRAM_cell1_2x_3v64x8m81
X018SRAM_cell1_2x_3v64x8m81_0[2|3] wl[4] 018SRAM_strap1_2x_3v64x8m81_3[3]/018SRAM_strap1_3v64x8m81_1/w_91_512#
+ wl[4] VSUBS 018SRAM_strap1_2x_3v64x8m81_3[3]/018SRAM_strap1_3v64x8m81_1/w_91_512#
+ wl[5] wl[5] VSUBS 018SRAM_strap1_2x_3v64x8m81_3[3]/018SRAM_strap1_3v64x8m81_1/w_91_512#
+ 018SRAM_strap1_2x_3v64x8m81_3[3]/018SRAM_strap1_3v64x8m81_1/w_91_512# bb[4] VSUBS
+ b[4] x018SRAM_cell1_2x_3v64x8m81
X018SRAM_cell1_2x_3v64x8m81_0[3|3] wl[6] 018SRAM_strap1_2x_3v64x8m81_3[3]/018SRAM_strap1_3v64x8m81_1/w_91_512#
+ wl[6] VSUBS 018SRAM_strap1_2x_3v64x8m81_3[3]/018SRAM_strap1_3v64x8m81_1/w_91_512#
+ wl[7] wl[7] VSUBS 018SRAM_strap1_2x_3v64x8m81_3[3]/018SRAM_strap1_3v64x8m81_1/w_91_512#
+ 018SRAM_strap1_2x_3v64x8m81_3[3]/018SRAM_strap1_3v64x8m81_1/w_91_512# bb[4] VSUBS
+ b[4] x018SRAM_cell1_2x_3v64x8m81
X018SRAM_cell1_2x_3v64x8m81_0[0|4] wl[0] 018SRAM_strap1_2x_3v64x8m81_3[3]/018SRAM_strap1_3v64x8m81_1/w_91_512#
+ wl[0] VSUBS 018SRAM_strap1_2x_3v64x8m81_3[3]/018SRAM_strap1_3v64x8m81_1/w_91_512#
+ wl[1] wl[1] VSUBS 018SRAM_strap1_2x_3v64x8m81_3[3]/018SRAM_strap1_3v64x8m81_1/w_91_512#
+ 018SRAM_strap1_2x_3v64x8m81_3[3]/018SRAM_strap1_3v64x8m81_1/w_91_512# b[3] VSUBS
+ bb[3] x018SRAM_cell1_2x_3v64x8m81
X018SRAM_cell1_2x_3v64x8m81_0[1|4] wl[2] 018SRAM_strap1_2x_3v64x8m81_3[3]/018SRAM_strap1_3v64x8m81_1/w_91_512#
+ wl[2] VSUBS 018SRAM_strap1_2x_3v64x8m81_3[3]/018SRAM_strap1_3v64x8m81_1/w_91_512#
+ wl[3] wl[3] VSUBS 018SRAM_strap1_2x_3v64x8m81_3[3]/018SRAM_strap1_3v64x8m81_1/w_91_512#
+ 018SRAM_strap1_2x_3v64x8m81_3[3]/018SRAM_strap1_3v64x8m81_1/w_91_512# b[3] VSUBS
+ bb[3] x018SRAM_cell1_2x_3v64x8m81
X018SRAM_cell1_2x_3v64x8m81_0[2|4] wl[4] 018SRAM_strap1_2x_3v64x8m81_3[3]/018SRAM_strap1_3v64x8m81_1/w_91_512#
+ wl[4] VSUBS 018SRAM_strap1_2x_3v64x8m81_3[3]/018SRAM_strap1_3v64x8m81_1/w_91_512#
+ wl[5] wl[5] VSUBS 018SRAM_strap1_2x_3v64x8m81_3[3]/018SRAM_strap1_3v64x8m81_1/w_91_512#
+ 018SRAM_strap1_2x_3v64x8m81_3[3]/018SRAM_strap1_3v64x8m81_1/w_91_512# b[3] VSUBS
+ bb[3] x018SRAM_cell1_2x_3v64x8m81
X018SRAM_cell1_2x_3v64x8m81_0[3|4] wl[6] 018SRAM_strap1_2x_3v64x8m81_3[3]/018SRAM_strap1_3v64x8m81_1/w_91_512#
+ wl[6] VSUBS 018SRAM_strap1_2x_3v64x8m81_3[3]/018SRAM_strap1_3v64x8m81_1/w_91_512#
+ wl[7] wl[7] VSUBS 018SRAM_strap1_2x_3v64x8m81_3[3]/018SRAM_strap1_3v64x8m81_1/w_91_512#
+ 018SRAM_strap1_2x_3v64x8m81_3[3]/018SRAM_strap1_3v64x8m81_1/w_91_512# b[3] VSUBS
+ bb[3] x018SRAM_cell1_2x_3v64x8m81
X018SRAM_cell1_2x_3v64x8m81_0[0|5] wl[0] 018SRAM_strap1_2x_3v64x8m81_3[3]/018SRAM_strap1_3v64x8m81_1/w_91_512#
+ wl[0] VSUBS 018SRAM_strap1_2x_3v64x8m81_3[3]/018SRAM_strap1_3v64x8m81_1/w_91_512#
+ wl[1] wl[1] VSUBS 018SRAM_strap1_2x_3v64x8m81_3[3]/018SRAM_strap1_3v64x8m81_1/w_91_512#
+ 018SRAM_strap1_2x_3v64x8m81_3[3]/018SRAM_strap1_3v64x8m81_1/w_91_512# bb[2] VSUBS
+ b[2] x018SRAM_cell1_2x_3v64x8m81
X018SRAM_cell1_2x_3v64x8m81_0[1|5] wl[2] 018SRAM_strap1_2x_3v64x8m81_3[3]/018SRAM_strap1_3v64x8m81_1/w_91_512#
+ wl[2] VSUBS 018SRAM_strap1_2x_3v64x8m81_3[3]/018SRAM_strap1_3v64x8m81_1/w_91_512#
+ wl[3] wl[3] VSUBS 018SRAM_strap1_2x_3v64x8m81_3[3]/018SRAM_strap1_3v64x8m81_1/w_91_512#
+ 018SRAM_strap1_2x_3v64x8m81_3[3]/018SRAM_strap1_3v64x8m81_1/w_91_512# bb[2] VSUBS
+ b[2] x018SRAM_cell1_2x_3v64x8m81
X018SRAM_cell1_2x_3v64x8m81_0[2|5] wl[4] 018SRAM_strap1_2x_3v64x8m81_3[3]/018SRAM_strap1_3v64x8m81_1/w_91_512#
+ wl[4] VSUBS 018SRAM_strap1_2x_3v64x8m81_3[3]/018SRAM_strap1_3v64x8m81_1/w_91_512#
+ wl[5] wl[5] VSUBS 018SRAM_strap1_2x_3v64x8m81_3[3]/018SRAM_strap1_3v64x8m81_1/w_91_512#
+ 018SRAM_strap1_2x_3v64x8m81_3[3]/018SRAM_strap1_3v64x8m81_1/w_91_512# bb[2] VSUBS
+ b[2] x018SRAM_cell1_2x_3v64x8m81
X018SRAM_cell1_2x_3v64x8m81_0[3|5] wl[6] 018SRAM_strap1_2x_3v64x8m81_3[3]/018SRAM_strap1_3v64x8m81_1/w_91_512#
+ wl[6] VSUBS 018SRAM_strap1_2x_3v64x8m81_3[3]/018SRAM_strap1_3v64x8m81_1/w_91_512#
+ wl[7] wl[7] VSUBS 018SRAM_strap1_2x_3v64x8m81_3[3]/018SRAM_strap1_3v64x8m81_1/w_91_512#
+ 018SRAM_strap1_2x_3v64x8m81_3[3]/018SRAM_strap1_3v64x8m81_1/w_91_512# bb[2] VSUBS
+ b[2] x018SRAM_cell1_2x_3v64x8m81
X018SRAM_cell1_2x_3v64x8m81_0[0|6] wl[0] 018SRAM_strap1_2x_3v64x8m81_3[3]/018SRAM_strap1_3v64x8m81_1/w_91_512#
+ wl[0] VSUBS 018SRAM_strap1_2x_3v64x8m81_3[3]/018SRAM_strap1_3v64x8m81_1/w_91_512#
+ wl[1] wl[1] VSUBS 018SRAM_strap1_2x_3v64x8m81_3[3]/018SRAM_strap1_3v64x8m81_1/w_91_512#
+ 018SRAM_strap1_2x_3v64x8m81_3[3]/018SRAM_strap1_3v64x8m81_1/w_91_512# b[1] VSUBS
+ bb[1] x018SRAM_cell1_2x_3v64x8m81
X018SRAM_cell1_2x_3v64x8m81_0[1|6] wl[2] 018SRAM_strap1_2x_3v64x8m81_3[3]/018SRAM_strap1_3v64x8m81_1/w_91_512#
+ wl[2] VSUBS 018SRAM_strap1_2x_3v64x8m81_3[3]/018SRAM_strap1_3v64x8m81_1/w_91_512#
+ wl[3] wl[3] VSUBS 018SRAM_strap1_2x_3v64x8m81_3[3]/018SRAM_strap1_3v64x8m81_1/w_91_512#
+ 018SRAM_strap1_2x_3v64x8m81_3[3]/018SRAM_strap1_3v64x8m81_1/w_91_512# b[1] VSUBS
+ bb[1] x018SRAM_cell1_2x_3v64x8m81
X018SRAM_cell1_2x_3v64x8m81_0[2|6] wl[4] 018SRAM_strap1_2x_3v64x8m81_3[3]/018SRAM_strap1_3v64x8m81_1/w_91_512#
+ wl[4] VSUBS 018SRAM_strap1_2x_3v64x8m81_3[3]/018SRAM_strap1_3v64x8m81_1/w_91_512#
+ wl[5] wl[5] VSUBS 018SRAM_strap1_2x_3v64x8m81_3[3]/018SRAM_strap1_3v64x8m81_1/w_91_512#
+ 018SRAM_strap1_2x_3v64x8m81_3[3]/018SRAM_strap1_3v64x8m81_1/w_91_512# b[1] VSUBS
+ bb[1] x018SRAM_cell1_2x_3v64x8m81
X018SRAM_cell1_2x_3v64x8m81_0[3|6] wl[6] 018SRAM_strap1_2x_3v64x8m81_3[3]/018SRAM_strap1_3v64x8m81_1/w_91_512#
+ wl[6] VSUBS 018SRAM_strap1_2x_3v64x8m81_3[3]/018SRAM_strap1_3v64x8m81_1/w_91_512#
+ wl[7] wl[7] VSUBS 018SRAM_strap1_2x_3v64x8m81_3[3]/018SRAM_strap1_3v64x8m81_1/w_91_512#
+ 018SRAM_strap1_2x_3v64x8m81_3[3]/018SRAM_strap1_3v64x8m81_1/w_91_512# b[1] VSUBS
+ bb[1] x018SRAM_cell1_2x_3v64x8m81
X018SRAM_cell1_2x_3v64x8m81_0[0|7] wl[0] 018SRAM_strap1_2x_3v64x8m81_3[3]/018SRAM_strap1_3v64x8m81_1/w_91_512#
+ wl[0] VSUBS 018SRAM_strap1_2x_3v64x8m81_3[3]/018SRAM_strap1_3v64x8m81_1/w_91_512#
+ wl[1] wl[1] VSUBS 018SRAM_strap1_2x_3v64x8m81_3[3]/018SRAM_strap1_3v64x8m81_1/w_91_512#
+ 018SRAM_strap1_2x_3v64x8m81_3[3]/018SRAM_strap1_3v64x8m81_1/w_91_512# bb[0] VSUBS
+ b[0] x018SRAM_cell1_2x_3v64x8m81
X018SRAM_cell1_2x_3v64x8m81_0[1|7] wl[2] 018SRAM_strap1_2x_3v64x8m81_3[3]/018SRAM_strap1_3v64x8m81_1/w_91_512#
+ wl[2] VSUBS 018SRAM_strap1_2x_3v64x8m81_3[3]/018SRAM_strap1_3v64x8m81_1/w_91_512#
+ wl[3] wl[3] VSUBS 018SRAM_strap1_2x_3v64x8m81_3[3]/018SRAM_strap1_3v64x8m81_1/w_91_512#
+ 018SRAM_strap1_2x_3v64x8m81_3[3]/018SRAM_strap1_3v64x8m81_1/w_91_512# bb[0] VSUBS
+ b[0] x018SRAM_cell1_2x_3v64x8m81
X018SRAM_cell1_2x_3v64x8m81_0[2|7] wl[4] 018SRAM_strap1_2x_3v64x8m81_3[3]/018SRAM_strap1_3v64x8m81_1/w_91_512#
+ wl[4] VSUBS 018SRAM_strap1_2x_3v64x8m81_3[3]/018SRAM_strap1_3v64x8m81_1/w_91_512#
+ wl[5] wl[5] VSUBS 018SRAM_strap1_2x_3v64x8m81_3[3]/018SRAM_strap1_3v64x8m81_1/w_91_512#
+ 018SRAM_strap1_2x_3v64x8m81_3[3]/018SRAM_strap1_3v64x8m81_1/w_91_512# bb[0] VSUBS
+ b[0] x018SRAM_cell1_2x_3v64x8m81
X018SRAM_cell1_2x_3v64x8m81_0[3|7] wl[6] 018SRAM_strap1_2x_3v64x8m81_3[3]/018SRAM_strap1_3v64x8m81_1/w_91_512#
+ wl[6] VSUBS 018SRAM_strap1_2x_3v64x8m81_3[3]/018SRAM_strap1_3v64x8m81_1/w_91_512#
+ wl[7] wl[7] VSUBS 018SRAM_strap1_2x_3v64x8m81_3[3]/018SRAM_strap1_3v64x8m81_1/w_91_512#
+ 018SRAM_strap1_2x_3v64x8m81_3[3]/018SRAM_strap1_3v64x8m81_1/w_91_512# bb[0] VSUBS
+ b[0] x018SRAM_cell1_2x_3v64x8m81
X018SRAM_cell1_2x_3v64x8m81_1[0|0] wl[0] 018SRAM_strap1_2x_3v64x8m81_3[3]/018SRAM_strap1_3v64x8m81_1/w_91_512#
+ wl[0] VSUBS 018SRAM_strap1_2x_3v64x8m81_3[3]/018SRAM_strap1_3v64x8m81_1/w_91_512#
+ wl[1] wl[1] VSUBS 018SRAM_strap1_2x_3v64x8m81_3[3]/018SRAM_strap1_3v64x8m81_1/w_91_512#
+ 018SRAM_strap1_2x_3v64x8m81_3[3]/018SRAM_strap1_3v64x8m81_1/w_91_512# b[23] VSUBS
+ bb[23] x018SRAM_cell1_2x_3v64x8m81
X018SRAM_cell1_2x_3v64x8m81_1[1|0] wl[2] 018SRAM_strap1_2x_3v64x8m81_3[3]/018SRAM_strap1_3v64x8m81_1/w_91_512#
+ wl[2] VSUBS 018SRAM_strap1_2x_3v64x8m81_3[3]/018SRAM_strap1_3v64x8m81_1/w_91_512#
+ wl[3] wl[3] VSUBS 018SRAM_strap1_2x_3v64x8m81_3[3]/018SRAM_strap1_3v64x8m81_1/w_91_512#
+ 018SRAM_strap1_2x_3v64x8m81_3[3]/018SRAM_strap1_3v64x8m81_1/w_91_512# b[23] VSUBS
+ bb[23] x018SRAM_cell1_2x_3v64x8m81
X018SRAM_cell1_2x_3v64x8m81_1[2|0] wl[4] 018SRAM_strap1_2x_3v64x8m81_3[3]/018SRAM_strap1_3v64x8m81_1/w_91_512#
+ wl[4] VSUBS 018SRAM_strap1_2x_3v64x8m81_3[3]/018SRAM_strap1_3v64x8m81_1/w_91_512#
+ wl[5] wl[5] VSUBS 018SRAM_strap1_2x_3v64x8m81_3[3]/018SRAM_strap1_3v64x8m81_1/w_91_512#
+ 018SRAM_strap1_2x_3v64x8m81_3[3]/018SRAM_strap1_3v64x8m81_1/w_91_512# b[23] VSUBS
+ bb[23] x018SRAM_cell1_2x_3v64x8m81
X018SRAM_cell1_2x_3v64x8m81_1[3|0] wl[6] 018SRAM_strap1_2x_3v64x8m81_3[3]/018SRAM_strap1_3v64x8m81_1/w_91_512#
+ wl[6] VSUBS 018SRAM_strap1_2x_3v64x8m81_3[3]/018SRAM_strap1_3v64x8m81_1/w_91_512#
+ wl[7] wl[7] VSUBS 018SRAM_strap1_2x_3v64x8m81_3[3]/018SRAM_strap1_3v64x8m81_1/w_91_512#
+ 018SRAM_strap1_2x_3v64x8m81_3[3]/018SRAM_strap1_3v64x8m81_1/w_91_512# b[23] VSUBS
+ bb[23] x018SRAM_cell1_2x_3v64x8m81
X018SRAM_cell1_2x_3v64x8m81_1[0|1] wl[0] 018SRAM_strap1_2x_3v64x8m81_3[3]/018SRAM_strap1_3v64x8m81_1/w_91_512#
+ wl[0] VSUBS 018SRAM_strap1_2x_3v64x8m81_3[3]/018SRAM_strap1_3v64x8m81_1/w_91_512#
+ wl[1] wl[1] VSUBS 018SRAM_strap1_2x_3v64x8m81_3[3]/018SRAM_strap1_3v64x8m81_1/w_91_512#
+ 018SRAM_strap1_2x_3v64x8m81_3[3]/018SRAM_strap1_3v64x8m81_1/w_91_512# bb[22] VSUBS
+ b[22] x018SRAM_cell1_2x_3v64x8m81
X018SRAM_cell1_2x_3v64x8m81_1[1|1] wl[2] 018SRAM_strap1_2x_3v64x8m81_3[3]/018SRAM_strap1_3v64x8m81_1/w_91_512#
+ wl[2] VSUBS 018SRAM_strap1_2x_3v64x8m81_3[3]/018SRAM_strap1_3v64x8m81_1/w_91_512#
+ wl[3] wl[3] VSUBS 018SRAM_strap1_2x_3v64x8m81_3[3]/018SRAM_strap1_3v64x8m81_1/w_91_512#
+ 018SRAM_strap1_2x_3v64x8m81_3[3]/018SRAM_strap1_3v64x8m81_1/w_91_512# bb[22] VSUBS
+ b[22] x018SRAM_cell1_2x_3v64x8m81
X018SRAM_cell1_2x_3v64x8m81_1[2|1] wl[4] 018SRAM_strap1_2x_3v64x8m81_3[3]/018SRAM_strap1_3v64x8m81_1/w_91_512#
+ wl[4] VSUBS 018SRAM_strap1_2x_3v64x8m81_3[3]/018SRAM_strap1_3v64x8m81_1/w_91_512#
+ wl[5] wl[5] VSUBS 018SRAM_strap1_2x_3v64x8m81_3[3]/018SRAM_strap1_3v64x8m81_1/w_91_512#
+ 018SRAM_strap1_2x_3v64x8m81_3[3]/018SRAM_strap1_3v64x8m81_1/w_91_512# bb[22] VSUBS
+ b[22] x018SRAM_cell1_2x_3v64x8m81
X018SRAM_cell1_2x_3v64x8m81_1[3|1] wl[6] 018SRAM_strap1_2x_3v64x8m81_3[3]/018SRAM_strap1_3v64x8m81_1/w_91_512#
+ wl[6] VSUBS 018SRAM_strap1_2x_3v64x8m81_3[3]/018SRAM_strap1_3v64x8m81_1/w_91_512#
+ wl[7] wl[7] VSUBS 018SRAM_strap1_2x_3v64x8m81_3[3]/018SRAM_strap1_3v64x8m81_1/w_91_512#
+ 018SRAM_strap1_2x_3v64x8m81_3[3]/018SRAM_strap1_3v64x8m81_1/w_91_512# bb[22] VSUBS
+ b[22] x018SRAM_cell1_2x_3v64x8m81
X018SRAM_cell1_2x_3v64x8m81_1[0|2] wl[0] 018SRAM_strap1_2x_3v64x8m81_3[3]/018SRAM_strap1_3v64x8m81_1/w_91_512#
+ wl[0] VSUBS 018SRAM_strap1_2x_3v64x8m81_3[3]/018SRAM_strap1_3v64x8m81_1/w_91_512#
+ wl[1] wl[1] VSUBS 018SRAM_strap1_2x_3v64x8m81_3[3]/018SRAM_strap1_3v64x8m81_1/w_91_512#
+ 018SRAM_strap1_2x_3v64x8m81_3[3]/018SRAM_strap1_3v64x8m81_1/w_91_512# b[21] VSUBS
+ bb[21] x018SRAM_cell1_2x_3v64x8m81
X018SRAM_cell1_2x_3v64x8m81_1[1|2] wl[2] 018SRAM_strap1_2x_3v64x8m81_3[3]/018SRAM_strap1_3v64x8m81_1/w_91_512#
+ wl[2] VSUBS 018SRAM_strap1_2x_3v64x8m81_3[3]/018SRAM_strap1_3v64x8m81_1/w_91_512#
+ wl[3] wl[3] VSUBS 018SRAM_strap1_2x_3v64x8m81_3[3]/018SRAM_strap1_3v64x8m81_1/w_91_512#
+ 018SRAM_strap1_2x_3v64x8m81_3[3]/018SRAM_strap1_3v64x8m81_1/w_91_512# b[21] VSUBS
+ bb[21] x018SRAM_cell1_2x_3v64x8m81
X018SRAM_cell1_2x_3v64x8m81_1[2|2] wl[4] 018SRAM_strap1_2x_3v64x8m81_3[3]/018SRAM_strap1_3v64x8m81_1/w_91_512#
+ wl[4] VSUBS 018SRAM_strap1_2x_3v64x8m81_3[3]/018SRAM_strap1_3v64x8m81_1/w_91_512#
+ wl[5] wl[5] VSUBS 018SRAM_strap1_2x_3v64x8m81_3[3]/018SRAM_strap1_3v64x8m81_1/w_91_512#
+ 018SRAM_strap1_2x_3v64x8m81_3[3]/018SRAM_strap1_3v64x8m81_1/w_91_512# b[21] VSUBS
+ bb[21] x018SRAM_cell1_2x_3v64x8m81
X018SRAM_cell1_2x_3v64x8m81_1[3|2] wl[6] 018SRAM_strap1_2x_3v64x8m81_3[3]/018SRAM_strap1_3v64x8m81_1/w_91_512#
+ wl[6] VSUBS 018SRAM_strap1_2x_3v64x8m81_3[3]/018SRAM_strap1_3v64x8m81_1/w_91_512#
+ wl[7] wl[7] VSUBS 018SRAM_strap1_2x_3v64x8m81_3[3]/018SRAM_strap1_3v64x8m81_1/w_91_512#
+ 018SRAM_strap1_2x_3v64x8m81_3[3]/018SRAM_strap1_3v64x8m81_1/w_91_512# b[21] VSUBS
+ bb[21] x018SRAM_cell1_2x_3v64x8m81
X018SRAM_cell1_2x_3v64x8m81_1[0|3] wl[0] 018SRAM_strap1_2x_3v64x8m81_3[3]/018SRAM_strap1_3v64x8m81_1/w_91_512#
+ wl[0] VSUBS 018SRAM_strap1_2x_3v64x8m81_3[3]/018SRAM_strap1_3v64x8m81_1/w_91_512#
+ wl[1] wl[1] VSUBS 018SRAM_strap1_2x_3v64x8m81_3[3]/018SRAM_strap1_3v64x8m81_1/w_91_512#
+ 018SRAM_strap1_2x_3v64x8m81_3[3]/018SRAM_strap1_3v64x8m81_1/w_91_512# bb[20] VSUBS
+ b[20] x018SRAM_cell1_2x_3v64x8m81
X018SRAM_cell1_2x_3v64x8m81_1[1|3] wl[2] 018SRAM_strap1_2x_3v64x8m81_3[3]/018SRAM_strap1_3v64x8m81_1/w_91_512#
+ wl[2] VSUBS 018SRAM_strap1_2x_3v64x8m81_3[3]/018SRAM_strap1_3v64x8m81_1/w_91_512#
+ wl[3] wl[3] VSUBS 018SRAM_strap1_2x_3v64x8m81_3[3]/018SRAM_strap1_3v64x8m81_1/w_91_512#
+ 018SRAM_strap1_2x_3v64x8m81_3[3]/018SRAM_strap1_3v64x8m81_1/w_91_512# bb[20] VSUBS
+ b[20] x018SRAM_cell1_2x_3v64x8m81
X018SRAM_cell1_2x_3v64x8m81_1[2|3] wl[4] 018SRAM_strap1_2x_3v64x8m81_3[3]/018SRAM_strap1_3v64x8m81_1/w_91_512#
+ wl[4] VSUBS 018SRAM_strap1_2x_3v64x8m81_3[3]/018SRAM_strap1_3v64x8m81_1/w_91_512#
+ wl[5] wl[5] VSUBS 018SRAM_strap1_2x_3v64x8m81_3[3]/018SRAM_strap1_3v64x8m81_1/w_91_512#
+ 018SRAM_strap1_2x_3v64x8m81_3[3]/018SRAM_strap1_3v64x8m81_1/w_91_512# bb[20] VSUBS
+ b[20] x018SRAM_cell1_2x_3v64x8m81
X018SRAM_cell1_2x_3v64x8m81_1[3|3] wl[6] 018SRAM_strap1_2x_3v64x8m81_3[3]/018SRAM_strap1_3v64x8m81_1/w_91_512#
+ wl[6] VSUBS 018SRAM_strap1_2x_3v64x8m81_3[3]/018SRAM_strap1_3v64x8m81_1/w_91_512#
+ wl[7] wl[7] VSUBS 018SRAM_strap1_2x_3v64x8m81_3[3]/018SRAM_strap1_3v64x8m81_1/w_91_512#
+ 018SRAM_strap1_2x_3v64x8m81_3[3]/018SRAM_strap1_3v64x8m81_1/w_91_512# bb[20] VSUBS
+ b[20] x018SRAM_cell1_2x_3v64x8m81
X018SRAM_cell1_2x_3v64x8m81_1[0|4] wl[0] 018SRAM_strap1_2x_3v64x8m81_3[3]/018SRAM_strap1_3v64x8m81_1/w_91_512#
+ wl[0] VSUBS 018SRAM_strap1_2x_3v64x8m81_3[3]/018SRAM_strap1_3v64x8m81_1/w_91_512#
+ wl[1] wl[1] VSUBS 018SRAM_strap1_2x_3v64x8m81_3[3]/018SRAM_strap1_3v64x8m81_1/w_91_512#
+ 018SRAM_strap1_2x_3v64x8m81_3[3]/018SRAM_strap1_3v64x8m81_1/w_91_512# b[19] VSUBS
+ bb[19] x018SRAM_cell1_2x_3v64x8m81
X018SRAM_cell1_2x_3v64x8m81_1[1|4] wl[2] 018SRAM_strap1_2x_3v64x8m81_3[3]/018SRAM_strap1_3v64x8m81_1/w_91_512#
+ wl[2] VSUBS 018SRAM_strap1_2x_3v64x8m81_3[3]/018SRAM_strap1_3v64x8m81_1/w_91_512#
+ wl[3] wl[3] VSUBS 018SRAM_strap1_2x_3v64x8m81_3[3]/018SRAM_strap1_3v64x8m81_1/w_91_512#
+ 018SRAM_strap1_2x_3v64x8m81_3[3]/018SRAM_strap1_3v64x8m81_1/w_91_512# b[19] VSUBS
+ bb[19] x018SRAM_cell1_2x_3v64x8m81
X018SRAM_cell1_2x_3v64x8m81_1[2|4] wl[4] 018SRAM_strap1_2x_3v64x8m81_3[3]/018SRAM_strap1_3v64x8m81_1/w_91_512#
+ wl[4] VSUBS 018SRAM_strap1_2x_3v64x8m81_3[3]/018SRAM_strap1_3v64x8m81_1/w_91_512#
+ wl[5] wl[5] VSUBS 018SRAM_strap1_2x_3v64x8m81_3[3]/018SRAM_strap1_3v64x8m81_1/w_91_512#
+ 018SRAM_strap1_2x_3v64x8m81_3[3]/018SRAM_strap1_3v64x8m81_1/w_91_512# b[19] VSUBS
+ bb[19] x018SRAM_cell1_2x_3v64x8m81
X018SRAM_cell1_2x_3v64x8m81_1[3|4] wl[6] 018SRAM_strap1_2x_3v64x8m81_3[3]/018SRAM_strap1_3v64x8m81_1/w_91_512#
+ wl[6] VSUBS 018SRAM_strap1_2x_3v64x8m81_3[3]/018SRAM_strap1_3v64x8m81_1/w_91_512#
+ wl[7] wl[7] VSUBS 018SRAM_strap1_2x_3v64x8m81_3[3]/018SRAM_strap1_3v64x8m81_1/w_91_512#
+ 018SRAM_strap1_2x_3v64x8m81_3[3]/018SRAM_strap1_3v64x8m81_1/w_91_512# b[19] VSUBS
+ bb[19] x018SRAM_cell1_2x_3v64x8m81
X018SRAM_cell1_2x_3v64x8m81_1[0|5] wl[0] 018SRAM_strap1_2x_3v64x8m81_3[3]/018SRAM_strap1_3v64x8m81_1/w_91_512#
+ wl[0] VSUBS 018SRAM_strap1_2x_3v64x8m81_3[3]/018SRAM_strap1_3v64x8m81_1/w_91_512#
+ wl[1] wl[1] VSUBS 018SRAM_strap1_2x_3v64x8m81_3[3]/018SRAM_strap1_3v64x8m81_1/w_91_512#
+ 018SRAM_strap1_2x_3v64x8m81_3[3]/018SRAM_strap1_3v64x8m81_1/w_91_512# bb[18] VSUBS
+ b[18] x018SRAM_cell1_2x_3v64x8m81
X018SRAM_cell1_2x_3v64x8m81_1[1|5] wl[2] 018SRAM_strap1_2x_3v64x8m81_3[3]/018SRAM_strap1_3v64x8m81_1/w_91_512#
+ wl[2] VSUBS 018SRAM_strap1_2x_3v64x8m81_3[3]/018SRAM_strap1_3v64x8m81_1/w_91_512#
+ wl[3] wl[3] VSUBS 018SRAM_strap1_2x_3v64x8m81_3[3]/018SRAM_strap1_3v64x8m81_1/w_91_512#
+ 018SRAM_strap1_2x_3v64x8m81_3[3]/018SRAM_strap1_3v64x8m81_1/w_91_512# bb[18] VSUBS
+ b[18] x018SRAM_cell1_2x_3v64x8m81
X018SRAM_cell1_2x_3v64x8m81_1[2|5] wl[4] 018SRAM_strap1_2x_3v64x8m81_3[3]/018SRAM_strap1_3v64x8m81_1/w_91_512#
+ wl[4] VSUBS 018SRAM_strap1_2x_3v64x8m81_3[3]/018SRAM_strap1_3v64x8m81_1/w_91_512#
+ wl[5] wl[5] VSUBS 018SRAM_strap1_2x_3v64x8m81_3[3]/018SRAM_strap1_3v64x8m81_1/w_91_512#
+ 018SRAM_strap1_2x_3v64x8m81_3[3]/018SRAM_strap1_3v64x8m81_1/w_91_512# bb[18] VSUBS
+ b[18] x018SRAM_cell1_2x_3v64x8m81
X018SRAM_cell1_2x_3v64x8m81_1[3|5] wl[6] 018SRAM_strap1_2x_3v64x8m81_3[3]/018SRAM_strap1_3v64x8m81_1/w_91_512#
+ wl[6] VSUBS 018SRAM_strap1_2x_3v64x8m81_3[3]/018SRAM_strap1_3v64x8m81_1/w_91_512#
+ wl[7] wl[7] VSUBS 018SRAM_strap1_2x_3v64x8m81_3[3]/018SRAM_strap1_3v64x8m81_1/w_91_512#
+ 018SRAM_strap1_2x_3v64x8m81_3[3]/018SRAM_strap1_3v64x8m81_1/w_91_512# bb[18] VSUBS
+ b[18] x018SRAM_cell1_2x_3v64x8m81
X018SRAM_cell1_2x_3v64x8m81_1[0|6] wl[0] 018SRAM_strap1_2x_3v64x8m81_3[3]/018SRAM_strap1_3v64x8m81_1/w_91_512#
+ wl[0] VSUBS 018SRAM_strap1_2x_3v64x8m81_3[3]/018SRAM_strap1_3v64x8m81_1/w_91_512#
+ wl[1] wl[1] VSUBS 018SRAM_strap1_2x_3v64x8m81_3[3]/018SRAM_strap1_3v64x8m81_1/w_91_512#
+ 018SRAM_strap1_2x_3v64x8m81_3[3]/018SRAM_strap1_3v64x8m81_1/w_91_512# b[17] VSUBS
+ bb[17] x018SRAM_cell1_2x_3v64x8m81
X018SRAM_cell1_2x_3v64x8m81_1[1|6] wl[2] 018SRAM_strap1_2x_3v64x8m81_3[3]/018SRAM_strap1_3v64x8m81_1/w_91_512#
+ wl[2] VSUBS 018SRAM_strap1_2x_3v64x8m81_3[3]/018SRAM_strap1_3v64x8m81_1/w_91_512#
+ wl[3] wl[3] VSUBS 018SRAM_strap1_2x_3v64x8m81_3[3]/018SRAM_strap1_3v64x8m81_1/w_91_512#
+ 018SRAM_strap1_2x_3v64x8m81_3[3]/018SRAM_strap1_3v64x8m81_1/w_91_512# b[17] VSUBS
+ bb[17] x018SRAM_cell1_2x_3v64x8m81
X018SRAM_cell1_2x_3v64x8m81_1[2|6] wl[4] 018SRAM_strap1_2x_3v64x8m81_3[3]/018SRAM_strap1_3v64x8m81_1/w_91_512#
+ wl[4] VSUBS 018SRAM_strap1_2x_3v64x8m81_3[3]/018SRAM_strap1_3v64x8m81_1/w_91_512#
+ wl[5] wl[5] VSUBS 018SRAM_strap1_2x_3v64x8m81_3[3]/018SRAM_strap1_3v64x8m81_1/w_91_512#
+ 018SRAM_strap1_2x_3v64x8m81_3[3]/018SRAM_strap1_3v64x8m81_1/w_91_512# b[17] VSUBS
+ bb[17] x018SRAM_cell1_2x_3v64x8m81
X018SRAM_cell1_2x_3v64x8m81_1[3|6] wl[6] 018SRAM_strap1_2x_3v64x8m81_3[3]/018SRAM_strap1_3v64x8m81_1/w_91_512#
+ wl[6] VSUBS 018SRAM_strap1_2x_3v64x8m81_3[3]/018SRAM_strap1_3v64x8m81_1/w_91_512#
+ wl[7] wl[7] VSUBS 018SRAM_strap1_2x_3v64x8m81_3[3]/018SRAM_strap1_3v64x8m81_1/w_91_512#
+ 018SRAM_strap1_2x_3v64x8m81_3[3]/018SRAM_strap1_3v64x8m81_1/w_91_512# b[17] VSUBS
+ bb[17] x018SRAM_cell1_2x_3v64x8m81
X018SRAM_cell1_2x_3v64x8m81_1[0|7] wl[0] 018SRAM_strap1_2x_3v64x8m81_3[3]/018SRAM_strap1_3v64x8m81_1/w_91_512#
+ wl[0] VSUBS 018SRAM_strap1_2x_3v64x8m81_3[3]/018SRAM_strap1_3v64x8m81_1/w_91_512#
+ wl[1] wl[1] VSUBS 018SRAM_strap1_2x_3v64x8m81_3[3]/018SRAM_strap1_3v64x8m81_1/w_91_512#
+ 018SRAM_strap1_2x_3v64x8m81_3[3]/018SRAM_strap1_3v64x8m81_1/w_91_512# bb[16] VSUBS
+ b[16] x018SRAM_cell1_2x_3v64x8m81
X018SRAM_cell1_2x_3v64x8m81_1[1|7] wl[2] 018SRAM_strap1_2x_3v64x8m81_3[3]/018SRAM_strap1_3v64x8m81_1/w_91_512#
+ wl[2] VSUBS 018SRAM_strap1_2x_3v64x8m81_3[3]/018SRAM_strap1_3v64x8m81_1/w_91_512#
+ wl[3] wl[3] VSUBS 018SRAM_strap1_2x_3v64x8m81_3[3]/018SRAM_strap1_3v64x8m81_1/w_91_512#
+ 018SRAM_strap1_2x_3v64x8m81_3[3]/018SRAM_strap1_3v64x8m81_1/w_91_512# bb[16] VSUBS
+ b[16] x018SRAM_cell1_2x_3v64x8m81
X018SRAM_cell1_2x_3v64x8m81_1[2|7] wl[4] 018SRAM_strap1_2x_3v64x8m81_3[3]/018SRAM_strap1_3v64x8m81_1/w_91_512#
+ wl[4] VSUBS 018SRAM_strap1_2x_3v64x8m81_3[3]/018SRAM_strap1_3v64x8m81_1/w_91_512#
+ wl[5] wl[5] VSUBS 018SRAM_strap1_2x_3v64x8m81_3[3]/018SRAM_strap1_3v64x8m81_1/w_91_512#
+ 018SRAM_strap1_2x_3v64x8m81_3[3]/018SRAM_strap1_3v64x8m81_1/w_91_512# bb[16] VSUBS
+ b[16] x018SRAM_cell1_2x_3v64x8m81
X018SRAM_cell1_2x_3v64x8m81_1[3|7] wl[6] 018SRAM_strap1_2x_3v64x8m81_3[3]/018SRAM_strap1_3v64x8m81_1/w_91_512#
+ wl[6] VSUBS 018SRAM_strap1_2x_3v64x8m81_3[3]/018SRAM_strap1_3v64x8m81_1/w_91_512#
+ wl[7] wl[7] VSUBS 018SRAM_strap1_2x_3v64x8m81_3[3]/018SRAM_strap1_3v64x8m81_1/w_91_512#
+ 018SRAM_strap1_2x_3v64x8m81_3[3]/018SRAM_strap1_3v64x8m81_1/w_91_512# bb[16] VSUBS
+ b[16] x018SRAM_cell1_2x_3v64x8m81
X018SRAM_cell1_2x_3v64x8m81_2[0|0] wl[0] 018SRAM_strap1_2x_3v64x8m81_3[3]/018SRAM_strap1_3v64x8m81_1/w_91_512#
+ wl[0] VSUBS 018SRAM_strap1_2x_3v64x8m81_3[3]/018SRAM_strap1_3v64x8m81_1/w_91_512#
+ wl[1] wl[1] VSUBS 018SRAM_strap1_2x_3v64x8m81_3[3]/018SRAM_strap1_3v64x8m81_1/w_91_512#
+ 018SRAM_strap1_2x_3v64x8m81_3[3]/018SRAM_strap1_3v64x8m81_1/w_91_512# bb[31] VSUBS
+ b[31] x018SRAM_cell1_2x_3v64x8m81
X018SRAM_cell1_2x_3v64x8m81_2[1|0] wl[2] 018SRAM_strap1_2x_3v64x8m81_3[3]/018SRAM_strap1_3v64x8m81_1/w_91_512#
+ wl[2] VSUBS 018SRAM_strap1_2x_3v64x8m81_3[3]/018SRAM_strap1_3v64x8m81_1/w_91_512#
+ wl[3] wl[3] VSUBS 018SRAM_strap1_2x_3v64x8m81_3[3]/018SRAM_strap1_3v64x8m81_1/w_91_512#
+ 018SRAM_strap1_2x_3v64x8m81_3[3]/018SRAM_strap1_3v64x8m81_1/w_91_512# bb[31] VSUBS
+ b[31] x018SRAM_cell1_2x_3v64x8m81
X018SRAM_cell1_2x_3v64x8m81_2[2|0] wl[4] 018SRAM_strap1_2x_3v64x8m81_3[3]/018SRAM_strap1_3v64x8m81_1/w_91_512#
+ wl[4] VSUBS 018SRAM_strap1_2x_3v64x8m81_3[3]/018SRAM_strap1_3v64x8m81_1/w_91_512#
+ wl[5] wl[5] VSUBS 018SRAM_strap1_2x_3v64x8m81_3[3]/018SRAM_strap1_3v64x8m81_1/w_91_512#
+ 018SRAM_strap1_2x_3v64x8m81_3[3]/018SRAM_strap1_3v64x8m81_1/w_91_512# bb[31] VSUBS
+ b[31] x018SRAM_cell1_2x_3v64x8m81
X018SRAM_cell1_2x_3v64x8m81_2[3|0] wl[6] 018SRAM_strap1_2x_3v64x8m81_3[3]/018SRAM_strap1_3v64x8m81_1/w_91_512#
+ wl[6] VSUBS 018SRAM_strap1_2x_3v64x8m81_3[3]/018SRAM_strap1_3v64x8m81_1/w_91_512#
+ wl[7] wl[7] VSUBS 018SRAM_strap1_2x_3v64x8m81_3[3]/018SRAM_strap1_3v64x8m81_1/w_91_512#
+ 018SRAM_strap1_2x_3v64x8m81_3[3]/018SRAM_strap1_3v64x8m81_1/w_91_512# bb[31] VSUBS
+ b[31] x018SRAM_cell1_2x_3v64x8m81
X018SRAM_cell1_2x_3v64x8m81_2[0|1] wl[0] 018SRAM_strap1_2x_3v64x8m81_3[3]/018SRAM_strap1_3v64x8m81_1/w_91_512#
+ wl[0] VSUBS 018SRAM_strap1_2x_3v64x8m81_3[3]/018SRAM_strap1_3v64x8m81_1/w_91_512#
+ wl[1] wl[1] VSUBS 018SRAM_strap1_2x_3v64x8m81_3[3]/018SRAM_strap1_3v64x8m81_1/w_91_512#
+ 018SRAM_strap1_2x_3v64x8m81_3[3]/018SRAM_strap1_3v64x8m81_1/w_91_512# b[30] VSUBS
+ bb[30] x018SRAM_cell1_2x_3v64x8m81
X018SRAM_cell1_2x_3v64x8m81_2[1|1] wl[2] 018SRAM_strap1_2x_3v64x8m81_3[3]/018SRAM_strap1_3v64x8m81_1/w_91_512#
+ wl[2] VSUBS 018SRAM_strap1_2x_3v64x8m81_3[3]/018SRAM_strap1_3v64x8m81_1/w_91_512#
+ wl[3] wl[3] VSUBS 018SRAM_strap1_2x_3v64x8m81_3[3]/018SRAM_strap1_3v64x8m81_1/w_91_512#
+ 018SRAM_strap1_2x_3v64x8m81_3[3]/018SRAM_strap1_3v64x8m81_1/w_91_512# b[30] VSUBS
+ bb[30] x018SRAM_cell1_2x_3v64x8m81
X018SRAM_cell1_2x_3v64x8m81_2[2|1] wl[4] 018SRAM_strap1_2x_3v64x8m81_3[3]/018SRAM_strap1_3v64x8m81_1/w_91_512#
+ wl[4] VSUBS 018SRAM_strap1_2x_3v64x8m81_3[3]/018SRAM_strap1_3v64x8m81_1/w_91_512#
+ wl[5] wl[5] VSUBS 018SRAM_strap1_2x_3v64x8m81_3[3]/018SRAM_strap1_3v64x8m81_1/w_91_512#
+ 018SRAM_strap1_2x_3v64x8m81_3[3]/018SRAM_strap1_3v64x8m81_1/w_91_512# b[30] VSUBS
+ bb[30] x018SRAM_cell1_2x_3v64x8m81
X018SRAM_cell1_2x_3v64x8m81_2[3|1] wl[6] 018SRAM_strap1_2x_3v64x8m81_3[3]/018SRAM_strap1_3v64x8m81_1/w_91_512#
+ wl[6] VSUBS 018SRAM_strap1_2x_3v64x8m81_3[3]/018SRAM_strap1_3v64x8m81_1/w_91_512#
+ wl[7] wl[7] VSUBS 018SRAM_strap1_2x_3v64x8m81_3[3]/018SRAM_strap1_3v64x8m81_1/w_91_512#
+ 018SRAM_strap1_2x_3v64x8m81_3[3]/018SRAM_strap1_3v64x8m81_1/w_91_512# b[30] VSUBS
+ bb[30] x018SRAM_cell1_2x_3v64x8m81
X018SRAM_cell1_2x_3v64x8m81_2[0|2] wl[0] 018SRAM_strap1_2x_3v64x8m81_3[3]/018SRAM_strap1_3v64x8m81_1/w_91_512#
+ wl[0] VSUBS 018SRAM_strap1_2x_3v64x8m81_3[3]/018SRAM_strap1_3v64x8m81_1/w_91_512#
+ wl[1] wl[1] VSUBS 018SRAM_strap1_2x_3v64x8m81_3[3]/018SRAM_strap1_3v64x8m81_1/w_91_512#
+ 018SRAM_strap1_2x_3v64x8m81_3[3]/018SRAM_strap1_3v64x8m81_1/w_91_512# bb[29] VSUBS
+ b[29] x018SRAM_cell1_2x_3v64x8m81
X018SRAM_cell1_2x_3v64x8m81_2[1|2] wl[2] 018SRAM_strap1_2x_3v64x8m81_3[3]/018SRAM_strap1_3v64x8m81_1/w_91_512#
+ wl[2] VSUBS 018SRAM_strap1_2x_3v64x8m81_3[3]/018SRAM_strap1_3v64x8m81_1/w_91_512#
+ wl[3] wl[3] VSUBS 018SRAM_strap1_2x_3v64x8m81_3[3]/018SRAM_strap1_3v64x8m81_1/w_91_512#
+ 018SRAM_strap1_2x_3v64x8m81_3[3]/018SRAM_strap1_3v64x8m81_1/w_91_512# bb[29] VSUBS
+ b[29] x018SRAM_cell1_2x_3v64x8m81
X018SRAM_cell1_2x_3v64x8m81_2[2|2] wl[4] 018SRAM_strap1_2x_3v64x8m81_3[3]/018SRAM_strap1_3v64x8m81_1/w_91_512#
+ wl[4] VSUBS 018SRAM_strap1_2x_3v64x8m81_3[3]/018SRAM_strap1_3v64x8m81_1/w_91_512#
+ wl[5] wl[5] VSUBS 018SRAM_strap1_2x_3v64x8m81_3[3]/018SRAM_strap1_3v64x8m81_1/w_91_512#
+ 018SRAM_strap1_2x_3v64x8m81_3[3]/018SRAM_strap1_3v64x8m81_1/w_91_512# bb[29] VSUBS
+ b[29] x018SRAM_cell1_2x_3v64x8m81
X018SRAM_cell1_2x_3v64x8m81_2[3|2] wl[6] 018SRAM_strap1_2x_3v64x8m81_3[3]/018SRAM_strap1_3v64x8m81_1/w_91_512#
+ wl[6] VSUBS 018SRAM_strap1_2x_3v64x8m81_3[3]/018SRAM_strap1_3v64x8m81_1/w_91_512#
+ wl[7] wl[7] VSUBS 018SRAM_strap1_2x_3v64x8m81_3[3]/018SRAM_strap1_3v64x8m81_1/w_91_512#
+ 018SRAM_strap1_2x_3v64x8m81_3[3]/018SRAM_strap1_3v64x8m81_1/w_91_512# bb[29] VSUBS
+ b[29] x018SRAM_cell1_2x_3v64x8m81
X018SRAM_cell1_2x_3v64x8m81_2[0|3] wl[0] 018SRAM_strap1_2x_3v64x8m81_3[3]/018SRAM_strap1_3v64x8m81_1/w_91_512#
+ wl[0] VSUBS 018SRAM_strap1_2x_3v64x8m81_3[3]/018SRAM_strap1_3v64x8m81_1/w_91_512#
+ wl[1] wl[1] VSUBS 018SRAM_strap1_2x_3v64x8m81_3[3]/018SRAM_strap1_3v64x8m81_1/w_91_512#
+ 018SRAM_strap1_2x_3v64x8m81_3[3]/018SRAM_strap1_3v64x8m81_1/w_91_512# b[28] VSUBS
+ bb[28] x018SRAM_cell1_2x_3v64x8m81
X018SRAM_cell1_2x_3v64x8m81_2[1|3] wl[2] 018SRAM_strap1_2x_3v64x8m81_3[3]/018SRAM_strap1_3v64x8m81_1/w_91_512#
+ wl[2] VSUBS 018SRAM_strap1_2x_3v64x8m81_3[3]/018SRAM_strap1_3v64x8m81_1/w_91_512#
+ wl[3] wl[3] VSUBS 018SRAM_strap1_2x_3v64x8m81_3[3]/018SRAM_strap1_3v64x8m81_1/w_91_512#
+ 018SRAM_strap1_2x_3v64x8m81_3[3]/018SRAM_strap1_3v64x8m81_1/w_91_512# b[28] VSUBS
+ bb[28] x018SRAM_cell1_2x_3v64x8m81
X018SRAM_cell1_2x_3v64x8m81_2[2|3] wl[4] 018SRAM_strap1_2x_3v64x8m81_3[3]/018SRAM_strap1_3v64x8m81_1/w_91_512#
+ wl[4] VSUBS 018SRAM_strap1_2x_3v64x8m81_3[3]/018SRAM_strap1_3v64x8m81_1/w_91_512#
+ wl[5] wl[5] VSUBS 018SRAM_strap1_2x_3v64x8m81_3[3]/018SRAM_strap1_3v64x8m81_1/w_91_512#
+ 018SRAM_strap1_2x_3v64x8m81_3[3]/018SRAM_strap1_3v64x8m81_1/w_91_512# b[28] VSUBS
+ bb[28] x018SRAM_cell1_2x_3v64x8m81
X018SRAM_cell1_2x_3v64x8m81_2[3|3] wl[6] 018SRAM_strap1_2x_3v64x8m81_3[3]/018SRAM_strap1_3v64x8m81_1/w_91_512#
+ wl[6] VSUBS 018SRAM_strap1_2x_3v64x8m81_3[3]/018SRAM_strap1_3v64x8m81_1/w_91_512#
+ wl[7] wl[7] VSUBS 018SRAM_strap1_2x_3v64x8m81_3[3]/018SRAM_strap1_3v64x8m81_1/w_91_512#
+ 018SRAM_strap1_2x_3v64x8m81_3[3]/018SRAM_strap1_3v64x8m81_1/w_91_512# b[28] VSUBS
+ bb[28] x018SRAM_cell1_2x_3v64x8m81
X018SRAM_cell1_2x_3v64x8m81_2[0|4] wl[0] 018SRAM_strap1_2x_3v64x8m81_3[3]/018SRAM_strap1_3v64x8m81_1/w_91_512#
+ wl[0] VSUBS 018SRAM_strap1_2x_3v64x8m81_3[3]/018SRAM_strap1_3v64x8m81_1/w_91_512#
+ wl[1] wl[1] VSUBS 018SRAM_strap1_2x_3v64x8m81_3[3]/018SRAM_strap1_3v64x8m81_1/w_91_512#
+ 018SRAM_strap1_2x_3v64x8m81_3[3]/018SRAM_strap1_3v64x8m81_1/w_91_512# bb[27] VSUBS
+ b[27] x018SRAM_cell1_2x_3v64x8m81
X018SRAM_cell1_2x_3v64x8m81_2[1|4] wl[2] 018SRAM_strap1_2x_3v64x8m81_3[3]/018SRAM_strap1_3v64x8m81_1/w_91_512#
+ wl[2] VSUBS 018SRAM_strap1_2x_3v64x8m81_3[3]/018SRAM_strap1_3v64x8m81_1/w_91_512#
+ wl[3] wl[3] VSUBS 018SRAM_strap1_2x_3v64x8m81_3[3]/018SRAM_strap1_3v64x8m81_1/w_91_512#
+ 018SRAM_strap1_2x_3v64x8m81_3[3]/018SRAM_strap1_3v64x8m81_1/w_91_512# bb[27] VSUBS
+ b[27] x018SRAM_cell1_2x_3v64x8m81
X018SRAM_cell1_2x_3v64x8m81_2[2|4] wl[4] 018SRAM_strap1_2x_3v64x8m81_3[3]/018SRAM_strap1_3v64x8m81_1/w_91_512#
+ wl[4] VSUBS 018SRAM_strap1_2x_3v64x8m81_3[3]/018SRAM_strap1_3v64x8m81_1/w_91_512#
+ wl[5] wl[5] VSUBS 018SRAM_strap1_2x_3v64x8m81_3[3]/018SRAM_strap1_3v64x8m81_1/w_91_512#
+ 018SRAM_strap1_2x_3v64x8m81_3[3]/018SRAM_strap1_3v64x8m81_1/w_91_512# bb[27] VSUBS
+ b[27] x018SRAM_cell1_2x_3v64x8m81
X018SRAM_cell1_2x_3v64x8m81_2[3|4] wl[6] 018SRAM_strap1_2x_3v64x8m81_3[3]/018SRAM_strap1_3v64x8m81_1/w_91_512#
+ wl[6] VSUBS 018SRAM_strap1_2x_3v64x8m81_3[3]/018SRAM_strap1_3v64x8m81_1/w_91_512#
+ wl[7] wl[7] VSUBS 018SRAM_strap1_2x_3v64x8m81_3[3]/018SRAM_strap1_3v64x8m81_1/w_91_512#
+ 018SRAM_strap1_2x_3v64x8m81_3[3]/018SRAM_strap1_3v64x8m81_1/w_91_512# bb[27] VSUBS
+ b[27] x018SRAM_cell1_2x_3v64x8m81
X018SRAM_cell1_2x_3v64x8m81_2[0|5] wl[0] 018SRAM_strap1_2x_3v64x8m81_3[3]/018SRAM_strap1_3v64x8m81_1/w_91_512#
+ wl[0] VSUBS 018SRAM_strap1_2x_3v64x8m81_3[3]/018SRAM_strap1_3v64x8m81_1/w_91_512#
+ wl[1] wl[1] VSUBS 018SRAM_strap1_2x_3v64x8m81_3[3]/018SRAM_strap1_3v64x8m81_1/w_91_512#
+ 018SRAM_strap1_2x_3v64x8m81_3[3]/018SRAM_strap1_3v64x8m81_1/w_91_512# b[26] VSUBS
+ bb[26] x018SRAM_cell1_2x_3v64x8m81
X018SRAM_cell1_2x_3v64x8m81_2[1|5] wl[2] 018SRAM_strap1_2x_3v64x8m81_3[3]/018SRAM_strap1_3v64x8m81_1/w_91_512#
+ wl[2] VSUBS 018SRAM_strap1_2x_3v64x8m81_3[3]/018SRAM_strap1_3v64x8m81_1/w_91_512#
+ wl[3] wl[3] VSUBS 018SRAM_strap1_2x_3v64x8m81_3[3]/018SRAM_strap1_3v64x8m81_1/w_91_512#
+ 018SRAM_strap1_2x_3v64x8m81_3[3]/018SRAM_strap1_3v64x8m81_1/w_91_512# b[26] VSUBS
+ bb[26] x018SRAM_cell1_2x_3v64x8m81
X018SRAM_cell1_2x_3v64x8m81_2[2|5] wl[4] 018SRAM_strap1_2x_3v64x8m81_3[3]/018SRAM_strap1_3v64x8m81_1/w_91_512#
+ wl[4] VSUBS 018SRAM_strap1_2x_3v64x8m81_3[3]/018SRAM_strap1_3v64x8m81_1/w_91_512#
+ wl[5] wl[5] VSUBS 018SRAM_strap1_2x_3v64x8m81_3[3]/018SRAM_strap1_3v64x8m81_1/w_91_512#
+ 018SRAM_strap1_2x_3v64x8m81_3[3]/018SRAM_strap1_3v64x8m81_1/w_91_512# b[26] VSUBS
+ bb[26] x018SRAM_cell1_2x_3v64x8m81
X018SRAM_cell1_2x_3v64x8m81_2[3|5] wl[6] 018SRAM_strap1_2x_3v64x8m81_3[3]/018SRAM_strap1_3v64x8m81_1/w_91_512#
+ wl[6] VSUBS 018SRAM_strap1_2x_3v64x8m81_3[3]/018SRAM_strap1_3v64x8m81_1/w_91_512#
+ wl[7] wl[7] VSUBS 018SRAM_strap1_2x_3v64x8m81_3[3]/018SRAM_strap1_3v64x8m81_1/w_91_512#
+ 018SRAM_strap1_2x_3v64x8m81_3[3]/018SRAM_strap1_3v64x8m81_1/w_91_512# b[26] VSUBS
+ bb[26] x018SRAM_cell1_2x_3v64x8m81
X018SRAM_cell1_2x_3v64x8m81_2[0|6] wl[0] 018SRAM_strap1_2x_3v64x8m81_3[3]/018SRAM_strap1_3v64x8m81_1/w_91_512#
+ wl[0] VSUBS 018SRAM_strap1_2x_3v64x8m81_3[3]/018SRAM_strap1_3v64x8m81_1/w_91_512#
+ wl[1] wl[1] VSUBS 018SRAM_strap1_2x_3v64x8m81_3[3]/018SRAM_strap1_3v64x8m81_1/w_91_512#
+ 018SRAM_strap1_2x_3v64x8m81_3[3]/018SRAM_strap1_3v64x8m81_1/w_91_512# bb[25] VSUBS
+ b[25] x018SRAM_cell1_2x_3v64x8m81
X018SRAM_cell1_2x_3v64x8m81_2[1|6] wl[2] 018SRAM_strap1_2x_3v64x8m81_3[3]/018SRAM_strap1_3v64x8m81_1/w_91_512#
+ wl[2] VSUBS 018SRAM_strap1_2x_3v64x8m81_3[3]/018SRAM_strap1_3v64x8m81_1/w_91_512#
+ wl[3] wl[3] VSUBS 018SRAM_strap1_2x_3v64x8m81_3[3]/018SRAM_strap1_3v64x8m81_1/w_91_512#
+ 018SRAM_strap1_2x_3v64x8m81_3[3]/018SRAM_strap1_3v64x8m81_1/w_91_512# bb[25] VSUBS
+ b[25] x018SRAM_cell1_2x_3v64x8m81
X018SRAM_cell1_2x_3v64x8m81_2[2|6] wl[4] 018SRAM_strap1_2x_3v64x8m81_3[3]/018SRAM_strap1_3v64x8m81_1/w_91_512#
+ wl[4] VSUBS 018SRAM_strap1_2x_3v64x8m81_3[3]/018SRAM_strap1_3v64x8m81_1/w_91_512#
+ wl[5] wl[5] VSUBS 018SRAM_strap1_2x_3v64x8m81_3[3]/018SRAM_strap1_3v64x8m81_1/w_91_512#
+ 018SRAM_strap1_2x_3v64x8m81_3[3]/018SRAM_strap1_3v64x8m81_1/w_91_512# bb[25] VSUBS
+ b[25] x018SRAM_cell1_2x_3v64x8m81
X018SRAM_cell1_2x_3v64x8m81_2[3|6] wl[6] 018SRAM_strap1_2x_3v64x8m81_3[3]/018SRAM_strap1_3v64x8m81_1/w_91_512#
+ wl[6] VSUBS 018SRAM_strap1_2x_3v64x8m81_3[3]/018SRAM_strap1_3v64x8m81_1/w_91_512#
+ wl[7] wl[7] VSUBS 018SRAM_strap1_2x_3v64x8m81_3[3]/018SRAM_strap1_3v64x8m81_1/w_91_512#
+ 018SRAM_strap1_2x_3v64x8m81_3[3]/018SRAM_strap1_3v64x8m81_1/w_91_512# bb[25] VSUBS
+ b[25] x018SRAM_cell1_2x_3v64x8m81
X018SRAM_cell1_2x_3v64x8m81_2[0|7] wl[0] 018SRAM_strap1_2x_3v64x8m81_3[3]/018SRAM_strap1_3v64x8m81_1/w_91_512#
+ wl[0] VSUBS 018SRAM_strap1_2x_3v64x8m81_3[3]/018SRAM_strap1_3v64x8m81_1/w_91_512#
+ wl[1] wl[1] VSUBS 018SRAM_strap1_2x_3v64x8m81_3[3]/018SRAM_strap1_3v64x8m81_1/w_91_512#
+ 018SRAM_strap1_2x_3v64x8m81_3[3]/018SRAM_strap1_3v64x8m81_1/w_91_512# b[24] VSUBS
+ bb[24] x018SRAM_cell1_2x_3v64x8m81
X018SRAM_cell1_2x_3v64x8m81_2[1|7] wl[2] 018SRAM_strap1_2x_3v64x8m81_3[3]/018SRAM_strap1_3v64x8m81_1/w_91_512#
+ wl[2] VSUBS 018SRAM_strap1_2x_3v64x8m81_3[3]/018SRAM_strap1_3v64x8m81_1/w_91_512#
+ wl[3] wl[3] VSUBS 018SRAM_strap1_2x_3v64x8m81_3[3]/018SRAM_strap1_3v64x8m81_1/w_91_512#
+ 018SRAM_strap1_2x_3v64x8m81_3[3]/018SRAM_strap1_3v64x8m81_1/w_91_512# b[24] VSUBS
+ bb[24] x018SRAM_cell1_2x_3v64x8m81
X018SRAM_cell1_2x_3v64x8m81_2[2|7] wl[4] 018SRAM_strap1_2x_3v64x8m81_3[3]/018SRAM_strap1_3v64x8m81_1/w_91_512#
+ wl[4] VSUBS 018SRAM_strap1_2x_3v64x8m81_3[3]/018SRAM_strap1_3v64x8m81_1/w_91_512#
+ wl[5] wl[5] VSUBS 018SRAM_strap1_2x_3v64x8m81_3[3]/018SRAM_strap1_3v64x8m81_1/w_91_512#
+ 018SRAM_strap1_2x_3v64x8m81_3[3]/018SRAM_strap1_3v64x8m81_1/w_91_512# b[24] VSUBS
+ bb[24] x018SRAM_cell1_2x_3v64x8m81
X018SRAM_cell1_2x_3v64x8m81_2[3|7] wl[6] 018SRAM_strap1_2x_3v64x8m81_3[3]/018SRAM_strap1_3v64x8m81_1/w_91_512#
+ wl[6] VSUBS 018SRAM_strap1_2x_3v64x8m81_3[3]/018SRAM_strap1_3v64x8m81_1/w_91_512#
+ wl[7] wl[7] VSUBS 018SRAM_strap1_2x_3v64x8m81_3[3]/018SRAM_strap1_3v64x8m81_1/w_91_512#
+ 018SRAM_strap1_2x_3v64x8m81_3[3]/018SRAM_strap1_3v64x8m81_1/w_91_512# b[24] VSUBS
+ bb[24] x018SRAM_cell1_2x_3v64x8m81
X018SRAM_cell1_2x_3v64x8m81_3[0|0] wl[0] 018SRAM_strap1_2x_3v64x8m81_3[3]/018SRAM_strap1_3v64x8m81_1/w_91_512#
+ wl[0] VSUBS 018SRAM_strap1_2x_3v64x8m81_3[3]/018SRAM_strap1_3v64x8m81_1/w_91_512#
+ wl[1] wl[1] VSUBS 018SRAM_strap1_2x_3v64x8m81_3[3]/018SRAM_strap1_3v64x8m81_1/w_91_512#
+ 018SRAM_strap1_2x_3v64x8m81_3[3]/018SRAM_strap1_3v64x8m81_1/w_91_512# bb[15] VSUBS
+ b[15] x018SRAM_cell1_2x_3v64x8m81
X018SRAM_cell1_2x_3v64x8m81_3[1|0] wl[2] 018SRAM_strap1_2x_3v64x8m81_3[3]/018SRAM_strap1_3v64x8m81_1/w_91_512#
+ wl[2] VSUBS 018SRAM_strap1_2x_3v64x8m81_3[3]/018SRAM_strap1_3v64x8m81_1/w_91_512#
+ wl[3] wl[3] VSUBS 018SRAM_strap1_2x_3v64x8m81_3[3]/018SRAM_strap1_3v64x8m81_1/w_91_512#
+ 018SRAM_strap1_2x_3v64x8m81_3[3]/018SRAM_strap1_3v64x8m81_1/w_91_512# bb[15] VSUBS
+ b[15] x018SRAM_cell1_2x_3v64x8m81
X018SRAM_cell1_2x_3v64x8m81_3[2|0] wl[4] 018SRAM_strap1_2x_3v64x8m81_3[3]/018SRAM_strap1_3v64x8m81_1/w_91_512#
+ wl[4] VSUBS 018SRAM_strap1_2x_3v64x8m81_3[3]/018SRAM_strap1_3v64x8m81_1/w_91_512#
+ wl[5] wl[5] VSUBS 018SRAM_strap1_2x_3v64x8m81_3[3]/018SRAM_strap1_3v64x8m81_1/w_91_512#
+ 018SRAM_strap1_2x_3v64x8m81_3[3]/018SRAM_strap1_3v64x8m81_1/w_91_512# bb[15] VSUBS
+ b[15] x018SRAM_cell1_2x_3v64x8m81
X018SRAM_cell1_2x_3v64x8m81_3[3|0] wl[6] 018SRAM_strap1_2x_3v64x8m81_3[3]/018SRAM_strap1_3v64x8m81_1/w_91_512#
+ wl[6] VSUBS 018SRAM_strap1_2x_3v64x8m81_3[3]/018SRAM_strap1_3v64x8m81_1/w_91_512#
+ wl[7] wl[7] VSUBS 018SRAM_strap1_2x_3v64x8m81_3[3]/018SRAM_strap1_3v64x8m81_1/w_91_512#
+ 018SRAM_strap1_2x_3v64x8m81_3[3]/018SRAM_strap1_3v64x8m81_1/w_91_512# bb[15] VSUBS
+ b[15] x018SRAM_cell1_2x_3v64x8m81
X018SRAM_cell1_2x_3v64x8m81_3[0|1] wl[0] 018SRAM_strap1_2x_3v64x8m81_3[3]/018SRAM_strap1_3v64x8m81_1/w_91_512#
+ wl[0] VSUBS 018SRAM_strap1_2x_3v64x8m81_3[3]/018SRAM_strap1_3v64x8m81_1/w_91_512#
+ wl[1] wl[1] VSUBS 018SRAM_strap1_2x_3v64x8m81_3[3]/018SRAM_strap1_3v64x8m81_1/w_91_512#
+ 018SRAM_strap1_2x_3v64x8m81_3[3]/018SRAM_strap1_3v64x8m81_1/w_91_512# b[14] VSUBS
+ bb[14] x018SRAM_cell1_2x_3v64x8m81
X018SRAM_cell1_2x_3v64x8m81_3[1|1] wl[2] 018SRAM_strap1_2x_3v64x8m81_3[3]/018SRAM_strap1_3v64x8m81_1/w_91_512#
+ wl[2] VSUBS 018SRAM_strap1_2x_3v64x8m81_3[3]/018SRAM_strap1_3v64x8m81_1/w_91_512#
+ wl[3] wl[3] VSUBS 018SRAM_strap1_2x_3v64x8m81_3[3]/018SRAM_strap1_3v64x8m81_1/w_91_512#
+ 018SRAM_strap1_2x_3v64x8m81_3[3]/018SRAM_strap1_3v64x8m81_1/w_91_512# b[14] VSUBS
+ bb[14] x018SRAM_cell1_2x_3v64x8m81
X018SRAM_cell1_2x_3v64x8m81_3[2|1] wl[4] 018SRAM_strap1_2x_3v64x8m81_3[3]/018SRAM_strap1_3v64x8m81_1/w_91_512#
+ wl[4] VSUBS 018SRAM_strap1_2x_3v64x8m81_3[3]/018SRAM_strap1_3v64x8m81_1/w_91_512#
+ wl[5] wl[5] VSUBS 018SRAM_strap1_2x_3v64x8m81_3[3]/018SRAM_strap1_3v64x8m81_1/w_91_512#
+ 018SRAM_strap1_2x_3v64x8m81_3[3]/018SRAM_strap1_3v64x8m81_1/w_91_512# b[14] VSUBS
+ bb[14] x018SRAM_cell1_2x_3v64x8m81
X018SRAM_cell1_2x_3v64x8m81_3[3|1] wl[6] 018SRAM_strap1_2x_3v64x8m81_3[3]/018SRAM_strap1_3v64x8m81_1/w_91_512#
+ wl[6] VSUBS 018SRAM_strap1_2x_3v64x8m81_3[3]/018SRAM_strap1_3v64x8m81_1/w_91_512#
+ wl[7] wl[7] VSUBS 018SRAM_strap1_2x_3v64x8m81_3[3]/018SRAM_strap1_3v64x8m81_1/w_91_512#
+ 018SRAM_strap1_2x_3v64x8m81_3[3]/018SRAM_strap1_3v64x8m81_1/w_91_512# b[14] VSUBS
+ bb[14] x018SRAM_cell1_2x_3v64x8m81
X018SRAM_cell1_2x_3v64x8m81_3[0|2] wl[0] 018SRAM_strap1_2x_3v64x8m81_3[3]/018SRAM_strap1_3v64x8m81_1/w_91_512#
+ wl[0] VSUBS 018SRAM_strap1_2x_3v64x8m81_3[3]/018SRAM_strap1_3v64x8m81_1/w_91_512#
+ wl[1] wl[1] VSUBS 018SRAM_strap1_2x_3v64x8m81_3[3]/018SRAM_strap1_3v64x8m81_1/w_91_512#
+ 018SRAM_strap1_2x_3v64x8m81_3[3]/018SRAM_strap1_3v64x8m81_1/w_91_512# bb[13] VSUBS
+ b[13] x018SRAM_cell1_2x_3v64x8m81
X018SRAM_cell1_2x_3v64x8m81_3[1|2] wl[2] 018SRAM_strap1_2x_3v64x8m81_3[3]/018SRAM_strap1_3v64x8m81_1/w_91_512#
+ wl[2] VSUBS 018SRAM_strap1_2x_3v64x8m81_3[3]/018SRAM_strap1_3v64x8m81_1/w_91_512#
+ wl[3] wl[3] VSUBS 018SRAM_strap1_2x_3v64x8m81_3[3]/018SRAM_strap1_3v64x8m81_1/w_91_512#
+ 018SRAM_strap1_2x_3v64x8m81_3[3]/018SRAM_strap1_3v64x8m81_1/w_91_512# bb[13] VSUBS
+ b[13] x018SRAM_cell1_2x_3v64x8m81
X018SRAM_cell1_2x_3v64x8m81_3[2|2] wl[4] 018SRAM_strap1_2x_3v64x8m81_3[3]/018SRAM_strap1_3v64x8m81_1/w_91_512#
+ wl[4] VSUBS 018SRAM_strap1_2x_3v64x8m81_3[3]/018SRAM_strap1_3v64x8m81_1/w_91_512#
+ wl[5] wl[5] VSUBS 018SRAM_strap1_2x_3v64x8m81_3[3]/018SRAM_strap1_3v64x8m81_1/w_91_512#
+ 018SRAM_strap1_2x_3v64x8m81_3[3]/018SRAM_strap1_3v64x8m81_1/w_91_512# bb[13] VSUBS
+ b[13] x018SRAM_cell1_2x_3v64x8m81
X018SRAM_cell1_2x_3v64x8m81_3[3|2] wl[6] 018SRAM_strap1_2x_3v64x8m81_3[3]/018SRAM_strap1_3v64x8m81_1/w_91_512#
+ wl[6] VSUBS 018SRAM_strap1_2x_3v64x8m81_3[3]/018SRAM_strap1_3v64x8m81_1/w_91_512#
+ wl[7] wl[7] VSUBS 018SRAM_strap1_2x_3v64x8m81_3[3]/018SRAM_strap1_3v64x8m81_1/w_91_512#
+ 018SRAM_strap1_2x_3v64x8m81_3[3]/018SRAM_strap1_3v64x8m81_1/w_91_512# bb[13] VSUBS
+ b[13] x018SRAM_cell1_2x_3v64x8m81
X018SRAM_cell1_2x_3v64x8m81_3[0|3] wl[0] 018SRAM_strap1_2x_3v64x8m81_3[3]/018SRAM_strap1_3v64x8m81_1/w_91_512#
+ wl[0] VSUBS 018SRAM_strap1_2x_3v64x8m81_3[3]/018SRAM_strap1_3v64x8m81_1/w_91_512#
+ wl[1] wl[1] VSUBS 018SRAM_strap1_2x_3v64x8m81_3[3]/018SRAM_strap1_3v64x8m81_1/w_91_512#
+ 018SRAM_strap1_2x_3v64x8m81_3[3]/018SRAM_strap1_3v64x8m81_1/w_91_512# b[12] VSUBS
+ bb[12] x018SRAM_cell1_2x_3v64x8m81
X018SRAM_cell1_2x_3v64x8m81_3[1|3] wl[2] 018SRAM_strap1_2x_3v64x8m81_3[3]/018SRAM_strap1_3v64x8m81_1/w_91_512#
+ wl[2] VSUBS 018SRAM_strap1_2x_3v64x8m81_3[3]/018SRAM_strap1_3v64x8m81_1/w_91_512#
+ wl[3] wl[3] VSUBS 018SRAM_strap1_2x_3v64x8m81_3[3]/018SRAM_strap1_3v64x8m81_1/w_91_512#
+ 018SRAM_strap1_2x_3v64x8m81_3[3]/018SRAM_strap1_3v64x8m81_1/w_91_512# b[12] VSUBS
+ bb[12] x018SRAM_cell1_2x_3v64x8m81
X018SRAM_cell1_2x_3v64x8m81_3[2|3] wl[4] 018SRAM_strap1_2x_3v64x8m81_3[3]/018SRAM_strap1_3v64x8m81_1/w_91_512#
+ wl[4] VSUBS 018SRAM_strap1_2x_3v64x8m81_3[3]/018SRAM_strap1_3v64x8m81_1/w_91_512#
+ wl[5] wl[5] VSUBS 018SRAM_strap1_2x_3v64x8m81_3[3]/018SRAM_strap1_3v64x8m81_1/w_91_512#
+ 018SRAM_strap1_2x_3v64x8m81_3[3]/018SRAM_strap1_3v64x8m81_1/w_91_512# b[12] VSUBS
+ bb[12] x018SRAM_cell1_2x_3v64x8m81
X018SRAM_cell1_2x_3v64x8m81_3[3|3] wl[6] 018SRAM_strap1_2x_3v64x8m81_3[3]/018SRAM_strap1_3v64x8m81_1/w_91_512#
+ wl[6] VSUBS 018SRAM_strap1_2x_3v64x8m81_3[3]/018SRAM_strap1_3v64x8m81_1/w_91_512#
+ wl[7] wl[7] VSUBS 018SRAM_strap1_2x_3v64x8m81_3[3]/018SRAM_strap1_3v64x8m81_1/w_91_512#
+ 018SRAM_strap1_2x_3v64x8m81_3[3]/018SRAM_strap1_3v64x8m81_1/w_91_512# b[12] VSUBS
+ bb[12] x018SRAM_cell1_2x_3v64x8m81
X018SRAM_cell1_2x_3v64x8m81_3[0|4] wl[0] 018SRAM_strap1_2x_3v64x8m81_3[3]/018SRAM_strap1_3v64x8m81_1/w_91_512#
+ wl[0] VSUBS 018SRAM_strap1_2x_3v64x8m81_3[3]/018SRAM_strap1_3v64x8m81_1/w_91_512#
+ wl[1] wl[1] VSUBS 018SRAM_strap1_2x_3v64x8m81_3[3]/018SRAM_strap1_3v64x8m81_1/w_91_512#
+ 018SRAM_strap1_2x_3v64x8m81_3[3]/018SRAM_strap1_3v64x8m81_1/w_91_512# bb[11] VSUBS
+ b[11] x018SRAM_cell1_2x_3v64x8m81
X018SRAM_cell1_2x_3v64x8m81_3[1|4] wl[2] 018SRAM_strap1_2x_3v64x8m81_3[3]/018SRAM_strap1_3v64x8m81_1/w_91_512#
+ wl[2] VSUBS 018SRAM_strap1_2x_3v64x8m81_3[3]/018SRAM_strap1_3v64x8m81_1/w_91_512#
+ wl[3] wl[3] VSUBS 018SRAM_strap1_2x_3v64x8m81_3[3]/018SRAM_strap1_3v64x8m81_1/w_91_512#
+ 018SRAM_strap1_2x_3v64x8m81_3[3]/018SRAM_strap1_3v64x8m81_1/w_91_512# bb[11] VSUBS
+ b[11] x018SRAM_cell1_2x_3v64x8m81
X018SRAM_cell1_2x_3v64x8m81_3[2|4] wl[4] 018SRAM_strap1_2x_3v64x8m81_3[3]/018SRAM_strap1_3v64x8m81_1/w_91_512#
+ wl[4] VSUBS 018SRAM_strap1_2x_3v64x8m81_3[3]/018SRAM_strap1_3v64x8m81_1/w_91_512#
+ wl[5] wl[5] VSUBS 018SRAM_strap1_2x_3v64x8m81_3[3]/018SRAM_strap1_3v64x8m81_1/w_91_512#
+ 018SRAM_strap1_2x_3v64x8m81_3[3]/018SRAM_strap1_3v64x8m81_1/w_91_512# bb[11] VSUBS
+ b[11] x018SRAM_cell1_2x_3v64x8m81
X018SRAM_cell1_2x_3v64x8m81_3[3|4] wl[6] 018SRAM_strap1_2x_3v64x8m81_3[3]/018SRAM_strap1_3v64x8m81_1/w_91_512#
+ wl[6] VSUBS 018SRAM_strap1_2x_3v64x8m81_3[3]/018SRAM_strap1_3v64x8m81_1/w_91_512#
+ wl[7] wl[7] VSUBS 018SRAM_strap1_2x_3v64x8m81_3[3]/018SRAM_strap1_3v64x8m81_1/w_91_512#
+ 018SRAM_strap1_2x_3v64x8m81_3[3]/018SRAM_strap1_3v64x8m81_1/w_91_512# bb[11] VSUBS
+ b[11] x018SRAM_cell1_2x_3v64x8m81
X018SRAM_cell1_2x_3v64x8m81_3[0|5] wl[0] 018SRAM_strap1_2x_3v64x8m81_3[3]/018SRAM_strap1_3v64x8m81_1/w_91_512#
+ wl[0] VSUBS 018SRAM_strap1_2x_3v64x8m81_3[3]/018SRAM_strap1_3v64x8m81_1/w_91_512#
+ wl[1] wl[1] VSUBS 018SRAM_strap1_2x_3v64x8m81_3[3]/018SRAM_strap1_3v64x8m81_1/w_91_512#
+ 018SRAM_strap1_2x_3v64x8m81_3[3]/018SRAM_strap1_3v64x8m81_1/w_91_512# b[10] VSUBS
+ bb[10] x018SRAM_cell1_2x_3v64x8m81
X018SRAM_cell1_2x_3v64x8m81_3[1|5] wl[2] 018SRAM_strap1_2x_3v64x8m81_3[3]/018SRAM_strap1_3v64x8m81_1/w_91_512#
+ wl[2] VSUBS 018SRAM_strap1_2x_3v64x8m81_3[3]/018SRAM_strap1_3v64x8m81_1/w_91_512#
+ wl[3] wl[3] VSUBS 018SRAM_strap1_2x_3v64x8m81_3[3]/018SRAM_strap1_3v64x8m81_1/w_91_512#
+ 018SRAM_strap1_2x_3v64x8m81_3[3]/018SRAM_strap1_3v64x8m81_1/w_91_512# b[10] VSUBS
+ bb[10] x018SRAM_cell1_2x_3v64x8m81
X018SRAM_cell1_2x_3v64x8m81_3[2|5] wl[4] 018SRAM_strap1_2x_3v64x8m81_3[3]/018SRAM_strap1_3v64x8m81_1/w_91_512#
+ wl[4] VSUBS 018SRAM_strap1_2x_3v64x8m81_3[3]/018SRAM_strap1_3v64x8m81_1/w_91_512#
+ wl[5] wl[5] VSUBS 018SRAM_strap1_2x_3v64x8m81_3[3]/018SRAM_strap1_3v64x8m81_1/w_91_512#
+ 018SRAM_strap1_2x_3v64x8m81_3[3]/018SRAM_strap1_3v64x8m81_1/w_91_512# b[10] VSUBS
+ bb[10] x018SRAM_cell1_2x_3v64x8m81
X018SRAM_cell1_2x_3v64x8m81_3[3|5] wl[6] 018SRAM_strap1_2x_3v64x8m81_3[3]/018SRAM_strap1_3v64x8m81_1/w_91_512#
+ wl[6] VSUBS 018SRAM_strap1_2x_3v64x8m81_3[3]/018SRAM_strap1_3v64x8m81_1/w_91_512#
+ wl[7] wl[7] VSUBS 018SRAM_strap1_2x_3v64x8m81_3[3]/018SRAM_strap1_3v64x8m81_1/w_91_512#
+ 018SRAM_strap1_2x_3v64x8m81_3[3]/018SRAM_strap1_3v64x8m81_1/w_91_512# b[10] VSUBS
+ bb[10] x018SRAM_cell1_2x_3v64x8m81
X018SRAM_cell1_2x_3v64x8m81_3[0|6] wl[0] 018SRAM_strap1_2x_3v64x8m81_3[3]/018SRAM_strap1_3v64x8m81_1/w_91_512#
+ wl[0] VSUBS 018SRAM_strap1_2x_3v64x8m81_3[3]/018SRAM_strap1_3v64x8m81_1/w_91_512#
+ wl[1] wl[1] VSUBS 018SRAM_strap1_2x_3v64x8m81_3[3]/018SRAM_strap1_3v64x8m81_1/w_91_512#
+ 018SRAM_strap1_2x_3v64x8m81_3[3]/018SRAM_strap1_3v64x8m81_1/w_91_512# bb[9] VSUBS
+ b[9] x018SRAM_cell1_2x_3v64x8m81
X018SRAM_cell1_2x_3v64x8m81_3[1|6] wl[2] 018SRAM_strap1_2x_3v64x8m81_3[3]/018SRAM_strap1_3v64x8m81_1/w_91_512#
+ wl[2] VSUBS 018SRAM_strap1_2x_3v64x8m81_3[3]/018SRAM_strap1_3v64x8m81_1/w_91_512#
+ wl[3] wl[3] VSUBS 018SRAM_strap1_2x_3v64x8m81_3[3]/018SRAM_strap1_3v64x8m81_1/w_91_512#
+ 018SRAM_strap1_2x_3v64x8m81_3[3]/018SRAM_strap1_3v64x8m81_1/w_91_512# bb[9] VSUBS
+ b[9] x018SRAM_cell1_2x_3v64x8m81
X018SRAM_cell1_2x_3v64x8m81_3[2|6] wl[4] 018SRAM_strap1_2x_3v64x8m81_3[3]/018SRAM_strap1_3v64x8m81_1/w_91_512#
+ wl[4] VSUBS 018SRAM_strap1_2x_3v64x8m81_3[3]/018SRAM_strap1_3v64x8m81_1/w_91_512#
+ wl[5] wl[5] VSUBS 018SRAM_strap1_2x_3v64x8m81_3[3]/018SRAM_strap1_3v64x8m81_1/w_91_512#
+ 018SRAM_strap1_2x_3v64x8m81_3[3]/018SRAM_strap1_3v64x8m81_1/w_91_512# bb[9] VSUBS
+ b[9] x018SRAM_cell1_2x_3v64x8m81
X018SRAM_cell1_2x_3v64x8m81_3[3|6] wl[6] 018SRAM_strap1_2x_3v64x8m81_3[3]/018SRAM_strap1_3v64x8m81_1/w_91_512#
+ wl[6] VSUBS 018SRAM_strap1_2x_3v64x8m81_3[3]/018SRAM_strap1_3v64x8m81_1/w_91_512#
+ wl[7] wl[7] VSUBS 018SRAM_strap1_2x_3v64x8m81_3[3]/018SRAM_strap1_3v64x8m81_1/w_91_512#
+ 018SRAM_strap1_2x_3v64x8m81_3[3]/018SRAM_strap1_3v64x8m81_1/w_91_512# bb[9] VSUBS
+ b[9] x018SRAM_cell1_2x_3v64x8m81
X018SRAM_cell1_2x_3v64x8m81_3[0|7] wl[0] 018SRAM_strap1_2x_3v64x8m81_3[3]/018SRAM_strap1_3v64x8m81_1/w_91_512#
+ wl[0] VSUBS 018SRAM_strap1_2x_3v64x8m81_3[3]/018SRAM_strap1_3v64x8m81_1/w_91_512#
+ wl[1] wl[1] VSUBS 018SRAM_strap1_2x_3v64x8m81_3[3]/018SRAM_strap1_3v64x8m81_1/w_91_512#
+ 018SRAM_strap1_2x_3v64x8m81_3[3]/018SRAM_strap1_3v64x8m81_1/w_91_512# b[8] VSUBS
+ bb[8] x018SRAM_cell1_2x_3v64x8m81
X018SRAM_cell1_2x_3v64x8m81_3[1|7] wl[2] 018SRAM_strap1_2x_3v64x8m81_3[3]/018SRAM_strap1_3v64x8m81_1/w_91_512#
+ wl[2] VSUBS 018SRAM_strap1_2x_3v64x8m81_3[3]/018SRAM_strap1_3v64x8m81_1/w_91_512#
+ wl[3] wl[3] VSUBS 018SRAM_strap1_2x_3v64x8m81_3[3]/018SRAM_strap1_3v64x8m81_1/w_91_512#
+ 018SRAM_strap1_2x_3v64x8m81_3[3]/018SRAM_strap1_3v64x8m81_1/w_91_512# b[8] VSUBS
+ bb[8] x018SRAM_cell1_2x_3v64x8m81
X018SRAM_cell1_2x_3v64x8m81_3[2|7] wl[4] 018SRAM_strap1_2x_3v64x8m81_3[3]/018SRAM_strap1_3v64x8m81_1/w_91_512#
+ wl[4] VSUBS 018SRAM_strap1_2x_3v64x8m81_3[3]/018SRAM_strap1_3v64x8m81_1/w_91_512#
+ wl[5] wl[5] VSUBS 018SRAM_strap1_2x_3v64x8m81_3[3]/018SRAM_strap1_3v64x8m81_1/w_91_512#
+ 018SRAM_strap1_2x_3v64x8m81_3[3]/018SRAM_strap1_3v64x8m81_1/w_91_512# b[8] VSUBS
+ bb[8] x018SRAM_cell1_2x_3v64x8m81
X018SRAM_cell1_2x_3v64x8m81_3[3|7] wl[6] 018SRAM_strap1_2x_3v64x8m81_3[3]/018SRAM_strap1_3v64x8m81_1/w_91_512#
+ wl[6] VSUBS 018SRAM_strap1_2x_3v64x8m81_3[3]/018SRAM_strap1_3v64x8m81_1/w_91_512#
+ wl[7] wl[7] VSUBS 018SRAM_strap1_2x_3v64x8m81_3[3]/018SRAM_strap1_3v64x8m81_1/w_91_512#
+ 018SRAM_strap1_2x_3v64x8m81_3[3]/018SRAM_strap1_3v64x8m81_1/w_91_512# b[8] VSUBS
+ bb[8] x018SRAM_cell1_2x_3v64x8m81
.ends

.subckt col_64a_3v64x8m81 ypass[0] ypass[1] ypass[3] ypass[4] ypass[5] WL[32] WL[6]
+ WL[4] ypass[2] b[10] b[13] b[19] b[31] din[1] din[3] din[2] din[0] q[0] q[1] q[2]
+ q[3] b[17] b[14] bb[10] bb[11] bb[12] bb[13] bb[14] bb[15] bb[16] bb[22] bb[24]
+ bb[25] bb[26] bb[28] bb[30] bb[31] b[15] b[12] b[0] pcb[0] pcb[1] pcb[2] WEN[1]
+ WEN[0] VDD_uq5 b[3] b[1] WL[2] b[5] b[6] WL[0] m3_n771_22409# b[4] WL[7] b[2] WL[5]
+ b[8] bb[20] saout_m2_3v64x8m81_4/GWEN WL[3] ypass[6] WL[1] bb[0] ypass[7] bb[1]
+ bb[2] b[11] men bb[23] bb[3] VDD_uq4 b[21] bb[4] b[22] bb[5] VDD_uq1 b[23] b[9]
+ pcb[3] bb[21] bb[6] b[24] bb[7] b[25] b[20] VDD_uq2 bb[8] b[30] bb[9] b[27] VDD
+ bb[18] bb[29] b[18] bb[19] b[29] b[28] bb[17] VDD_uq0 WEN[3] bb[27] VDD_uq3 b[16]
+ GWE WEN[2] b[7] VDD_uq6 b[26] VSS
Xsaout_m2_3v64x8m81_3 ypass[4] ypass[5] saout_m2_3v64x8m81_3/men saout_m2_3v64x8m81_4/GWEN
+ din[0] q[0] pcb[3] b[24] b[27] VDD_uq3 saout_m2_3v64x8m81_3/vss_uq0 bb[25] b[26]
+ bb[29] b[29] bb[24] bb[30] b[30] WEN[3] bb[26] b[31] GWE bb[28] b[28] ypass[0] VDD_uq4
+ ypass[1] ypass[7] VDD ypass[2] men ypass[6] VDD_uq0 VDD_uq2 VDD_uq6 VDD_uq1 VDD_uq5
+ VSS bb[27] bb[31] b[25] ypass[3] saout_m2_3v64x8m81
Xsaout_R_m2_3v64x8m81_0 ypass[1] ypass[3] ypass[4] ypass[5] ypass[0] saout_m2_3v64x8m81_4/GWEN
+ din[3] b[4] b[0] bb[7] q[3] saout_R_m2_3v64x8m81_0/pcb saout_R_m2_3v64x8m81_0/vss_uq6
+ VDD saout_R_m2_3v64x8m81_0/pcb_uq0 saout_R_m2_3v64x8m81_0/datain_uq0 b[2] b[5] bb[1]
+ bb[6] b[1] b[7] GWE bb[5] bb[2] ypass[7] ypass[6] bb[3] b[3] WEN[0] VDD_uq4 VDD_uq3
+ VDD_uq0 men ypass[2] pcb[0] VDD_uq2 VDD_uq6 VDD_uq1 VDD_uq5 bb[4] bb[0] b[6] VSS
+ saout_R_m2_3v64x8m81
Xsaout_R_m2_3v64x8m81_1 ypass[1] ypass[3] ypass[4] ypass[5] ypass[0] saout_m2_3v64x8m81_4/GWEN
+ din[1] b[20] b[16] bb[23] q[1] saout_R_m2_3v64x8m81_1/pcb saout_R_m2_3v64x8m81_1/vss_uq6
+ VDD saout_R_m2_3v64x8m81_1/pcb_uq0 saout_R_m2_3v64x8m81_1/datain_uq0 b[18] b[21]
+ bb[17] bb[22] b[17] b[23] GWE bb[21] bb[18] ypass[7] ypass[6] bb[19] b[19] WEN[2]
+ VDD_uq4 VDD_uq3 VDD_uq0 men ypass[2] pcb[2] VDD_uq2 VDD_uq6 VDD_uq1 VDD_uq5 bb[20]
+ bb[16] b[22] VSS saout_R_m2_3v64x8m81
Xsaout_m2_3v64x8m81_4 ypass[4] ypass[5] saout_m2_3v64x8m81_4/men saout_m2_3v64x8m81_4/GWEN
+ din[2] q[2] pcb[1] b[8] b[11] VDD_uq3 saout_m2_3v64x8m81_4/vss_uq0 bb[9] b[10] bb[13]
+ b[13] bb[8] bb[14] b[14] WEN[1] bb[10] b[15] GWE bb[12] b[12] ypass[0] VDD_uq4 ypass[1]
+ ypass[7] VDD ypass[2] men ypass[6] VDD_uq0 VDD_uq2 VDD_uq6 VDD_uq1 VDD_uq5 VSS bb[11]
+ bb[15] b[9] ypass[3] saout_m2_3v64x8m81
XCell_array8x8_3v64x8m81_0 bb[19] b[20] bb[17] b[7] bb[6] bb[8] b[26] b[5] b[24] bb[4]
+ b[28] b[29] b[3] bb[2] b[27] b[1] bb[7] bb[25] bb[0] bb[26] b[6] b[25] bb[27] bb[5]
+ bb[28] bb[24] b[23] bb[29] b[4] b[10] b[12] bb[22] bb[3] b[30] bb[9] b[14] b[21]
+ b[31] b[2] b[15] b[8] bb[20] b[16] bb[1] b[13] WL[0] b[18] WL[6] WL[3] b[19] bb[18]
+ bb[11] b[11] WL[1] bb[12] b[17] bb[23] WL[7] bb[13] bb[30] bb[10] bb[14] b[22] bb[31]
+ VDD_uq6 b[9] bb[15] WL[4] WL[5] bb[21] WL[2] bb[16] b[0] VSS Cell_array8x8_3v64x8m81
.ends

.subckt dcap_103_novia_3v64x8m81 w_n205_0# a_n30_42# a_n119_86#
X0 a_n119_86# a_n30_42# a_n119_86# w_n205_0# pfet_03v3 ad=0.4717p pd=3.01u as=0 ps=0 w=1.06u l=1.74u
.ends

.subckt x018SRAM_cell1_dummy_3v64x8m81 m3_82_330# a_248_342# a_248_592# w_82_512#
+ a_62_178# m2_346_89# m2_134_89# VSUBS
X0 a_248_592# a_192_298# a_110_250# w_82_512# pfet_03v3 ad=0.1613p pd=1.39u as=0.1238p ps=1.44u w=0.28u l=0.28u
X1 a_248_342# a_192_298# a_110_250# VSUBS nfet_03v3 ad=0.171p pd=1.33u as=0.15665p ps=1.32u w=0.45u l=0.28u
X2 a_192_298# a_110_250# a_248_592# w_82_512# pfet_03v3 ad=0.1238p pd=1.44u as=0.1613p ps=1.39u w=0.28u l=0.28u
X3 a_192_298# a_110_250# a_248_342# VSUBS nfet_03v3 ad=0.15665p pd=1.32u as=0.171p ps=1.33u w=0.45u l=0.28u
X4 a_110_250# a_62_178# a_110_96# VSUBS nfet_03v3 ad=0.15665p pd=1.32u as=0.1208p ps=1.42u w=0.28u l=0.36u
X5 a_192_298# a_62_178# a_430_96# VSUBS nfet_03v3 ad=0.15665p pd=1.32u as=0.1208p ps=1.42u w=0.28u l=0.36u
.ends

.subckt new_dummyrow_unit_3v64x8m81 018SRAM_cell1_dummy_3v64x8m81_11/m2_346_89# 018SRAM_cell1_dummy_3v64x8m81_7/m2_346_89#
+ 018SRAM_cell1_dummy_3v64x8m81_11/m2_134_89# 018SRAM_cell1_dummy_3v64x8m81_7/m2_134_89#
+ 018SRAM_cell1_dummy_3v64x8m81_12/m2_346_89# 018SRAM_cell1_dummy_3v64x8m81_8/m2_346_89#
+ 018SRAM_cell1_dummy_3v64x8m81_12/m2_134_89# 018SRAM_cell1_dummy_3v64x8m81_8/m2_134_89#
+ 018SRAM_cell1_dummy_3v64x8m81_13/m2_346_89# 018SRAM_cell1_dummy_3v64x8m81_13/m2_134_89#
+ 018SRAM_cell1_dummy_3v64x8m81_9/m2_346_89# 018SRAM_cell1_dummy_3v64x8m81_9/m2_134_89#
+ 018SRAM_cell1_dummy_3v64x8m81_14/m2_346_89# 018SRAM_cell1_dummy_3v64x8m81_14/m2_134_89#
+ 018SRAM_cell1_dummy_3v64x8m81_15/m2_346_89# 018SRAM_cell1_dummy_3v64x8m81_15/m2_134_89#
+ 018SRAM_cell1_dummy_3v64x8m81_0/m2_346_89# 018SRAM_cell1_dummy_3v64x8m81_0/m2_134_89#
+ 018SRAM_cell1_dummy_3v64x8m81_1/m2_346_89# 018SRAM_cell1_dummy_3v64x8m81_1/m2_134_89#
+ 018SRAM_cell1_dummy_3v64x8m81_2/m2_346_89# 018SRAM_cell1_dummy_3v64x8m81_2/m2_134_89#
+ 018SRAM_cell1_dummy_3v64x8m81_3/m2_346_89# 018SRAM_cell1_dummy_3v64x8m81_3/m2_134_89#
+ 018SRAM_cell1_dummy_3v64x8m81_4/m2_134_89# 018SRAM_cell1_dummy_3v64x8m81_4/m2_346_89#
+ 018SRAM_strap1_3v64x8m81_1/a_91_178# 018SRAM_cell1_dummy_3v64x8m81_5/m2_134_89#
+ 018SRAM_cell1_dummy_3v64x8m81_5/m2_346_89# 018SRAM_cell1_dummy_3v64x8m81_10/m2_346_89#
+ 018SRAM_cell1_dummy_3v64x8m81_6/m2_346_89# 018SRAM_cell1_dummy_3v64x8m81_10/m2_134_89#
+ VSUBS 018SRAM_cell1_dummy_3v64x8m81_6/m2_134_89# 018SRAM_strap1_3v64x8m81_1/w_91_512#
X018SRAM_cell1_dummy_3v64x8m81_10 018SRAM_strap1_3v64x8m81_1/a_91_178# VSUBS 018SRAM_strap1_3v64x8m81_1/w_91_512#
+ 018SRAM_strap1_3v64x8m81_1/w_91_512# 018SRAM_strap1_3v64x8m81_1/a_91_178# 018SRAM_cell1_dummy_3v64x8m81_10/m2_346_89#
+ 018SRAM_cell1_dummy_3v64x8m81_10/m2_134_89# VSUBS x018SRAM_cell1_dummy_3v64x8m81
X018SRAM_cell1_dummy_3v64x8m81_12 018SRAM_strap1_3v64x8m81_1/a_91_178# VSUBS 018SRAM_strap1_3v64x8m81_1/w_91_512#
+ 018SRAM_strap1_3v64x8m81_1/w_91_512# 018SRAM_strap1_3v64x8m81_1/a_91_178# 018SRAM_cell1_dummy_3v64x8m81_12/m2_346_89#
+ 018SRAM_cell1_dummy_3v64x8m81_12/m2_134_89# VSUBS x018SRAM_cell1_dummy_3v64x8m81
X018SRAM_cell1_dummy_3v64x8m81_11 018SRAM_strap1_3v64x8m81_1/a_91_178# VSUBS 018SRAM_strap1_3v64x8m81_1/w_91_512#
+ 018SRAM_strap1_3v64x8m81_1/w_91_512# 018SRAM_strap1_3v64x8m81_1/a_91_178# 018SRAM_cell1_dummy_3v64x8m81_11/m2_346_89#
+ 018SRAM_cell1_dummy_3v64x8m81_11/m2_134_89# VSUBS x018SRAM_cell1_dummy_3v64x8m81
X018SRAM_cell1_dummy_3v64x8m81_13 018SRAM_strap1_3v64x8m81_1/a_91_178# VSUBS 018SRAM_strap1_3v64x8m81_1/w_91_512#
+ 018SRAM_strap1_3v64x8m81_1/w_91_512# 018SRAM_strap1_3v64x8m81_1/a_91_178# 018SRAM_cell1_dummy_3v64x8m81_13/m2_346_89#
+ 018SRAM_cell1_dummy_3v64x8m81_13/m2_134_89# VSUBS x018SRAM_cell1_dummy_3v64x8m81
X018SRAM_cell1_dummy_3v64x8m81_14 018SRAM_strap1_3v64x8m81_1/a_91_178# VSUBS 018SRAM_strap1_3v64x8m81_1/w_91_512#
+ 018SRAM_strap1_3v64x8m81_1/w_91_512# 018SRAM_strap1_3v64x8m81_1/a_91_178# 018SRAM_cell1_dummy_3v64x8m81_14/m2_346_89#
+ 018SRAM_cell1_dummy_3v64x8m81_14/m2_134_89# VSUBS x018SRAM_cell1_dummy_3v64x8m81
X018SRAM_cell1_dummy_3v64x8m81_15 018SRAM_strap1_3v64x8m81_1/a_91_178# VSUBS 018SRAM_strap1_3v64x8m81_1/w_91_512#
+ 018SRAM_strap1_3v64x8m81_1/w_91_512# 018SRAM_strap1_3v64x8m81_1/a_91_178# 018SRAM_cell1_dummy_3v64x8m81_15/m2_346_89#
+ 018SRAM_cell1_dummy_3v64x8m81_15/m2_134_89# VSUBS x018SRAM_cell1_dummy_3v64x8m81
X018SRAM_cell1_dummy_3v64x8m81_0 018SRAM_strap1_3v64x8m81_1/a_91_178# VSUBS 018SRAM_strap1_3v64x8m81_1/w_91_512#
+ 018SRAM_strap1_3v64x8m81_1/w_91_512# 018SRAM_strap1_3v64x8m81_1/a_91_178# 018SRAM_cell1_dummy_3v64x8m81_0/m2_346_89#
+ 018SRAM_cell1_dummy_3v64x8m81_0/m2_134_89# VSUBS x018SRAM_cell1_dummy_3v64x8m81
X018SRAM_cell1_dummy_3v64x8m81_1 018SRAM_strap1_3v64x8m81_1/a_91_178# VSUBS 018SRAM_strap1_3v64x8m81_1/w_91_512#
+ 018SRAM_strap1_3v64x8m81_1/w_91_512# 018SRAM_strap1_3v64x8m81_1/a_91_178# 018SRAM_cell1_dummy_3v64x8m81_1/m2_346_89#
+ 018SRAM_cell1_dummy_3v64x8m81_1/m2_134_89# VSUBS x018SRAM_cell1_dummy_3v64x8m81
X018SRAM_cell1_dummy_3v64x8m81_2 018SRAM_strap1_3v64x8m81_1/a_91_178# VSUBS 018SRAM_strap1_3v64x8m81_1/w_91_512#
+ 018SRAM_strap1_3v64x8m81_1/w_91_512# 018SRAM_strap1_3v64x8m81_1/a_91_178# 018SRAM_cell1_dummy_3v64x8m81_2/m2_346_89#
+ 018SRAM_cell1_dummy_3v64x8m81_2/m2_134_89# VSUBS x018SRAM_cell1_dummy_3v64x8m81
X018SRAM_cell1_dummy_3v64x8m81_3 018SRAM_strap1_3v64x8m81_1/a_91_178# VSUBS 018SRAM_strap1_3v64x8m81_1/w_91_512#
+ 018SRAM_strap1_3v64x8m81_1/w_91_512# 018SRAM_strap1_3v64x8m81_1/a_91_178# 018SRAM_cell1_dummy_3v64x8m81_3/m2_346_89#
+ 018SRAM_cell1_dummy_3v64x8m81_3/m2_134_89# VSUBS x018SRAM_cell1_dummy_3v64x8m81
X018SRAM_cell1_dummy_3v64x8m81_4 018SRAM_strap1_3v64x8m81_1/a_91_178# VSUBS 018SRAM_strap1_3v64x8m81_1/w_91_512#
+ 018SRAM_strap1_3v64x8m81_1/w_91_512# 018SRAM_strap1_3v64x8m81_1/a_91_178# 018SRAM_cell1_dummy_3v64x8m81_4/m2_346_89#
+ 018SRAM_cell1_dummy_3v64x8m81_4/m2_134_89# VSUBS x018SRAM_cell1_dummy_3v64x8m81
X018SRAM_cell1_dummy_3v64x8m81_5 018SRAM_strap1_3v64x8m81_1/a_91_178# VSUBS 018SRAM_strap1_3v64x8m81_1/w_91_512#
+ 018SRAM_strap1_3v64x8m81_1/w_91_512# 018SRAM_strap1_3v64x8m81_1/a_91_178# 018SRAM_cell1_dummy_3v64x8m81_5/m2_346_89#
+ 018SRAM_cell1_dummy_3v64x8m81_5/m2_134_89# VSUBS x018SRAM_cell1_dummy_3v64x8m81
X018SRAM_cell1_dummy_3v64x8m81_6 018SRAM_strap1_3v64x8m81_1/a_91_178# VSUBS 018SRAM_strap1_3v64x8m81_1/w_91_512#
+ 018SRAM_strap1_3v64x8m81_1/w_91_512# 018SRAM_strap1_3v64x8m81_1/a_91_178# 018SRAM_cell1_dummy_3v64x8m81_6/m2_346_89#
+ 018SRAM_cell1_dummy_3v64x8m81_6/m2_134_89# VSUBS x018SRAM_cell1_dummy_3v64x8m81
X018SRAM_cell1_dummy_3v64x8m81_7 018SRAM_strap1_3v64x8m81_1/a_91_178# VSUBS 018SRAM_strap1_3v64x8m81_1/w_91_512#
+ 018SRAM_strap1_3v64x8m81_1/w_91_512# 018SRAM_strap1_3v64x8m81_1/a_91_178# 018SRAM_cell1_dummy_3v64x8m81_7/m2_346_89#
+ 018SRAM_cell1_dummy_3v64x8m81_7/m2_134_89# VSUBS x018SRAM_cell1_dummy_3v64x8m81
X018SRAM_cell1_dummy_3v64x8m81_8 018SRAM_strap1_3v64x8m81_1/a_91_178# VSUBS 018SRAM_strap1_3v64x8m81_1/w_91_512#
+ 018SRAM_strap1_3v64x8m81_1/w_91_512# 018SRAM_strap1_3v64x8m81_1/a_91_178# 018SRAM_cell1_dummy_3v64x8m81_8/m2_346_89#
+ 018SRAM_cell1_dummy_3v64x8m81_8/m2_134_89# VSUBS x018SRAM_cell1_dummy_3v64x8m81
X018SRAM_cell1_dummy_3v64x8m81_9 018SRAM_strap1_3v64x8m81_1/a_91_178# VSUBS 018SRAM_strap1_3v64x8m81_1/w_91_512#
+ 018SRAM_strap1_3v64x8m81_1/w_91_512# 018SRAM_strap1_3v64x8m81_1/a_91_178# 018SRAM_cell1_dummy_3v64x8m81_9/m2_346_89#
+ 018SRAM_cell1_dummy_3v64x8m81_9/m2_134_89# VSUBS x018SRAM_cell1_dummy_3v64x8m81
.ends

.subckt new_dummyrowunit01_3v64x8m81 018SRAM_cell1_dummy_3v64x8m81_11/m2_346_89# 018SRAM_cell1_dummy_3v64x8m81_11/m2_134_89#
+ 018SRAM_cell1_dummy_3v64x8m81_7/m2_346_89# 018SRAM_cell1_dummy_3v64x8m81_7/m2_134_89#
+ 018SRAM_cell1_dummy_3v64x8m81_12/m2_346_89# 018SRAM_cell1_dummy_3v64x8m81_12/m2_134_89#
+ 018SRAM_cell1_dummy_3v64x8m81_8/m2_346_89# 018SRAM_cell1_dummy_3v64x8m81_8/m2_134_89#
+ 018SRAM_cell1_dummy_3v64x8m81_13/m2_346_89# 018SRAM_cell1_dummy_3v64x8m81_13/m2_134_89#
+ 018SRAM_cell1_dummy_3v64x8m81_9/m2_134_89# 018SRAM_cell1_dummy_3v64x8m81_9/m2_346_89#
+ 018SRAM_cell1_dummy_3v64x8m81_14/m2_346_89# 018SRAM_cell1_dummy_3v64x8m81_14/m2_134_89#
+ 018SRAM_cell1_dummy_3v64x8m81_15/m2_134_89# 018SRAM_cell1_dummy_3v64x8m81_15/m2_346_89#
+ 018SRAM_cell1_dummy_3v64x8m81_0/m2_134_89# 018SRAM_cell1_dummy_3v64x8m81_0/m2_346_89#
+ 018SRAM_cell1_dummy_3v64x8m81_1/m2_346_89# 018SRAM_cell1_dummy_3v64x8m81_1/m2_134_89#
+ 018SRAM_cell1_dummy_3v64x8m81_2/m2_346_89# 018SRAM_cell1_dummy_3v64x8m81_2/m2_134_89#
+ 018SRAM_cell1_dummy_3v64x8m81_3/m2_346_89# 018SRAM_cell1_dummy_3v64x8m81_3/m2_134_89#
+ 018SRAM_cell1_dummy_3v64x8m81_4/m2_346_89# 018SRAM_cell1_dummy_3v64x8m81_4/m2_134_89#
+ 018SRAM_cell1_dummy_3v64x8m81_5/m2_346_89# 018SRAM_cell1_dummy_3v64x8m81_5/m2_134_89#
+ 018SRAM_strap1_3v64x8m81_1/a_91_178# 018SRAM_cell1_dummy_3v64x8m81_6/m2_346_89#
+ 018SRAM_cell1_dummy_3v64x8m81_10/m2_134_89# 018SRAM_cell1_dummy_3v64x8m81_10/m2_346_89#
+ VSUBS 018SRAM_cell1_dummy_3v64x8m81_6/m2_134_89# 018SRAM_strap1_3v64x8m81_1/w_91_512#
X018SRAM_cell1_dummy_3v64x8m81_10 018SRAM_strap1_3v64x8m81_1/a_91_178# VSUBS 018SRAM_strap1_3v64x8m81_1/w_91_512#
+ 018SRAM_strap1_3v64x8m81_1/w_91_512# 018SRAM_strap1_3v64x8m81_1/a_91_178# 018SRAM_cell1_dummy_3v64x8m81_10/m2_346_89#
+ 018SRAM_cell1_dummy_3v64x8m81_10/m2_134_89# VSUBS x018SRAM_cell1_dummy_3v64x8m81
X018SRAM_cell1_dummy_3v64x8m81_12 018SRAM_strap1_3v64x8m81_1/a_91_178# VSUBS 018SRAM_strap1_3v64x8m81_1/w_91_512#
+ 018SRAM_strap1_3v64x8m81_1/w_91_512# 018SRAM_strap1_3v64x8m81_1/a_91_178# 018SRAM_cell1_dummy_3v64x8m81_12/m2_346_89#
+ 018SRAM_cell1_dummy_3v64x8m81_12/m2_134_89# VSUBS x018SRAM_cell1_dummy_3v64x8m81
X018SRAM_cell1_dummy_3v64x8m81_11 018SRAM_strap1_3v64x8m81_1/a_91_178# VSUBS 018SRAM_strap1_3v64x8m81_1/w_91_512#
+ 018SRAM_strap1_3v64x8m81_1/w_91_512# 018SRAM_strap1_3v64x8m81_1/a_91_178# 018SRAM_cell1_dummy_3v64x8m81_11/m2_346_89#
+ 018SRAM_cell1_dummy_3v64x8m81_11/m2_134_89# VSUBS x018SRAM_cell1_dummy_3v64x8m81
X018SRAM_cell1_dummy_3v64x8m81_13 018SRAM_strap1_3v64x8m81_1/a_91_178# VSUBS 018SRAM_strap1_3v64x8m81_1/w_91_512#
+ 018SRAM_strap1_3v64x8m81_1/w_91_512# 018SRAM_strap1_3v64x8m81_1/a_91_178# 018SRAM_cell1_dummy_3v64x8m81_13/m2_346_89#
+ 018SRAM_cell1_dummy_3v64x8m81_13/m2_134_89# VSUBS x018SRAM_cell1_dummy_3v64x8m81
X018SRAM_cell1_dummy_3v64x8m81_14 018SRAM_strap1_3v64x8m81_1/a_91_178# VSUBS 018SRAM_strap1_3v64x8m81_1/w_91_512#
+ 018SRAM_strap1_3v64x8m81_1/w_91_512# 018SRAM_strap1_3v64x8m81_1/a_91_178# 018SRAM_cell1_dummy_3v64x8m81_14/m2_346_89#
+ 018SRAM_cell1_dummy_3v64x8m81_14/m2_134_89# VSUBS x018SRAM_cell1_dummy_3v64x8m81
X018SRAM_cell1_dummy_3v64x8m81_15 018SRAM_strap1_3v64x8m81_1/a_91_178# VSUBS 018SRAM_strap1_3v64x8m81_1/w_91_512#
+ 018SRAM_strap1_3v64x8m81_1/w_91_512# 018SRAM_strap1_3v64x8m81_1/a_91_178# 018SRAM_cell1_dummy_3v64x8m81_15/m2_346_89#
+ 018SRAM_cell1_dummy_3v64x8m81_15/m2_134_89# VSUBS x018SRAM_cell1_dummy_3v64x8m81
X018SRAM_cell1_dummy_3v64x8m81_0 018SRAM_strap1_3v64x8m81_1/a_91_178# VSUBS 018SRAM_strap1_3v64x8m81_1/w_91_512#
+ 018SRAM_strap1_3v64x8m81_1/w_91_512# 018SRAM_strap1_3v64x8m81_1/a_91_178# 018SRAM_cell1_dummy_3v64x8m81_0/m2_346_89#
+ 018SRAM_cell1_dummy_3v64x8m81_0/m2_134_89# VSUBS x018SRAM_cell1_dummy_3v64x8m81
X018SRAM_cell1_dummy_3v64x8m81_1 018SRAM_strap1_3v64x8m81_1/a_91_178# VSUBS 018SRAM_strap1_3v64x8m81_1/w_91_512#
+ 018SRAM_strap1_3v64x8m81_1/w_91_512# 018SRAM_strap1_3v64x8m81_1/a_91_178# 018SRAM_cell1_dummy_3v64x8m81_1/m2_346_89#
+ 018SRAM_cell1_dummy_3v64x8m81_1/m2_134_89# VSUBS x018SRAM_cell1_dummy_3v64x8m81
X018SRAM_cell1_dummy_3v64x8m81_2 018SRAM_strap1_3v64x8m81_1/a_91_178# VSUBS 018SRAM_strap1_3v64x8m81_1/w_91_512#
+ 018SRAM_strap1_3v64x8m81_1/w_91_512# 018SRAM_strap1_3v64x8m81_1/a_91_178# 018SRAM_cell1_dummy_3v64x8m81_2/m2_346_89#
+ 018SRAM_cell1_dummy_3v64x8m81_2/m2_134_89# VSUBS x018SRAM_cell1_dummy_3v64x8m81
X018SRAM_cell1_dummy_3v64x8m81_3 018SRAM_strap1_3v64x8m81_1/a_91_178# VSUBS 018SRAM_strap1_3v64x8m81_1/w_91_512#
+ 018SRAM_strap1_3v64x8m81_1/w_91_512# 018SRAM_strap1_3v64x8m81_1/a_91_178# 018SRAM_cell1_dummy_3v64x8m81_3/m2_346_89#
+ 018SRAM_cell1_dummy_3v64x8m81_3/m2_134_89# VSUBS x018SRAM_cell1_dummy_3v64x8m81
X018SRAM_cell1_dummy_3v64x8m81_4 018SRAM_strap1_3v64x8m81_1/a_91_178# VSUBS 018SRAM_strap1_3v64x8m81_1/w_91_512#
+ 018SRAM_strap1_3v64x8m81_1/w_91_512# 018SRAM_strap1_3v64x8m81_1/a_91_178# 018SRAM_cell1_dummy_3v64x8m81_4/m2_346_89#
+ 018SRAM_cell1_dummy_3v64x8m81_4/m2_134_89# VSUBS x018SRAM_cell1_dummy_3v64x8m81
X018SRAM_cell1_dummy_3v64x8m81_5 018SRAM_strap1_3v64x8m81_1/a_91_178# VSUBS 018SRAM_strap1_3v64x8m81_1/w_91_512#
+ 018SRAM_strap1_3v64x8m81_1/w_91_512# 018SRAM_strap1_3v64x8m81_1/a_91_178# 018SRAM_cell1_dummy_3v64x8m81_5/m2_346_89#
+ 018SRAM_cell1_dummy_3v64x8m81_5/m2_134_89# VSUBS x018SRAM_cell1_dummy_3v64x8m81
X018SRAM_cell1_dummy_3v64x8m81_6 018SRAM_strap1_3v64x8m81_1/a_91_178# VSUBS 018SRAM_strap1_3v64x8m81_1/w_91_512#
+ 018SRAM_strap1_3v64x8m81_1/w_91_512# 018SRAM_strap1_3v64x8m81_1/a_91_178# 018SRAM_cell1_dummy_3v64x8m81_6/m2_346_89#
+ 018SRAM_cell1_dummy_3v64x8m81_6/m2_134_89# VSUBS x018SRAM_cell1_dummy_3v64x8m81
X018SRAM_cell1_dummy_3v64x8m81_7 018SRAM_strap1_3v64x8m81_1/a_91_178# VSUBS 018SRAM_strap1_3v64x8m81_1/w_91_512#
+ 018SRAM_strap1_3v64x8m81_1/w_91_512# 018SRAM_strap1_3v64x8m81_1/a_91_178# 018SRAM_cell1_dummy_3v64x8m81_7/m2_346_89#
+ 018SRAM_cell1_dummy_3v64x8m81_7/m2_134_89# VSUBS x018SRAM_cell1_dummy_3v64x8m81
X018SRAM_cell1_dummy_3v64x8m81_8 018SRAM_strap1_3v64x8m81_1/a_91_178# VSUBS 018SRAM_strap1_3v64x8m81_1/w_91_512#
+ 018SRAM_strap1_3v64x8m81_1/w_91_512# 018SRAM_strap1_3v64x8m81_1/a_91_178# 018SRAM_cell1_dummy_3v64x8m81_8/m2_346_89#
+ 018SRAM_cell1_dummy_3v64x8m81_8/m2_134_89# VSUBS x018SRAM_cell1_dummy_3v64x8m81
X018SRAM_cell1_dummy_3v64x8m81_9 018SRAM_strap1_3v64x8m81_1/a_91_178# VSUBS 018SRAM_strap1_3v64x8m81_1/w_91_512#
+ 018SRAM_strap1_3v64x8m81_1/w_91_512# 018SRAM_strap1_3v64x8m81_1/a_91_178# 018SRAM_cell1_dummy_3v64x8m81_9/m2_346_89#
+ 018SRAM_cell1_dummy_3v64x8m81_9/m2_134_89# VSUBS x018SRAM_cell1_dummy_3v64x8m81
.ends

.subckt x018SRAM_cell1_cutPC_3v64x8m81 m3_82_330# a_248_342# a_248_592# a_62_178#
+ w_30_512# a_430_96# a_110_96# VSUBS
X0 a_248_592# a_192_298# a_110_250# w_30_512# pfet_03v3 ad=0.1613p pd=1.39u as=0.1238p ps=1.44u w=0.28u l=0.28u
X1 a_248_342# a_192_298# a_110_250# VSUBS nfet_03v3 ad=0.171p pd=1.33u as=0.15665p ps=1.32u w=0.45u l=0.28u
X2 a_192_298# a_110_250# a_248_592# w_30_512# pfet_03v3 ad=0.1238p pd=1.44u as=0.1613p ps=1.39u w=0.28u l=0.28u
X3 a_192_298# a_110_250# a_248_342# VSUBS nfet_03v3 ad=0.15665p pd=1.32u as=0.171p ps=1.33u w=0.45u l=0.28u
X4 a_110_250# a_62_178# a_110_96# VSUBS nfet_03v3 ad=0.15665p pd=1.32u as=0.1208p ps=1.42u w=0.28u l=0.36u
X5 a_192_298# a_62_178# a_430_96# VSUBS nfet_03v3 ad=0.15665p pd=1.32u as=0.1208p ps=1.42u w=0.28u l=0.36u
.ends

.subckt array16_64_dummy_01_3v64x8m81 018SRAM_cell1_cutPC_3v64x8m81_2/w_30_512# 018SRAM_cell1_cutPC_3v64x8m81_4/a_62_178#
+ 018SRAM_cell1_cutPC_3v64x8m81_31/a_62_178# 018SRAM_cell1_cutPC_3v64x8m81_60/a_62_178#
+ 018SRAM_cell1_cutPC_3v64x8m81_4/w_30_512# VSS_uq0 018SRAM_cell1_cutPC_3v64x8m81_3/w_30_512#
+ 018SRAM_cell1_cutPC_3v64x8m81_2/m3_82_330# 018SRAM_cell1_cutPC_3v64x8m81_61/a_62_178#
+ 018SRAM_cell1_cutPC_3v64x8m81_3/m3_82_330# 018SRAM_cell1_cutPC_3v64x8m81_3/a_248_342#
+ 018SRAM_cell1_cutPC_3v64x8m81_60/m3_82_330# 018SRAM_cell1_cutPC_3v64x8m81_31/m3_82_330#
+ 018SRAM_cell1_cutPC_3v64x8m81_60/a_248_342# 018SRAM_cell1_cutPC_3v64x8m81_61/w_30_512#
+ 018SRAM_cell1_cutPC_3v64x8m81_4/m3_82_330# 018SRAM_cell1_cutPC_3v64x8m81_3/a_248_592#
+ 018SRAM_cell1_cutPC_3v64x8m81_31/a_248_342# 018SRAM_cell1_cutPC_3v64x8m81_4/a_248_342#
+ VDD_uq0 018SRAM_cell1_cutPC_3v64x8m81_61/m3_82_330# 018SRAM_cell1_cutPC_3v64x8m81_61/a_248_342#
+ 018SRAM_cell1_cutPC_3v64x8m81_2/a_62_178# 018SRAM_cell1_cutPC_3v64x8m81_61/a_248_592#
+ 018SRAM_cell1_cutPC_3v64x8m81_62/m3_82_330# 018SRAM_cell1_cutPC_3v64x8m81_4/a_110_96#
+ 018SRAM_cell1_cutPC_3v64x8m81_62/a_62_178# 018SRAM_cell1_cutPC_3v64x8m81_62/a_248_342#
+ VDD VSS 018SRAM_cell1_cutPC_3v64x8m81_63/m3_82_330# 018SRAM_cell1_cutPC_3v64x8m81_63/a_248_342#
+ 018SRAM_cell1_cutPC_3v64x8m81_62/w_30_512# 018SRAM_cell1_cutPC_3v64x8m81_2/a_248_592#
+ 018SRAM_cell1_cutPC_3v64x8m81_3/a_62_178# VSUBS 018SRAM_cell1_cutPC_3v64x8m81_4/a_430_96#
+ 018SRAM_cell1_cutPC_3v64x8m81_63/a_62_178#
X018SRAM_cell1_cutPC_3v64x8m81_2 018SRAM_cell1_cutPC_3v64x8m81_2/m3_82_330# VSS 018SRAM_cell1_cutPC_3v64x8m81_2/a_248_592#
+ 018SRAM_cell1_cutPC_3v64x8m81_2/a_62_178# 018SRAM_cell1_cutPC_3v64x8m81_2/w_30_512#
+ 018SRAM_cell1_cutPC_3v64x8m81_4/a_430_96# 018SRAM_cell1_cutPC_3v64x8m81_4/a_110_96#
+ VSUBS x018SRAM_cell1_cutPC_3v64x8m81
X018SRAM_cell1_cutPC_3v64x8m81_3 018SRAM_cell1_cutPC_3v64x8m81_3/m3_82_330# 018SRAM_cell1_cutPC_3v64x8m81_3/a_248_342#
+ 018SRAM_cell1_cutPC_3v64x8m81_3/a_248_592# 018SRAM_cell1_cutPC_3v64x8m81_3/a_62_178#
+ 018SRAM_cell1_cutPC_3v64x8m81_3/w_30_512# 018SRAM_cell1_cutPC_3v64x8m81_4/a_430_96#
+ 018SRAM_cell1_cutPC_3v64x8m81_4/a_110_96# VSUBS x018SRAM_cell1_cutPC_3v64x8m81
X018SRAM_cell1_cutPC_3v64x8m81_4 018SRAM_cell1_cutPC_3v64x8m81_4/m3_82_330# 018SRAM_cell1_cutPC_3v64x8m81_4/a_248_342#
+ VDD_uq0 018SRAM_cell1_cutPC_3v64x8m81_4/a_62_178# 018SRAM_cell1_cutPC_3v64x8m81_4/w_30_512#
+ 018SRAM_cell1_cutPC_3v64x8m81_4/a_430_96# 018SRAM_cell1_cutPC_3v64x8m81_4/a_110_96#
+ VSUBS x018SRAM_cell1_cutPC_3v64x8m81
X018SRAM_cell1_cutPC_3v64x8m81_60 018SRAM_cell1_cutPC_3v64x8m81_60/m3_82_330# 018SRAM_cell1_cutPC_3v64x8m81_60/a_248_342#
+ 018SRAM_cell1_cutPC_3v64x8m81_3/a_248_592# 018SRAM_cell1_cutPC_3v64x8m81_60/a_62_178#
+ 018SRAM_cell1_cutPC_3v64x8m81_3/w_30_512# 018SRAM_cell1_cutPC_3v64x8m81_4/a_430_96#
+ 018SRAM_cell1_cutPC_3v64x8m81_4/a_110_96# VSUBS x018SRAM_cell1_cutPC_3v64x8m81
X018SRAM_cell1_cutPC_3v64x8m81_61 018SRAM_cell1_cutPC_3v64x8m81_61/m3_82_330# 018SRAM_cell1_cutPC_3v64x8m81_61/a_248_342#
+ 018SRAM_cell1_cutPC_3v64x8m81_61/a_248_592# 018SRAM_cell1_cutPC_3v64x8m81_61/a_62_178#
+ 018SRAM_cell1_cutPC_3v64x8m81_61/w_30_512# 018SRAM_cell1_cutPC_3v64x8m81_4/a_430_96#
+ 018SRAM_cell1_cutPC_3v64x8m81_4/a_110_96# VSUBS x018SRAM_cell1_cutPC_3v64x8m81
X018SRAM_cell1_cutPC_3v64x8m81_62 018SRAM_cell1_cutPC_3v64x8m81_62/m3_82_330# 018SRAM_cell1_cutPC_3v64x8m81_62/a_248_342#
+ VDD 018SRAM_cell1_cutPC_3v64x8m81_62/a_62_178# 018SRAM_cell1_cutPC_3v64x8m81_62/w_30_512#
+ 018SRAM_cell1_cutPC_3v64x8m81_4/a_430_96# 018SRAM_cell1_cutPC_3v64x8m81_4/a_110_96#
+ VSUBS x018SRAM_cell1_cutPC_3v64x8m81
X018SRAM_cell1_cutPC_3v64x8m81_63 018SRAM_cell1_cutPC_3v64x8m81_63/m3_82_330# 018SRAM_cell1_cutPC_3v64x8m81_63/a_248_342#
+ 018SRAM_cell1_cutPC_3v64x8m81_2/a_248_592# 018SRAM_cell1_cutPC_3v64x8m81_63/a_62_178#
+ 018SRAM_cell1_cutPC_3v64x8m81_2/w_30_512# 018SRAM_cell1_cutPC_3v64x8m81_4/a_430_96#
+ 018SRAM_cell1_cutPC_3v64x8m81_4/a_110_96# VSUBS x018SRAM_cell1_cutPC_3v64x8m81
X018SRAM_cell1_cutPC_3v64x8m81_31 018SRAM_cell1_cutPC_3v64x8m81_31/m3_82_330# 018SRAM_cell1_cutPC_3v64x8m81_31/a_248_342#
+ 018SRAM_cell1_cutPC_3v64x8m81_61/a_248_592# 018SRAM_cell1_cutPC_3v64x8m81_31/a_62_178#
+ 018SRAM_cell1_cutPC_3v64x8m81_61/w_30_512# 018SRAM_cell1_cutPC_3v64x8m81_4/a_430_96#
+ 018SRAM_cell1_cutPC_3v64x8m81_4/a_110_96# VSUBS x018SRAM_cell1_cutPC_3v64x8m81
.ends

.subckt ldummy_3v64x4_3v64x8m81 new_dummyrowunit01_3v64x8m81_0/018SRAM_cell1_dummy_3v64x8m81_7/m2_134_89#
+ array16_64_dummy_01_3v64x8m81_0/018SRAM_cell1_cutPC_3v64x8m81_31/m3_82_330# array16_64_dummy_01_3v64x8m81_0/018SRAM_cell1_cutPC_3v64x8m81_31/a_248_342#
+ 018SRAM_cell1_dummy_3v64x8m81_11/m2_346_89# array16_64_dummy_01_3v64x8m81_0/018SRAM_cell1_cutPC_3v64x8m81_3/a_248_592#
+ 018SRAM_cell1_dummy_3v64x8m81_11/m2_134_89# new_dummyrow_unit_3v64x8m81_0/018SRAM_cell1_dummy_3v64x8m81_11/m2_346_89#
+ new_dummyrow_unit_3v64x8m81_0/018SRAM_cell1_dummy_3v64x8m81_11/m2_134_89# array16_64_dummy_01_3v64x8m81_0/018SRAM_cell1_cutPC_3v64x8m81_3/m3_82_330#
+ 018SRAM_cell1_dummy_3v64x8m81_21/m2_346_89# new_dummyrow_unit_3v64x8m81_0/018SRAM_cell1_dummy_3v64x8m81_1/m2_346_89#
+ array16_64_dummy_01_3v64x8m81_0/018SRAM_cell1_cutPC_3v64x8m81_3/a_248_342# 018SRAM_cell1_dummy_3v64x8m81_21/m2_134_89#
+ 018SRAM_cell1_dummy_3v64x8m81_7/m2_346_89# new_dummyrow_unit_3v64x8m81_0/018SRAM_cell1_dummy_3v64x8m81_1/m2_134_89#
+ 018SRAM_cell1_dummy_3v64x8m81_7/m2_134_89# 018SRAM_cell1_dummy_3v64x8m81_31/m2_346_89#
+ array16_64_dummy_01_3v64x8m81_0/018SRAM_cell1_cutPC_3v64x8m81_61/m3_82_330# array16_64_dummy_01_3v64x8m81_0/018SRAM_cell1_cutPC_3v64x8m81_61/a_248_342#
+ 018SRAM_cell1_dummy_3v64x8m81_31/m2_134_89# new_dummyrowunit01_3v64x8m81_0/018SRAM_cell1_dummy_3v64x8m81_8/m2_346_89#
+ new_dummyrowunit01_3v64x8m81_0/018SRAM_cell1_dummy_3v64x8m81_8/m2_134_89# new_dummyrowunit01_3v64x8m81_0/018SRAM_cell1_dummy_3v64x8m81_10/m2_346_89#
+ new_dummyrowunit01_3v64x8m81_0/018SRAM_cell1_dummy_3v64x8m81_10/m2_134_89# array16_64_dummy_01_3v64x8m81_0/018SRAM_cell1_cutPC_3v64x8m81_61/a_248_592#
+ 018SRAM_cell1_dummy_3v64x8m81_12/m2_346_89# new_dummyrow_unit_3v64x8m81_0/018SRAM_cell1_dummy_3v64x8m81_12/m2_346_89#
+ 018SRAM_cell1_dummy_3v64x8m81_12/m2_134_89# array16_64_dummy_01_3v64x8m81_0/018SRAM_cell1_cutPC_3v64x8m81_4/m3_82_330#
+ new_dummyrow_unit_3v64x8m81_0/018SRAM_cell1_dummy_3v64x8m81_12/m2_134_89# array16_64_dummy_01_3v64x8m81_0/018SRAM_cell1_cutPC_3v64x8m81_4/a_248_342#
+ new_dummyrow_unit_3v64x8m81_0/018SRAM_cell1_dummy_3v64x8m81_2/m2_346_89# array16_64_dummy_01_3v64x8m81_0/018SRAM_cell1_cutPC_3v64x8m81_61/w_30_512#
+ 018SRAM_cell1_dummy_3v64x8m81_22/m2_346_89# 018SRAM_cell1_dummy_3v64x8m81_8/m2_346_89#
+ 018SRAM_cell1_dummy_3v64x8m81_22/m2_134_89# new_dummyrow_unit_3v64x8m81_0/018SRAM_cell1_dummy_3v64x8m81_2/m2_134_89#
+ 018SRAM_cell1_dummy_3v64x8m81_8/m2_134_89# array16_64_dummy_01_3v64x8m81_0/018SRAM_cell1_cutPC_3v64x8m81_62/m3_82_330#
+ array16_64_dummy_01_3v64x8m81_0/018SRAM_cell1_cutPC_3v64x8m81_62/a_248_342# array16_64_dummy_01_3v64x8m81_0/VSS
+ new_dummyrowunit01_3v64x8m81_0/018SRAM_cell1_dummy_3v64x8m81_9/m2_346_89# new_dummyrowunit01_3v64x8m81_0/018SRAM_cell1_dummy_3v64x8m81_9/m2_134_89#
+ new_dummyrowunit01_3v64x8m81_0/018SRAM_cell1_dummy_3v64x8m81_11/m2_346_89# new_dummyrowunit01_3v64x8m81_0/018SRAM_cell1_dummy_3v64x8m81_11/m2_134_89#
+ 018SRAM_cell1_dummy_3v64x8m81_13/m2_134_89# 018SRAM_cell1_dummy_3v64x8m81_13/m2_346_89#
+ new_dummyrow_unit_3v64x8m81_0/018SRAM_cell1_dummy_3v64x8m81_13/m2_346_89# new_dummyrow_unit_3v64x8m81_0/018SRAM_cell1_dummy_3v64x8m81_13/m2_134_89#
+ 018SRAM_cell1_dummy_3v64x8m81_23/m2_346_89# new_dummyrow_unit_3v64x8m81_0/018SRAM_cell1_dummy_3v64x8m81_3/m2_346_89#
+ 018SRAM_cell1_dummy_3v64x8m81_9/m2_346_89# 018SRAM_cell1_dummy_3v64x8m81_23/m2_134_89#
+ new_dummyrow_unit_3v64x8m81_0/018SRAM_cell1_dummy_3v64x8m81_3/m2_134_89# 018SRAM_cell1_dummy_3v64x8m81_9/m2_134_89#
+ array16_64_dummy_01_3v64x8m81_0/018SRAM_cell1_cutPC_3v64x8m81_63/m3_82_330# array16_64_dummy_01_3v64x8m81_0/018SRAM_cell1_cutPC_3v64x8m81_63/a_248_342#
+ new_dummyrowunit01_3v64x8m81_0/018SRAM_cell1_dummy_3v64x8m81_12/m2_346_89# new_dummyrowunit01_3v64x8m81_0/018SRAM_cell1_dummy_3v64x8m81_12/m2_134_89#
+ 018SRAM_cell1_dummy_3v64x8m81_14/m2_346_89# array16_64_dummy_01_3v64x8m81_0/018SRAM_cell1_cutPC_3v64x8m81_2/a_248_592#
+ new_dummyrow_unit_3v64x8m81_0/018SRAM_cell1_dummy_3v64x8m81_14/m2_346_89# 018SRAM_cell1_dummy_3v64x8m81_14/m2_134_89#
+ new_dummyrow_unit_3v64x8m81_0/018SRAM_cell1_dummy_3v64x8m81_14/m2_134_89# new_dummyrow_unit_3v64x8m81_0/018SRAM_cell1_dummy_3v64x8m81_4/m2_346_89#
+ 018SRAM_cell1_dummy_3v64x8m81_24/m2_346_89# new_dummyrow_unit_3v64x8m81_0/018SRAM_cell1_dummy_3v64x8m81_4/m2_134_89#
+ 018SRAM_cell1_dummy_3v64x8m81_24/m2_134_89# new_dummyrowunit01_3v64x8m81_0/018SRAM_cell1_dummy_3v64x8m81_0/m2_346_89#
+ new_dummyrowunit01_3v64x8m81_0/018SRAM_cell1_dummy_3v64x8m81_0/m2_134_89# new_dummyrowunit01_3v64x8m81_0/018SRAM_cell1_dummy_3v64x8m81_13/m2_346_89#
+ new_dummyrowunit01_3v64x8m81_0/018SRAM_cell1_dummy_3v64x8m81_13/m2_134_89# 018SRAM_cell1_dummy_3v64x8m81_15/m2_346_89#
+ new_dummyrow_unit_3v64x8m81_0/018SRAM_cell1_dummy_3v64x8m81_15/m2_346_89# 018SRAM_cell1_dummy_3v64x8m81_15/m2_134_89#
+ new_dummyrow_unit_3v64x8m81_0/018SRAM_cell1_dummy_3v64x8m81_15/m2_134_89# 018SRAM_cell1_dummy_3v64x8m81_25/m2_346_89#
+ new_dummyrow_unit_3v64x8m81_0/018SRAM_cell1_dummy_3v64x8m81_5/m2_346_89# new_dummyrow_unit_3v64x8m81_0/018SRAM_cell1_dummy_3v64x8m81_5/m2_134_89#
+ 018SRAM_cell1_dummy_3v64x8m81_0/m2_134_89# 018SRAM_cell1_dummy_3v64x8m81_0/m2_346_89#
+ 018SRAM_cell1_dummy_3v64x8m81_25/m2_134_89# new_dummyrowunit01_3v64x8m81_0/018SRAM_cell1_dummy_3v64x8m81_1/m2_346_89#
+ new_dummyrowunit01_3v64x8m81_0/018SRAM_cell1_dummy_3v64x8m81_1/m2_134_89# new_dummyrowunit01_3v64x8m81_0/018SRAM_cell1_dummy_3v64x8m81_14/m2_346_89#
+ 018SRAM_cell1_dummy_3v64x8m81_16/m2_346_89# new_dummyrowunit01_3v64x8m81_0/018SRAM_cell1_dummy_3v64x8m81_14/m2_134_89#
+ 018SRAM_cell1_dummy_3v64x8m81_16/m2_134_89# 018SRAM_cell1_dummy_3v64x8m81_26/m2_346_89#
+ new_dummyrow_unit_3v64x8m81_0/018SRAM_cell1_dummy_3v64x8m81_6/m2_346_89# new_dummyrow_unit_3v64x8m81_0/018SRAM_cell1_dummy_3v64x8m81_6/m2_134_89#
+ 018SRAM_cell1_dummy_3v64x8m81_1/m2_346_89# 018SRAM_cell1_dummy_3v64x8m81_26/m2_134_89#
+ 018SRAM_cell1_dummy_3v64x8m81_1/m2_134_89# new_dummyrowunit01_3v64x8m81_0/018SRAM_cell1_dummy_3v64x8m81_2/m2_346_89#
+ new_dummyrowunit01_3v64x8m81_0/018SRAM_cell1_dummy_3v64x8m81_2/m2_134_89# new_dummyrowunit01_3v64x8m81_0/018SRAM_cell1_dummy_3v64x8m81_15/m2_346_89#
+ new_dummyrowunit01_3v64x8m81_0/018SRAM_cell1_dummy_3v64x8m81_15/m2_134_89# 018SRAM_cell1_dummy_3v64x8m81_17/m2_346_89#
+ 018SRAM_cell1_dummy_3v64x8m81_17/m2_134_89# new_dummyrow_unit_3v64x8m81_0/018SRAM_cell1_dummy_3v64x8m81_7/m2_346_89#
+ 018SRAM_cell1_dummy_3v64x8m81_27/m2_346_89# 018SRAM_cell1_dummy_3v64x8m81_2/m2_346_89#
+ 018SRAM_cell1_dummy_3v64x8m81_27/m2_134_89# new_dummyrow_unit_3v64x8m81_0/018SRAM_cell1_dummy_3v64x8m81_7/m2_134_89#
+ 018SRAM_cell1_dummy_3v64x8m81_2/m2_134_89# new_dummyrowunit01_3v64x8m81_0/018SRAM_cell1_dummy_3v64x8m81_3/m2_346_89#
+ array16_64_dummy_01_3v64x8m81_0/018SRAM_cell1_cutPC_3v64x8m81_2/w_30_512# new_dummyrowunit01_3v64x8m81_0/018SRAM_cell1_dummy_3v64x8m81_3/m2_134_89#
+ 018SRAM_cell1_dummy_3v64x8m81_18/m2_346_89# 018SRAM_cell1_dummy_3v64x8m81_18/m2_134_89#
+ 018SRAM_cell1_dummy_3v64x8m81_28/m2_134_89# new_dummyrow_unit_3v64x8m81_0/018SRAM_cell1_dummy_3v64x8m81_8/m2_346_89#
+ 018SRAM_cell1_dummy_3v64x8m81_28/m2_346_89# 018SRAM_cell1_dummy_3v64x8m81_3/m2_134_89#
+ 018SRAM_cell1_dummy_3v64x8m81_3/m2_346_89# new_dummyrow_unit_3v64x8m81_0/018SRAM_cell1_dummy_3v64x8m81_8/m2_134_89#
+ new_dummyrowunit01_3v64x8m81_0/018SRAM_cell1_dummy_3v64x8m81_4/m2_346_89# new_dummyrowunit01_3v64x8m81_0/018SRAM_cell1_dummy_3v64x8m81_4/m2_134_89#
+ 018SRAM_cell1_dummy_3v64x8m81_19/m2_346_89# 018SRAM_cell1_dummy_3v64x8m81_19/m2_134_89#
+ 018SRAM_cell1_dummy_3v64x8m81_29/m2_346_89# new_dummyrow_unit_3v64x8m81_0/018SRAM_cell1_dummy_3v64x8m81_9/m2_346_89#
+ 018SRAM_cell1_dummy_3v64x8m81_29/m2_134_89# 018SRAM_cell1_dummy_3v64x8m81_4/m2_346_89#
+ new_dummyrow_unit_3v64x8m81_0/018SRAM_cell1_dummy_3v64x8m81_9/m2_134_89# 018SRAM_cell1_dummy_3v64x8m81_4/m2_134_89#
+ new_dummyrowunit01_3v64x8m81_0/018SRAM_cell1_dummy_3v64x8m81_5/m2_134_89# new_dummyrowunit01_3v64x8m81_0/018SRAM_cell1_dummy_3v64x8m81_5/m2_346_89#
+ 018SRAM_cell1_dummy_3v64x8m81_5/m2_346_89# 018SRAM_cell1_dummy_3v64x8m81_5/m2_134_89#
+ new_dummyrowunit01_3v64x8m81_0/018SRAM_cell1_dummy_3v64x8m81_6/m2_346_89# array16_64_dummy_01_3v64x8m81_0/018SRAM_cell1_cutPC_3v64x8m81_3/w_30_512#
+ new_dummyrowunit01_3v64x8m81_0/018SRAM_cell1_dummy_3v64x8m81_6/m2_134_89# 018SRAM_cell1_dummy_3v64x8m81_10/m2_346_89#
+ 018SRAM_cell1_dummy_3v64x8m81_10/m2_134_89# new_dummyrow_unit_3v64x8m81_0/018SRAM_cell1_dummy_3v64x8m81_10/m2_346_89#
+ new_dummyrow_unit_3v64x8m81_0/018SRAM_cell1_dummy_3v64x8m81_10/m2_134_89# array16_64_dummy_01_3v64x8m81_0/018SRAM_cell1_cutPC_3v64x8m81_2/m3_82_330#
+ 018SRAM_cell1_dummy_3v64x8m81_20/m2_134_89# new_dummyrow_unit_3v64x8m81_0/018SRAM_cell1_dummy_3v64x8m81_0/m2_346_89#
+ 018SRAM_cell1_dummy_3v64x8m81_20/m2_346_89# new_dummyrow_unit_3v64x8m81_0/018SRAM_cell1_dummy_3v64x8m81_0/m2_134_89#
+ 018SRAM_cell1_dummy_3v64x8m81_6/m2_346_89# 018SRAM_cell1_dummy_3v64x8m81_6/m2_134_89#
+ 018SRAM_cell1_dummy_3v64x8m81_30/m2_346_89# array16_64_dummy_01_3v64x8m81_0/018SRAM_cell1_cutPC_3v64x8m81_60/m3_82_330#
+ 018SRAM_cell1_dummy_3v64x8m81_30/m2_134_89# VSUBS array16_64_dummy_01_3v64x8m81_0/018SRAM_cell1_cutPC_3v64x8m81_60/a_248_342#
+ array16_64_dummy_01_3v64x8m81_0/VDD array16_64_dummy_01_3v64x8m81_0/VDD_uq0 new_dummyrowunit01_3v64x8m81_0/018SRAM_cell1_dummy_3v64x8m81_7/m2_346_89#
Xnew_dummyrow_unit_3v64x8m81_0 new_dummyrow_unit_3v64x8m81_0/018SRAM_cell1_dummy_3v64x8m81_11/m2_346_89#
+ new_dummyrow_unit_3v64x8m81_0/018SRAM_cell1_dummy_3v64x8m81_7/m2_346_89# new_dummyrow_unit_3v64x8m81_0/018SRAM_cell1_dummy_3v64x8m81_11/m2_134_89#
+ new_dummyrow_unit_3v64x8m81_0/018SRAM_cell1_dummy_3v64x8m81_7/m2_134_89# new_dummyrow_unit_3v64x8m81_0/018SRAM_cell1_dummy_3v64x8m81_12/m2_346_89#
+ new_dummyrow_unit_3v64x8m81_0/018SRAM_cell1_dummy_3v64x8m81_8/m2_346_89# new_dummyrow_unit_3v64x8m81_0/018SRAM_cell1_dummy_3v64x8m81_12/m2_134_89#
+ new_dummyrow_unit_3v64x8m81_0/018SRAM_cell1_dummy_3v64x8m81_8/m2_134_89# new_dummyrow_unit_3v64x8m81_0/018SRAM_cell1_dummy_3v64x8m81_13/m2_346_89#
+ new_dummyrow_unit_3v64x8m81_0/018SRAM_cell1_dummy_3v64x8m81_13/m2_134_89# new_dummyrow_unit_3v64x8m81_0/018SRAM_cell1_dummy_3v64x8m81_9/m2_346_89#
+ new_dummyrow_unit_3v64x8m81_0/018SRAM_cell1_dummy_3v64x8m81_9/m2_134_89# new_dummyrow_unit_3v64x8m81_0/018SRAM_cell1_dummy_3v64x8m81_14/m2_346_89#
+ new_dummyrow_unit_3v64x8m81_0/018SRAM_cell1_dummy_3v64x8m81_14/m2_134_89# new_dummyrow_unit_3v64x8m81_0/018SRAM_cell1_dummy_3v64x8m81_15/m2_346_89#
+ new_dummyrow_unit_3v64x8m81_0/018SRAM_cell1_dummy_3v64x8m81_15/m2_134_89# new_dummyrow_unit_3v64x8m81_0/018SRAM_cell1_dummy_3v64x8m81_0/m2_346_89#
+ new_dummyrow_unit_3v64x8m81_0/018SRAM_cell1_dummy_3v64x8m81_0/m2_134_89# new_dummyrow_unit_3v64x8m81_0/018SRAM_cell1_dummy_3v64x8m81_1/m2_346_89#
+ new_dummyrow_unit_3v64x8m81_0/018SRAM_cell1_dummy_3v64x8m81_1/m2_134_89# new_dummyrow_unit_3v64x8m81_0/018SRAM_cell1_dummy_3v64x8m81_2/m2_346_89#
+ new_dummyrow_unit_3v64x8m81_0/018SRAM_cell1_dummy_3v64x8m81_2/m2_134_89# new_dummyrow_unit_3v64x8m81_0/018SRAM_cell1_dummy_3v64x8m81_3/m2_346_89#
+ new_dummyrow_unit_3v64x8m81_0/018SRAM_cell1_dummy_3v64x8m81_3/m2_134_89# new_dummyrow_unit_3v64x8m81_0/018SRAM_cell1_dummy_3v64x8m81_4/m2_134_89#
+ new_dummyrow_unit_3v64x8m81_0/018SRAM_cell1_dummy_3v64x8m81_4/m2_346_89# VSUBS new_dummyrow_unit_3v64x8m81_0/018SRAM_cell1_dummy_3v64x8m81_5/m2_134_89#
+ new_dummyrow_unit_3v64x8m81_0/018SRAM_cell1_dummy_3v64x8m81_5/m2_346_89# new_dummyrow_unit_3v64x8m81_0/018SRAM_cell1_dummy_3v64x8m81_10/m2_346_89#
+ new_dummyrow_unit_3v64x8m81_0/018SRAM_cell1_dummy_3v64x8m81_6/m2_346_89# new_dummyrow_unit_3v64x8m81_0/018SRAM_cell1_dummy_3v64x8m81_10/m2_134_89#
+ VSUBS new_dummyrow_unit_3v64x8m81_0/018SRAM_cell1_dummy_3v64x8m81_6/m2_134_89# array16_64_dummy_01_3v64x8m81_0/VDD_uq0
+ new_dummyrow_unit_3v64x8m81
X018SRAM_cell1_dummy_3v64x8m81_30 VSUBS VSUBS array16_64_dummy_01_3v64x8m81_0/VDD
+ array16_64_dummy_01_3v64x8m81_0/VDD VSUBS 018SRAM_cell1_dummy_3v64x8m81_30/m2_346_89#
+ 018SRAM_cell1_dummy_3v64x8m81_30/m2_134_89# VSUBS x018SRAM_cell1_dummy_3v64x8m81
X018SRAM_cell1_dummy_3v64x8m81_31 VSUBS VSUBS array16_64_dummy_01_3v64x8m81_0/VDD
+ array16_64_dummy_01_3v64x8m81_0/VDD VSUBS 018SRAM_cell1_dummy_3v64x8m81_31/m2_346_89#
+ 018SRAM_cell1_dummy_3v64x8m81_31/m2_134_89# VSUBS x018SRAM_cell1_dummy_3v64x8m81
X018SRAM_cell1_dummy_3v64x8m81_20 VSUBS VSUBS array16_64_dummy_01_3v64x8m81_0/VDD
+ array16_64_dummy_01_3v64x8m81_0/VDD VSUBS 018SRAM_cell1_dummy_3v64x8m81_20/m2_346_89#
+ 018SRAM_cell1_dummy_3v64x8m81_20/m2_134_89# VSUBS x018SRAM_cell1_dummy_3v64x8m81
X018SRAM_cell1_dummy_3v64x8m81_10 VSUBS VSUBS array16_64_dummy_01_3v64x8m81_0/VDD
+ array16_64_dummy_01_3v64x8m81_0/VDD VSUBS 018SRAM_cell1_dummy_3v64x8m81_10/m2_346_89#
+ 018SRAM_cell1_dummy_3v64x8m81_10/m2_134_89# VSUBS x018SRAM_cell1_dummy_3v64x8m81
Xnew_dummyrowunit01_3v64x8m81_0 new_dummyrowunit01_3v64x8m81_0/018SRAM_cell1_dummy_3v64x8m81_11/m2_346_89#
+ new_dummyrowunit01_3v64x8m81_0/018SRAM_cell1_dummy_3v64x8m81_11/m2_134_89# new_dummyrowunit01_3v64x8m81_0/018SRAM_cell1_dummy_3v64x8m81_7/m2_346_89#
+ new_dummyrowunit01_3v64x8m81_0/018SRAM_cell1_dummy_3v64x8m81_7/m2_134_89# new_dummyrowunit01_3v64x8m81_0/018SRAM_cell1_dummy_3v64x8m81_12/m2_346_89#
+ new_dummyrowunit01_3v64x8m81_0/018SRAM_cell1_dummy_3v64x8m81_12/m2_134_89# new_dummyrowunit01_3v64x8m81_0/018SRAM_cell1_dummy_3v64x8m81_8/m2_346_89#
+ new_dummyrowunit01_3v64x8m81_0/018SRAM_cell1_dummy_3v64x8m81_8/m2_134_89# new_dummyrowunit01_3v64x8m81_0/018SRAM_cell1_dummy_3v64x8m81_13/m2_346_89#
+ new_dummyrowunit01_3v64x8m81_0/018SRAM_cell1_dummy_3v64x8m81_13/m2_134_89# new_dummyrowunit01_3v64x8m81_0/018SRAM_cell1_dummy_3v64x8m81_9/m2_134_89#
+ new_dummyrowunit01_3v64x8m81_0/018SRAM_cell1_dummy_3v64x8m81_9/m2_346_89# new_dummyrowunit01_3v64x8m81_0/018SRAM_cell1_dummy_3v64x8m81_14/m2_346_89#
+ new_dummyrowunit01_3v64x8m81_0/018SRAM_cell1_dummy_3v64x8m81_14/m2_134_89# new_dummyrowunit01_3v64x8m81_0/018SRAM_cell1_dummy_3v64x8m81_15/m2_134_89#
+ new_dummyrowunit01_3v64x8m81_0/018SRAM_cell1_dummy_3v64x8m81_15/m2_346_89# new_dummyrowunit01_3v64x8m81_0/018SRAM_cell1_dummy_3v64x8m81_0/m2_134_89#
+ new_dummyrowunit01_3v64x8m81_0/018SRAM_cell1_dummy_3v64x8m81_0/m2_346_89# new_dummyrowunit01_3v64x8m81_0/018SRAM_cell1_dummy_3v64x8m81_1/m2_346_89#
+ new_dummyrowunit01_3v64x8m81_0/018SRAM_cell1_dummy_3v64x8m81_1/m2_134_89# new_dummyrowunit01_3v64x8m81_0/018SRAM_cell1_dummy_3v64x8m81_2/m2_346_89#
+ new_dummyrowunit01_3v64x8m81_0/018SRAM_cell1_dummy_3v64x8m81_2/m2_134_89# new_dummyrowunit01_3v64x8m81_0/018SRAM_cell1_dummy_3v64x8m81_3/m2_346_89#
+ new_dummyrowunit01_3v64x8m81_0/018SRAM_cell1_dummy_3v64x8m81_3/m2_134_89# new_dummyrowunit01_3v64x8m81_0/018SRAM_cell1_dummy_3v64x8m81_4/m2_346_89#
+ new_dummyrowunit01_3v64x8m81_0/018SRAM_cell1_dummy_3v64x8m81_4/m2_134_89# new_dummyrowunit01_3v64x8m81_0/018SRAM_cell1_dummy_3v64x8m81_5/m2_346_89#
+ new_dummyrowunit01_3v64x8m81_0/018SRAM_cell1_dummy_3v64x8m81_5/m2_134_89# VSUBS
+ new_dummyrowunit01_3v64x8m81_0/018SRAM_cell1_dummy_3v64x8m81_6/m2_346_89# new_dummyrowunit01_3v64x8m81_0/018SRAM_cell1_dummy_3v64x8m81_10/m2_134_89#
+ new_dummyrowunit01_3v64x8m81_0/018SRAM_cell1_dummy_3v64x8m81_10/m2_346_89# VSUBS
+ new_dummyrowunit01_3v64x8m81_0/018SRAM_cell1_dummy_3v64x8m81_6/m2_134_89# array16_64_dummy_01_3v64x8m81_0/VDD_uq0
+ new_dummyrowunit01_3v64x8m81
X018SRAM_cell1_dummy_3v64x8m81_21 VSUBS VSUBS array16_64_dummy_01_3v64x8m81_0/VDD
+ array16_64_dummy_01_3v64x8m81_0/VDD VSUBS 018SRAM_cell1_dummy_3v64x8m81_21/m2_346_89#
+ 018SRAM_cell1_dummy_3v64x8m81_21/m2_134_89# VSUBS x018SRAM_cell1_dummy_3v64x8m81
X018SRAM_cell1_dummy_3v64x8m81_11 VSUBS VSUBS array16_64_dummy_01_3v64x8m81_0/VDD
+ array16_64_dummy_01_3v64x8m81_0/VDD VSUBS 018SRAM_cell1_dummy_3v64x8m81_11/m2_346_89#
+ 018SRAM_cell1_dummy_3v64x8m81_11/m2_134_89# VSUBS x018SRAM_cell1_dummy_3v64x8m81
X018SRAM_cell1_dummy_3v64x8m81_12 VSUBS VSUBS array16_64_dummy_01_3v64x8m81_0/VDD
+ array16_64_dummy_01_3v64x8m81_0/VDD VSUBS 018SRAM_cell1_dummy_3v64x8m81_12/m2_346_89#
+ 018SRAM_cell1_dummy_3v64x8m81_12/m2_134_89# VSUBS x018SRAM_cell1_dummy_3v64x8m81
X018SRAM_cell1_dummy_3v64x8m81_23 VSUBS VSUBS array16_64_dummy_01_3v64x8m81_0/VDD
+ array16_64_dummy_01_3v64x8m81_0/VDD VSUBS 018SRAM_cell1_dummy_3v64x8m81_23/m2_346_89#
+ 018SRAM_cell1_dummy_3v64x8m81_23/m2_134_89# VSUBS x018SRAM_cell1_dummy_3v64x8m81
X018SRAM_cell1_dummy_3v64x8m81_22 VSUBS VSUBS array16_64_dummy_01_3v64x8m81_0/VDD
+ array16_64_dummy_01_3v64x8m81_0/VDD VSUBS 018SRAM_cell1_dummy_3v64x8m81_22/m2_346_89#
+ 018SRAM_cell1_dummy_3v64x8m81_22/m2_134_89# VSUBS x018SRAM_cell1_dummy_3v64x8m81
X018SRAM_cell1_3v64x8m81_0 VSUBS VSUBS array16_64_dummy_01_3v64x8m81_0/VDD VSUBS array16_64_dummy_01_3v64x8m81_0/VDD
+ 018SRAM_cell1_3v64x8m81_1/a_430_96# 018SRAM_cell1_3v64x8m81_1/a_110_96# VSUBS x018SRAM_cell1_3v64x8m81
X018SRAM_cell1_dummy_3v64x8m81_13 VSUBS VSUBS array16_64_dummy_01_3v64x8m81_0/VDD
+ array16_64_dummy_01_3v64x8m81_0/VDD VSUBS 018SRAM_cell1_dummy_3v64x8m81_13/m2_346_89#
+ 018SRAM_cell1_dummy_3v64x8m81_13/m2_134_89# VSUBS x018SRAM_cell1_dummy_3v64x8m81
X018SRAM_cell1_dummy_3v64x8m81_24 VSUBS VSUBS array16_64_dummy_01_3v64x8m81_0/VDD
+ array16_64_dummy_01_3v64x8m81_0/VDD VSUBS 018SRAM_cell1_dummy_3v64x8m81_24/m2_346_89#
+ 018SRAM_cell1_dummy_3v64x8m81_24/m2_134_89# VSUBS x018SRAM_cell1_dummy_3v64x8m81
X018SRAM_cell1_3v64x8m81_1 VSUBS VSUBS array16_64_dummy_01_3v64x8m81_0/VDD_uq0 VSUBS
+ array16_64_dummy_01_3v64x8m81_0/VDD_uq0 018SRAM_cell1_3v64x8m81_1/a_430_96# 018SRAM_cell1_3v64x8m81_1/a_110_96#
+ VSUBS x018SRAM_cell1_3v64x8m81
X018SRAM_cell1_dummy_3v64x8m81_14 VSUBS VSUBS array16_64_dummy_01_3v64x8m81_0/VDD
+ array16_64_dummy_01_3v64x8m81_0/VDD VSUBS 018SRAM_cell1_dummy_3v64x8m81_14/m2_346_89#
+ 018SRAM_cell1_dummy_3v64x8m81_14/m2_134_89# VSUBS x018SRAM_cell1_dummy_3v64x8m81
X018SRAM_cell1_dummy_3v64x8m81_25 VSUBS VSUBS array16_64_dummy_01_3v64x8m81_0/VDD
+ array16_64_dummy_01_3v64x8m81_0/VDD VSUBS 018SRAM_cell1_dummy_3v64x8m81_25/m2_346_89#
+ 018SRAM_cell1_dummy_3v64x8m81_25/m2_134_89# VSUBS x018SRAM_cell1_dummy_3v64x8m81
X018SRAM_cell1_dummy_3v64x8m81_26 VSUBS VSUBS array16_64_dummy_01_3v64x8m81_0/VDD
+ array16_64_dummy_01_3v64x8m81_0/VDD VSUBS 018SRAM_cell1_dummy_3v64x8m81_26/m2_346_89#
+ 018SRAM_cell1_dummy_3v64x8m81_26/m2_134_89# VSUBS x018SRAM_cell1_dummy_3v64x8m81
X018SRAM_cell1_dummy_3v64x8m81_15 VSUBS VSUBS array16_64_dummy_01_3v64x8m81_0/VDD
+ array16_64_dummy_01_3v64x8m81_0/VDD VSUBS 018SRAM_cell1_dummy_3v64x8m81_15/m2_346_89#
+ 018SRAM_cell1_dummy_3v64x8m81_15/m2_134_89# VSUBS x018SRAM_cell1_dummy_3v64x8m81
X018SRAM_cell1_dummy_3v64x8m81_16 VSUBS VSUBS array16_64_dummy_01_3v64x8m81_0/VDD
+ array16_64_dummy_01_3v64x8m81_0/VDD VSUBS 018SRAM_cell1_dummy_3v64x8m81_16/m2_346_89#
+ 018SRAM_cell1_dummy_3v64x8m81_16/m2_134_89# VSUBS x018SRAM_cell1_dummy_3v64x8m81
X018SRAM_cell1_dummy_3v64x8m81_27 VSUBS VSUBS array16_64_dummy_01_3v64x8m81_0/VDD
+ array16_64_dummy_01_3v64x8m81_0/VDD VSUBS 018SRAM_cell1_dummy_3v64x8m81_27/m2_346_89#
+ 018SRAM_cell1_dummy_3v64x8m81_27/m2_134_89# VSUBS x018SRAM_cell1_dummy_3v64x8m81
X018SRAM_cell1_dummy_3v64x8m81_17 VSUBS VSUBS array16_64_dummy_01_3v64x8m81_0/VDD
+ array16_64_dummy_01_3v64x8m81_0/VDD VSUBS 018SRAM_cell1_dummy_3v64x8m81_17/m2_346_89#
+ 018SRAM_cell1_dummy_3v64x8m81_17/m2_134_89# VSUBS x018SRAM_cell1_dummy_3v64x8m81
X018SRAM_cell1_dummy_3v64x8m81_28 VSUBS VSUBS array16_64_dummy_01_3v64x8m81_0/VDD
+ array16_64_dummy_01_3v64x8m81_0/VDD VSUBS 018SRAM_cell1_dummy_3v64x8m81_28/m2_346_89#
+ 018SRAM_cell1_dummy_3v64x8m81_28/m2_134_89# VSUBS x018SRAM_cell1_dummy_3v64x8m81
X018SRAM_cell1_dummy_3v64x8m81_0 VSUBS VSUBS array16_64_dummy_01_3v64x8m81_0/VDD array16_64_dummy_01_3v64x8m81_0/VDD
+ VSUBS 018SRAM_cell1_dummy_3v64x8m81_0/m2_346_89# 018SRAM_cell1_dummy_3v64x8m81_0/m2_134_89#
+ VSUBS x018SRAM_cell1_dummy_3v64x8m81
X018SRAM_cell1_dummy_3v64x8m81_18 VSUBS VSUBS array16_64_dummy_01_3v64x8m81_0/VDD
+ array16_64_dummy_01_3v64x8m81_0/VDD VSUBS 018SRAM_cell1_dummy_3v64x8m81_18/m2_346_89#
+ 018SRAM_cell1_dummy_3v64x8m81_18/m2_134_89# VSUBS x018SRAM_cell1_dummy_3v64x8m81
X018SRAM_cell1_dummy_3v64x8m81_29 VSUBS VSUBS array16_64_dummy_01_3v64x8m81_0/VDD
+ array16_64_dummy_01_3v64x8m81_0/VDD VSUBS 018SRAM_cell1_dummy_3v64x8m81_29/m2_346_89#
+ 018SRAM_cell1_dummy_3v64x8m81_29/m2_134_89# VSUBS x018SRAM_cell1_dummy_3v64x8m81
X018SRAM_cell1_dummy_3v64x8m81_1 VSUBS VSUBS array16_64_dummy_01_3v64x8m81_0/VDD array16_64_dummy_01_3v64x8m81_0/VDD
+ VSUBS 018SRAM_cell1_dummy_3v64x8m81_1/m2_346_89# 018SRAM_cell1_dummy_3v64x8m81_1/m2_134_89#
+ VSUBS x018SRAM_cell1_dummy_3v64x8m81
X018SRAM_cell1_dummy_3v64x8m81_19 VSUBS VSUBS array16_64_dummy_01_3v64x8m81_0/VDD
+ array16_64_dummy_01_3v64x8m81_0/VDD VSUBS 018SRAM_cell1_dummy_3v64x8m81_19/m2_346_89#
+ 018SRAM_cell1_dummy_3v64x8m81_19/m2_134_89# VSUBS x018SRAM_cell1_dummy_3v64x8m81
X018SRAM_cell1_dummy_3v64x8m81_2 VSUBS VSUBS array16_64_dummy_01_3v64x8m81_0/VDD array16_64_dummy_01_3v64x8m81_0/VDD
+ VSUBS 018SRAM_cell1_dummy_3v64x8m81_2/m2_346_89# 018SRAM_cell1_dummy_3v64x8m81_2/m2_134_89#
+ VSUBS x018SRAM_cell1_dummy_3v64x8m81
X018SRAM_cell1_dummy_3v64x8m81_3 VSUBS VSUBS array16_64_dummy_01_3v64x8m81_0/VDD array16_64_dummy_01_3v64x8m81_0/VDD
+ VSUBS 018SRAM_cell1_dummy_3v64x8m81_3/m2_346_89# 018SRAM_cell1_dummy_3v64x8m81_3/m2_134_89#
+ VSUBS x018SRAM_cell1_dummy_3v64x8m81
X018SRAM_cell1_dummy_3v64x8m81_4 VSUBS VSUBS array16_64_dummy_01_3v64x8m81_0/VDD array16_64_dummy_01_3v64x8m81_0/VDD
+ VSUBS 018SRAM_cell1_dummy_3v64x8m81_4/m2_346_89# 018SRAM_cell1_dummy_3v64x8m81_4/m2_134_89#
+ VSUBS x018SRAM_cell1_dummy_3v64x8m81
X018SRAM_cell1_dummy_3v64x8m81_5 VSUBS VSUBS array16_64_dummy_01_3v64x8m81_0/VDD array16_64_dummy_01_3v64x8m81_0/VDD
+ VSUBS 018SRAM_cell1_dummy_3v64x8m81_5/m2_346_89# 018SRAM_cell1_dummy_3v64x8m81_5/m2_134_89#
+ VSUBS x018SRAM_cell1_dummy_3v64x8m81
X018SRAM_cell1_dummy_3v64x8m81_6 VSUBS VSUBS array16_64_dummy_01_3v64x8m81_0/VDD array16_64_dummy_01_3v64x8m81_0/VDD
+ VSUBS 018SRAM_cell1_dummy_3v64x8m81_6/m2_346_89# 018SRAM_cell1_dummy_3v64x8m81_6/m2_134_89#
+ VSUBS x018SRAM_cell1_dummy_3v64x8m81
X018SRAM_cell1_dummy_3v64x8m81_7 VSUBS VSUBS array16_64_dummy_01_3v64x8m81_0/VDD array16_64_dummy_01_3v64x8m81_0/VDD
+ VSUBS 018SRAM_cell1_dummy_3v64x8m81_7/m2_346_89# 018SRAM_cell1_dummy_3v64x8m81_7/m2_134_89#
+ VSUBS x018SRAM_cell1_dummy_3v64x8m81
X018SRAM_cell1_dummy_3v64x8m81_8 VSUBS VSUBS array16_64_dummy_01_3v64x8m81_0/VDD array16_64_dummy_01_3v64x8m81_0/VDD
+ VSUBS 018SRAM_cell1_dummy_3v64x8m81_8/m2_346_89# 018SRAM_cell1_dummy_3v64x8m81_8/m2_134_89#
+ VSUBS x018SRAM_cell1_dummy_3v64x8m81
X018SRAM_cell1_dummy_3v64x8m81_9 VSUBS VSUBS array16_64_dummy_01_3v64x8m81_0/VDD array16_64_dummy_01_3v64x8m81_0/VDD
+ VSUBS 018SRAM_cell1_dummy_3v64x8m81_9/m2_346_89# 018SRAM_cell1_dummy_3v64x8m81_9/m2_134_89#
+ VSUBS x018SRAM_cell1_dummy_3v64x8m81
Xarray16_64_dummy_01_3v64x8m81_0 array16_64_dummy_01_3v64x8m81_0/018SRAM_cell1_cutPC_3v64x8m81_2/w_30_512#
+ VSUBS VSUBS VSUBS array16_64_dummy_01_3v64x8m81_0/VDD_uq0 VSUBS array16_64_dummy_01_3v64x8m81_0/018SRAM_cell1_cutPC_3v64x8m81_3/w_30_512#
+ array16_64_dummy_01_3v64x8m81_0/018SRAM_cell1_cutPC_3v64x8m81_2/m3_82_330# VSUBS
+ array16_64_dummy_01_3v64x8m81_0/018SRAM_cell1_cutPC_3v64x8m81_3/m3_82_330# array16_64_dummy_01_3v64x8m81_0/018SRAM_cell1_cutPC_3v64x8m81_3/a_248_342#
+ array16_64_dummy_01_3v64x8m81_0/018SRAM_cell1_cutPC_3v64x8m81_60/m3_82_330# array16_64_dummy_01_3v64x8m81_0/018SRAM_cell1_cutPC_3v64x8m81_31/m3_82_330#
+ array16_64_dummy_01_3v64x8m81_0/018SRAM_cell1_cutPC_3v64x8m81_60/a_248_342# array16_64_dummy_01_3v64x8m81_0/018SRAM_cell1_cutPC_3v64x8m81_61/w_30_512#
+ array16_64_dummy_01_3v64x8m81_0/018SRAM_cell1_cutPC_3v64x8m81_4/m3_82_330# array16_64_dummy_01_3v64x8m81_0/018SRAM_cell1_cutPC_3v64x8m81_3/a_248_592#
+ array16_64_dummy_01_3v64x8m81_0/018SRAM_cell1_cutPC_3v64x8m81_31/a_248_342# array16_64_dummy_01_3v64x8m81_0/018SRAM_cell1_cutPC_3v64x8m81_4/a_248_342#
+ array16_64_dummy_01_3v64x8m81_0/VDD_uq0 array16_64_dummy_01_3v64x8m81_0/018SRAM_cell1_cutPC_3v64x8m81_61/m3_82_330#
+ array16_64_dummy_01_3v64x8m81_0/018SRAM_cell1_cutPC_3v64x8m81_61/a_248_342# VSUBS
+ array16_64_dummy_01_3v64x8m81_0/018SRAM_cell1_cutPC_3v64x8m81_61/a_248_592# array16_64_dummy_01_3v64x8m81_0/018SRAM_cell1_cutPC_3v64x8m81_62/m3_82_330#
+ 018SRAM_cell1_3v64x8m81_1/a_110_96# VSUBS array16_64_dummy_01_3v64x8m81_0/018SRAM_cell1_cutPC_3v64x8m81_62/a_248_342#
+ array16_64_dummy_01_3v64x8m81_0/VDD array16_64_dummy_01_3v64x8m81_0/VSS array16_64_dummy_01_3v64x8m81_0/018SRAM_cell1_cutPC_3v64x8m81_63/m3_82_330#
+ array16_64_dummy_01_3v64x8m81_0/018SRAM_cell1_cutPC_3v64x8m81_63/a_248_342# array16_64_dummy_01_3v64x8m81_0/VDD
+ array16_64_dummy_01_3v64x8m81_0/018SRAM_cell1_cutPC_3v64x8m81_2/a_248_592# VSUBS
+ VSUBS 018SRAM_cell1_3v64x8m81_1/a_430_96# VSUBS array16_64_dummy_01_3v64x8m81
.ends

.subckt lcol4_64_3v64x8m81 WL[8] WL[6] din[3] q[1] q[2] q[3] pcb[2] pcb[3] pcb[0]
+ pcb[1] WEN[3] WEN[2] WEN[1] WEN[0] din[0] q[0] col_64a_3v64x8m81_0/ypass[0] din[1]
+ col_64a_3v64x8m81_0/ypass[1] col_64a_3v64x8m81_0/saout_m2_3v64x8m81_4/GWEN din[2]
+ col_64a_3v64x8m81_0/ypass[2] col_64a_3v64x8m81_0/ypass[3] col_64a_3v64x8m81_0/ypass[4]
+ col_64a_3v64x8m81_0/ypass[5] col_64a_3v64x8m81_0/ypass[6] WL[0] col_64a_3v64x8m81_0/ypass[7]
+ WL[1] WL[2] col_64a_3v64x8m81_0/men WL[3] WL[4] WL[5] col_64a_3v64x8m81_0/WL[6]
+ WL[7] col_64a_3v64x8m81_0/VDD_uq1 col_64a_3v64x8m81_0/VDD col_64a_3v64x8m81_0/VDD_uq4
+ col_64a_3v64x8m81_0/VDD_uq5 col_64a_3v64x8m81_0/VDD_uq0 col_64a_3v64x8m81_0/VDD_uq3
+ col_64a_3v64x8m81_0/VDD_uq2 VSUBS VDD col_64a_3v64x8m81_0/GWE
Xcol_64a_3v64x8m81_0 col_64a_3v64x8m81_0/ypass[0] col_64a_3v64x8m81_0/ypass[1] col_64a_3v64x8m81_0/ypass[3]
+ col_64a_3v64x8m81_0/ypass[4] col_64a_3v64x8m81_0/ypass[5] VSUBS col_64a_3v64x8m81_0/WL[6]
+ WL[4] col_64a_3v64x8m81_0/ypass[2] col_64a_3v64x8m81_0/b[10] col_64a_3v64x8m81_0/b[13]
+ col_64a_3v64x8m81_0/b[19] col_64a_3v64x8m81_0/b[31] din[1] din[3] din[2] din[0]
+ q[0] q[1] q[2] q[3] col_64a_3v64x8m81_0/b[17] col_64a_3v64x8m81_0/b[14] col_64a_3v64x8m81_0/bb[10]
+ col_64a_3v64x8m81_0/bb[11] col_64a_3v64x8m81_0/bb[12] col_64a_3v64x8m81_0/bb[13]
+ col_64a_3v64x8m81_0/bb[14] col_64a_3v64x8m81_0/bb[15] col_64a_3v64x8m81_0/bb[16]
+ col_64a_3v64x8m81_0/bb[22] col_64a_3v64x8m81_0/bb[24] col_64a_3v64x8m81_0/bb[25]
+ col_64a_3v64x8m81_0/bb[26] col_64a_3v64x8m81_0/bb[28] col_64a_3v64x8m81_0/bb[30]
+ col_64a_3v64x8m81_0/bb[31] col_64a_3v64x8m81_0/b[15] col_64a_3v64x8m81_0/b[12] col_64a_3v64x8m81_0/b[0]
+ pcb[0] pcb[1] pcb[2] WEN[1] WEN[0] col_64a_3v64x8m81_0/VDD_uq5 col_64a_3v64x8m81_0/b[3]
+ col_64a_3v64x8m81_0/b[1] WL[2] col_64a_3v64x8m81_0/b[5] col_64a_3v64x8m81_0/b[6]
+ WL[0] VSUBS col_64a_3v64x8m81_0/b[4] WL[7] col_64a_3v64x8m81_0/b[2] WL[5] col_64a_3v64x8m81_0/b[8]
+ col_64a_3v64x8m81_0/bb[20] col_64a_3v64x8m81_0/saout_m2_3v64x8m81_4/GWEN WL[3] col_64a_3v64x8m81_0/ypass[6]
+ WL[1] col_64a_3v64x8m81_0/bb[0] col_64a_3v64x8m81_0/ypass[7] col_64a_3v64x8m81_0/bb[1]
+ col_64a_3v64x8m81_0/bb[2] col_64a_3v64x8m81_0/b[11] col_64a_3v64x8m81_0/men col_64a_3v64x8m81_0/bb[23]
+ col_64a_3v64x8m81_0/bb[3] col_64a_3v64x8m81_0/VDD_uq4 col_64a_3v64x8m81_0/b[21]
+ col_64a_3v64x8m81_0/bb[4] col_64a_3v64x8m81_0/b[22] col_64a_3v64x8m81_0/bb[5] col_64a_3v64x8m81_0/VDD_uq1
+ col_64a_3v64x8m81_0/b[23] col_64a_3v64x8m81_0/b[9] pcb[3] col_64a_3v64x8m81_0/bb[21]
+ col_64a_3v64x8m81_0/bb[6] col_64a_3v64x8m81_0/b[24] col_64a_3v64x8m81_0/bb[7] col_64a_3v64x8m81_0/b[25]
+ col_64a_3v64x8m81_0/b[20] col_64a_3v64x8m81_0/VDD_uq2 col_64a_3v64x8m81_0/bb[8]
+ col_64a_3v64x8m81_0/b[30] col_64a_3v64x8m81_0/bb[9] col_64a_3v64x8m81_0/b[27] col_64a_3v64x8m81_0/VDD
+ col_64a_3v64x8m81_0/bb[18] col_64a_3v64x8m81_0/bb[29] col_64a_3v64x8m81_0/b[18]
+ col_64a_3v64x8m81_0/bb[19] col_64a_3v64x8m81_0/b[29] col_64a_3v64x8m81_0/b[28] col_64a_3v64x8m81_0/bb[17]
+ col_64a_3v64x8m81_0/VDD_uq0 WEN[3] col_64a_3v64x8m81_0/bb[27] col_64a_3v64x8m81_0/VDD_uq3
+ col_64a_3v64x8m81_0/b[16] col_64a_3v64x8m81_0/GWE WEN[2] col_64a_3v64x8m81_0/b[7]
+ VDD col_64a_3v64x8m81_0/b[26] VSUBS col_64a_3v64x8m81
Xdcap_103_novia_3v64x8m81_0[0] VDD VSUBS VDD dcap_103_novia_3v64x8m81
Xdcap_103_novia_3v64x8m81_0[1] VDD VSUBS VDD dcap_103_novia_3v64x8m81
Xdcap_103_novia_3v64x8m81_0[2] VDD VSUBS VDD dcap_103_novia_3v64x8m81
Xdcap_103_novia_3v64x8m81_0[3] VDD VSUBS VDD dcap_103_novia_3v64x8m81
Xdcap_103_novia_3v64x8m81_0[4] VDD VSUBS VDD dcap_103_novia_3v64x8m81
Xdcap_103_novia_3v64x8m81_0[5] VDD VSUBS VDD dcap_103_novia_3v64x8m81
Xdcap_103_novia_3v64x8m81_0[6] VDD VSUBS VDD dcap_103_novia_3v64x8m81
Xdcap_103_novia_3v64x8m81_0[7] VDD VSUBS VDD dcap_103_novia_3v64x8m81
Xdcap_103_novia_3v64x8m81_0[8] VDD VSUBS VDD dcap_103_novia_3v64x8m81
Xdcap_103_novia_3v64x8m81_0[9] VDD VSUBS VDD dcap_103_novia_3v64x8m81
Xdcap_103_novia_3v64x8m81_0[10] VDD VSUBS VDD dcap_103_novia_3v64x8m81
Xdcap_103_novia_3v64x8m81_0[11] VDD VSUBS VDD dcap_103_novia_3v64x8m81
Xdcap_103_novia_3v64x8m81_0[12] VDD VSUBS VDD dcap_103_novia_3v64x8m81
Xdcap_103_novia_3v64x8m81_0[13] VDD VSUBS VDD dcap_103_novia_3v64x8m81
Xdcap_103_novia_3v64x8m81_0[14] VDD VSUBS VDD dcap_103_novia_3v64x8m81
Xdcap_103_novia_3v64x8m81_0[15] VDD VSUBS VDD dcap_103_novia_3v64x8m81
Xdcap_103_novia_3v64x8m81_0[16] VDD VSUBS VDD dcap_103_novia_3v64x8m81
Xdcap_103_novia_3v64x8m81_0[17] VDD VSUBS VDD dcap_103_novia_3v64x8m81
Xdcap_103_novia_3v64x8m81_0[18] VDD VSUBS VDD dcap_103_novia_3v64x8m81
Xdcap_103_novia_3v64x8m81_0[19] VDD VSUBS VDD dcap_103_novia_3v64x8m81
Xdcap_103_novia_3v64x8m81_0[20] VDD VSUBS VDD dcap_103_novia_3v64x8m81
Xdcap_103_novia_3v64x8m81_0[21] VDD VSUBS VDD dcap_103_novia_3v64x8m81
Xdcap_103_novia_3v64x8m81_0[22] VDD VSUBS VDD dcap_103_novia_3v64x8m81
Xdcap_103_novia_3v64x8m81_0[23] VDD VSUBS VDD dcap_103_novia_3v64x8m81
Xdcap_103_novia_3v64x8m81_0[24] VDD VSUBS VDD dcap_103_novia_3v64x8m81
Xdcap_103_novia_3v64x8m81_0[25] VDD VSUBS VDD dcap_103_novia_3v64x8m81
Xdcap_103_novia_3v64x8m81_0[26] VDD VSUBS VDD dcap_103_novia_3v64x8m81
Xdcap_103_novia_3v64x8m81_0[27] VDD VSUBS VDD dcap_103_novia_3v64x8m81
Xdcap_103_novia_3v64x8m81_0[28] VDD VSUBS VDD dcap_103_novia_3v64x8m81
Xdcap_103_novia_3v64x8m81_0[29] VDD VSUBS VDD dcap_103_novia_3v64x8m81
Xdcap_103_novia_3v64x8m81_0[30] VDD VSUBS VDD dcap_103_novia_3v64x8m81
Xdcap_103_novia_3v64x8m81_0[31] VDD VSUBS VDD dcap_103_novia_3v64x8m81
Xdcap_103_novia_3v64x8m81_0[32] VDD VSUBS VDD dcap_103_novia_3v64x8m81
Xdcap_103_novia_3v64x8m81_0[33] VDD VSUBS VDD dcap_103_novia_3v64x8m81
Xdcap_103_novia_3v64x8m81_0[34] VDD VSUBS VDD dcap_103_novia_3v64x8m81
Xdcap_103_novia_3v64x8m81_0[35] VDD VSUBS VDD dcap_103_novia_3v64x8m81
Xldummy_3v64x4_3v64x8m81_0 col_64a_3v64x8m81_0/b[24] WL[3] VSUBS col_64a_3v64x8m81_0/bb[0]
+ VDD col_64a_3v64x8m81_0/b[0] col_64a_3v64x8m81_0/b[13] col_64a_3v64x8m81_0/bb[13]
+ WL[5] col_64a_3v64x8m81_0/bb[18] col_64a_3v64x8m81_0/bb[4] VSUBS col_64a_3v64x8m81_0/b[18]
+ col_64a_3v64x8m81_0/b[5] col_64a_3v64x8m81_0/b[4] col_64a_3v64x8m81_0/bb[5] col_64a_3v64x8m81_0/b[15]
+ WL[4] VSUBS col_64a_3v64x8m81_0/bb[15] col_64a_3v64x8m81_0/b[25] col_64a_3v64x8m81_0/bb[25]
+ col_64a_3v64x8m81_0/b[27] col_64a_3v64x8m81_0/bb[27] VDD col_64a_3v64x8m81_0/bb[8]
+ col_64a_3v64x8m81_0/bb[12] col_64a_3v64x8m81_0/b[8] WL[7] col_64a_3v64x8m81_0/b[12]
+ VSUBS col_64a_3v64x8m81_0/b[5] VDD col_64a_3v64x8m81_0/b[17] col_64a_3v64x8m81_0/b[3]
+ col_64a_3v64x8m81_0/bb[17] col_64a_3v64x8m81_0/bb[5] col_64a_3v64x8m81_0/bb[3] WL[0]
+ VSUBS VSUBS col_64a_3v64x8m81_0/bb[26] col_64a_3v64x8m81_0/b[26] col_64a_3v64x8m81_0/b[29]
+ col_64a_3v64x8m81_0/bb[29] col_64a_3v64x8m81_0/bb[9] col_64a_3v64x8m81_0/b[9] col_64a_3v64x8m81_0/bb[14]
+ col_64a_3v64x8m81_0/b[14] col_64a_3v64x8m81_0/bb[16] col_64a_3v64x8m81_0/b[3] col_64a_3v64x8m81_0/bb[2]
+ col_64a_3v64x8m81_0/b[16] col_64a_3v64x8m81_0/bb[3] col_64a_3v64x8m81_0/b[2] WL[2]
+ VSUBS col_64a_3v64x8m81_0/bb[28] col_64a_3v64x8m81_0/b[28] col_64a_3v64x8m81_0/bb[10]
+ VDD col_64a_3v64x8m81_0/b[15] col_64a_3v64x8m81_0/b[10] col_64a_3v64x8m81_0/bb[15]
+ col_64a_3v64x8m81_0/bb[2] col_64a_3v64x8m81_0/bb[24] col_64a_3v64x8m81_0/b[2] col_64a_3v64x8m81_0/b[24]
+ col_64a_3v64x8m81_0/bb[22] col_64a_3v64x8m81_0/b[22] col_64a_3v64x8m81_0/bb[30]
+ col_64a_3v64x8m81_0/b[30] col_64a_3v64x8m81_0/b[31] col_64a_3v64x8m81_0/b[7] col_64a_3v64x8m81_0/bb[31]
+ col_64a_3v64x8m81_0/bb[7] col_64a_3v64x8m81_0/b[25] col_64a_3v64x8m81_0/b[1] col_64a_3v64x8m81_0/bb[1]
+ col_64a_3v64x8m81_0/bb[11] col_64a_3v64x8m81_0/b[11] col_64a_3v64x8m81_0/bb[25]
+ col_64a_3v64x8m81_0/bb[20] col_64a_3v64x8m81_0/b[20] col_64a_3v64x8m81_0/b[31] col_64a_3v64x8m81_0/b[23]
+ col_64a_3v64x8m81_0/bb[31] col_64a_3v64x8m81_0/bb[23] col_64a_3v64x8m81_0/bb[26]
+ col_64a_3v64x8m81_0/bb[0] col_64a_3v64x8m81_0/b[0] col_64a_3v64x8m81_0/b[13] col_64a_3v64x8m81_0/b[26]
+ col_64a_3v64x8m81_0/bb[13] col_64a_3v64x8m81_0/b[21] col_64a_3v64x8m81_0/bb[21]
+ col_64a_3v64x8m81_0/b[23] col_64a_3v64x8m81_0/bb[23] col_64a_3v64x8m81_0/bb[22]
+ col_64a_3v64x8m81_0/b[22] col_64a_3v64x8m81_0/bb[8] col_64a_3v64x8m81_0/b[27] col_64a_3v64x8m81_0/bb[12]
+ col_64a_3v64x8m81_0/bb[27] col_64a_3v64x8m81_0/b[8] col_64a_3v64x8m81_0/b[12] col_64a_3v64x8m81_0/b[19]
+ VDD col_64a_3v64x8m81_0/bb[19] col_64a_3v64x8m81_0/bb[20] col_64a_3v64x8m81_0/b[20]
+ col_64a_3v64x8m81_0/bb[29] col_64a_3v64x8m81_0/b[9] col_64a_3v64x8m81_0/b[29] col_64a_3v64x8m81_0/b[14]
+ col_64a_3v64x8m81_0/bb[14] col_64a_3v64x8m81_0/bb[9] col_64a_3v64x8m81_0/bb[18]
+ col_64a_3v64x8m81_0/b[18] col_64a_3v64x8m81_0/b[21] col_64a_3v64x8m81_0/bb[21] col_64a_3v64x8m81_0/bb[28]
+ col_64a_3v64x8m81_0/bb[10] col_64a_3v64x8m81_0/b[28] col_64a_3v64x8m81_0/b[7] col_64a_3v64x8m81_0/b[10]
+ col_64a_3v64x8m81_0/bb[7] col_64a_3v64x8m81_0/bb[17] col_64a_3v64x8m81_0/b[17] col_64a_3v64x8m81_0/bb[6]
+ col_64a_3v64x8m81_0/b[6] col_64a_3v64x8m81_0/bb[16] VDD col_64a_3v64x8m81_0/b[16]
+ col_64a_3v64x8m81_0/b[1] col_64a_3v64x8m81_0/bb[1] col_64a_3v64x8m81_0/b[11] col_64a_3v64x8m81_0/bb[11]
+ WL[1] col_64a_3v64x8m81_0/bb[19] col_64a_3v64x8m81_0/bb[6] col_64a_3v64x8m81_0/b[19]
+ col_64a_3v64x8m81_0/b[6] col_64a_3v64x8m81_0/bb[4] col_64a_3v64x8m81_0/b[4] col_64a_3v64x8m81_0/bb[30]
+ col_64a_3v64x8m81_0/WL[6] col_64a_3v64x8m81_0/b[30] VSUBS VSUBS VDD VDD col_64a_3v64x8m81_0/bb[24]
+ ldummy_3v64x4_3v64x8m81
.ends

.subckt rarray4_64_3v64x8m81 018SRAM_cell1_2x_3v64x8m81_73/018SRAM_cell1_3v64x8m81_1/a_430_96#
+ 018SRAM_cell1_2x_3v64x8m81_343/018SRAM_cell1_3v64x8m81_1/a_430_96# 018SRAM_cell1_2x_3v64x8m81_330/018SRAM_cell1_3v64x8m81_1/a_110_96#
+ 018SRAM_cell1_2x_3v64x8m81_260/018SRAM_cell1_3v64x8m81_1/a_430_96# 018SRAM_cell1_2x_3v64x8m81_20/018SRAM_cell1_3v64x8m81_1/a_430_96#
+ 018SRAM_cell1_2x_3v64x8m81_9/018SRAM_cell1_3v64x8m81_1/a_110_96# 018SRAM_cell1_2x_3v64x8m81_73/018SRAM_cell1_3v64x8m81_1/a_110_96#
+ 018SRAM_cell1_2x_3v64x8m81_87/018SRAM_cell1_3v64x8m81_1/a_110_96# 018SRAM_cell1_2x_3v64x8m81_343/018SRAM_cell1_3v64x8m81_1/a_110_96#
+ 018SRAM_cell1_2x_3v64x8m81_264/018SRAM_cell1_3v64x8m81_1/a_110_96# 018SRAM_cell1_2x_3v64x8m81_341/018SRAM_cell1_3v64x8m81_1/a_430_96#
+ 018SRAM_cell1_2x_3v64x8m81_281/018SRAM_cell1_3v64x8m81_1/a_430_96# m3_n1397_2719#
+ 018SRAM_cell1_2x_3v64x8m81_260/018SRAM_cell1_3v64x8m81_1/a_110_96# 018SRAM_cell1_2x_3v64x8m81_54/018SRAM_cell1_3v64x8m81_1/a_430_96#
+ 018SRAM_cell1_2x_3v64x8m81_346/018SRAM_cell1_3v64x8m81_1/a_110_96# m3_n1397_247#
+ 018SRAM_cell1_2x_3v64x8m81_39/018SRAM_cell1_3v64x8m81_1/a_110_96# 018SRAM_cell1_2x_3v64x8m81_319/018SRAM_cell1_3v64x8m81_1/a_430_96#
+ 018SRAM_cell1_2x_3v64x8m81_285/018SRAM_cell1_3v64x8m81_1/a_430_96# 018SRAM_cell1_2x_3v64x8m81_78/018SRAM_cell1_3v64x8m81_1/a_110_96#
+ 018SRAM_cell1_2x_3v64x8m81_70/018SRAM_cell1_3v64x8m81_1/a_430_96# m3_n1397_3931#
+ 018SRAM_cell1_2x_3v64x8m81_8/018SRAM_cell1_3v64x8m81_1/a_430_96# 018SRAM_cell1_2x_3v64x8m81_43/018SRAM_cell1_3v64x8m81_1/a_110_96#
+ m3_n1397_1009# 018SRAM_cell1_2x_3v64x8m81_243/018SRAM_cell1_3v64x8m81_1/a_430_96#
+ 018SRAM_cell1_2x_3v64x8m81_96/018SRAM_cell1_3v64x8m81_1/a_430_96# 018SRAM_cell1_2x_3v64x8m81_20/018SRAM_cell1_3v64x8m81_1/a_110_96#
+ 018SRAM_cell1_2x_3v64x8m81_315/018SRAM_cell1_3v64x8m81_1/a_430_96# 018SRAM_cell1_2x_3v64x8m81_274/018SRAM_cell1_3v64x8m81_1/a_110_96#
+ 018SRAM_cell1_2x_3v64x8m81_109/018SRAM_cell1_3v64x8m81_1/a_430_96# 018SRAM_cell1_2x_3v64x8m81_103/018SRAM_cell1_3v64x8m81_1/a_430_96#
+ 018SRAM_cell1_2x_3v64x8m81_59/018SRAM_cell1_3v64x8m81_1/a_110_96# 018SRAM_cell1_2x_3v64x8m81_253/018SRAM_cell1_3v64x8m81_1/a_430_96#
+ 018SRAM_cell1_2x_3v64x8m81_292/018SRAM_cell1_3v64x8m81_1/a_430_96# 018SRAM_cell1_2x_3v64x8m81_349/018SRAM_cell1_3v64x8m81_1/a_110_96#
+ 018SRAM_cell1_2x_3v64x8m81_6/018SRAM_cell1_3v64x8m81_1/a_110_96# 018SRAM_cell1_2x_3v64x8m81_28/018SRAM_cell1_3v64x8m81_1/a_430_96#
+ 018SRAM_cell1_2x_3v64x8m81_87/018SRAM_cell1_3v64x8m81_1/a_430_96# m3_n1397_3433#
+ 018SRAM_cell1_2x_3v64x8m81_281/018SRAM_cell1_3v64x8m81_1/a_110_96# 018SRAM_cell1_2x_3v64x8m81_341/018SRAM_cell1_3v64x8m81_1/a_110_96#
+ 018SRAM_cell1_2x_3v64x8m81_324/018SRAM_cell1_3v64x8m81_1/a_110_96# 018SRAM_cell1_2x_3v64x8m81_54/018SRAM_cell1_3v64x8m81_1/a_110_96#
+ m3_n1397_2221# 018SRAM_cell1_2x_3v64x8m81_319/018SRAM_cell1_3v64x8m81_1/a_110_96#
+ 018SRAM_cell1_2x_3v64x8m81_9/018SRAM_cell1_3v64x8m81_1/a_430_96# 018SRAM_cell1_2x_3v64x8m81_346/018SRAM_cell1_3v64x8m81_1/a_430_96#
+ 018SRAM_cell1_2x_3v64x8m81_285/018SRAM_cell1_3v64x8m81_1/a_110_96# 018SRAM_cell1_2x_3v64x8m81_39/018SRAM_cell1_3v64x8m81_1/a_430_96#
+ 018SRAM_cell1_2x_3v64x8m81_349/018SRAM_cell1_3v64x8m81_1/a_430_96# 018SRAM_cell1_2x_3v64x8m81_70/018SRAM_cell1_3v64x8m81_1/a_110_96#
+ 018SRAM_cell1_2x_3v64x8m81_78/018SRAM_cell1_3v64x8m81_1/a_430_96# m3_n1397_1507#
+ 018SRAM_cell1_2x_3v64x8m81_264/018SRAM_cell1_3v64x8m81_1/a_430_96# 018SRAM_cell1_2x_3v64x8m81_8/018SRAM_cell1_3v64x8m81_1/a_110_96#
+ 018SRAM_cell1_2x_3v64x8m81_43/018SRAM_cell1_3v64x8m81_1/a_430_96# 018SRAM_cell1_2x_3v64x8m81_315/018SRAM_cell1_3v64x8m81_1/a_110_96#
+ 018SRAM_cell1_2x_3v64x8m81_243/018SRAM_cell1_3v64x8m81_1/a_110_96# 018SRAM_cell1_2x_3v64x8m81_96/018SRAM_cell1_3v64x8m81_1/a_110_96#
+ 018SRAM_cell1_2x_3v64x8m81_109/018SRAM_cell1_3v64x8m81_1/a_110_96# 018SRAM_cell1_2x_3v64x8m81_28/018SRAM_cell1_3v64x8m81_1/a_110_96#
+ 018SRAM_cell1_2x_3v64x8m81_6/018SRAM_cell1_3v64x8m81_1/a_430_96# 018SRAM_cell1_2x_3v64x8m81_103/018SRAM_cell1_3v64x8m81_1/a_110_96#
+ 018SRAM_cell1_2x_3v64x8m81_330/018SRAM_cell1_3v64x8m81_1/a_430_96# 018SRAM_cell1_2x_3v64x8m81_274/018SRAM_cell1_3v64x8m81_1/a_430_96#
+ 018SRAM_cell1_2x_3v64x8m81_324/018SRAM_cell1_3v64x8m81_1/a_430_96# 018SRAM_cell1_2x_3v64x8m81_253/018SRAM_cell1_3v64x8m81_1/a_110_96#
+ 018SRAM_cell1_2x_3v64x8m81_59/018SRAM_cell1_3v64x8m81_1/a_430_96# 018SRAM_cell1_2x_3v64x8m81_292/018SRAM_cell1_3v64x8m81_1/a_110_96#
+ 018SRAM_strap1_bndry_3v64x8m81_9/w_91_512# m3_n1397_4645# VSUBS
X018SRAM_cell1_2x_3v64x8m81_345 m3_n1397_1507# 018SRAM_strap1_bndry_3v64x8m81_9/w_91_512#
+ m3_n1397_1507# VSUBS 018SRAM_strap1_bndry_3v64x8m81_9/w_91_512# m3_n1397_2221# m3_n1397_2221#
+ VSUBS 018SRAM_strap1_bndry_3v64x8m81_9/w_91_512# 018SRAM_strap1_bndry_3v64x8m81_9/w_91_512#
+ 018SRAM_cell1_2x_3v64x8m81_349/018SRAM_cell1_3v64x8m81_1/a_430_96# VSUBS 018SRAM_cell1_2x_3v64x8m81_349/018SRAM_cell1_3v64x8m81_1/a_110_96#
+ x018SRAM_cell1_2x_3v64x8m81
X018SRAM_cell1_2x_3v64x8m81_301 m3_n1397_2719# 018SRAM_strap1_bndry_3v64x8m81_9/w_91_512#
+ m3_n1397_2719# VSUBS 018SRAM_strap1_bndry_3v64x8m81_9/w_91_512# m3_n1397_3433# m3_n1397_3433#
+ VSUBS 018SRAM_strap1_bndry_3v64x8m81_9/w_91_512# 018SRAM_strap1_bndry_3v64x8m81_9/w_91_512#
+ 018SRAM_cell1_2x_3v64x8m81_341/018SRAM_cell1_3v64x8m81_1/a_430_96# VSUBS 018SRAM_cell1_2x_3v64x8m81_341/018SRAM_cell1_3v64x8m81_1/a_110_96#
+ x018SRAM_cell1_2x_3v64x8m81
X018SRAM_cell1_2x_3v64x8m81_323 m3_n1397_2719# 018SRAM_strap1_bndry_3v64x8m81_9/w_91_512#
+ m3_n1397_2719# VSUBS 018SRAM_strap1_bndry_3v64x8m81_9/w_91_512# m3_n1397_3433# m3_n1397_3433#
+ VSUBS 018SRAM_strap1_bndry_3v64x8m81_9/w_91_512# 018SRAM_strap1_bndry_3v64x8m81_9/w_91_512#
+ 018SRAM_cell1_2x_3v64x8m81_324/018SRAM_cell1_3v64x8m81_1/a_430_96# VSUBS 018SRAM_cell1_2x_3v64x8m81_324/018SRAM_cell1_3v64x8m81_1/a_110_96#
+ x018SRAM_cell1_2x_3v64x8m81
X018SRAM_cell1_2x_3v64x8m81_312 m3_n1397_1507# 018SRAM_strap1_bndry_3v64x8m81_9/w_91_512#
+ m3_n1397_1507# VSUBS 018SRAM_strap1_bndry_3v64x8m81_9/w_91_512# m3_n1397_2221# m3_n1397_2221#
+ VSUBS 018SRAM_strap1_bndry_3v64x8m81_9/w_91_512# 018SRAM_strap1_bndry_3v64x8m81_9/w_91_512#
+ 018SRAM_cell1_2x_3v64x8m81_315/018SRAM_cell1_3v64x8m81_1/a_430_96# VSUBS 018SRAM_cell1_2x_3v64x8m81_315/018SRAM_cell1_3v64x8m81_1/a_110_96#
+ x018SRAM_cell1_2x_3v64x8m81
X018SRAM_cell1_2x_3v64x8m81_346 m3_n1397_1507# 018SRAM_strap1_bndry_3v64x8m81_9/w_91_512#
+ m3_n1397_1507# VSUBS 018SRAM_strap1_bndry_3v64x8m81_9/w_91_512# m3_n1397_2221# m3_n1397_2221#
+ VSUBS 018SRAM_strap1_bndry_3v64x8m81_9/w_91_512# 018SRAM_strap1_bndry_3v64x8m81_9/w_91_512#
+ 018SRAM_cell1_2x_3v64x8m81_346/018SRAM_cell1_3v64x8m81_1/a_430_96# VSUBS 018SRAM_cell1_2x_3v64x8m81_346/018SRAM_cell1_3v64x8m81_1/a_110_96#
+ x018SRAM_cell1_2x_3v64x8m81
X018SRAM_cell1_2x_3v64x8m81_302 m3_n1397_3931# 018SRAM_strap1_bndry_3v64x8m81_9/w_91_512#
+ m3_n1397_3931# VSUBS 018SRAM_strap1_bndry_3v64x8m81_9/w_91_512# m3_n1397_4645# m3_n1397_4645#
+ VSUBS 018SRAM_strap1_bndry_3v64x8m81_9/w_91_512# 018SRAM_strap1_bndry_3v64x8m81_9/w_91_512#
+ 018SRAM_cell1_2x_3v64x8m81_341/018SRAM_cell1_3v64x8m81_1/a_430_96# VSUBS 018SRAM_cell1_2x_3v64x8m81_341/018SRAM_cell1_3v64x8m81_1/a_110_96#
+ x018SRAM_cell1_2x_3v64x8m81
X018SRAM_cell1_2x_3v64x8m81_324 m3_n1397_3931# 018SRAM_strap1_bndry_3v64x8m81_9/w_91_512#
+ m3_n1397_3931# VSUBS 018SRAM_strap1_bndry_3v64x8m81_9/w_91_512# m3_n1397_4645# m3_n1397_4645#
+ VSUBS 018SRAM_strap1_bndry_3v64x8m81_9/w_91_512# 018SRAM_strap1_bndry_3v64x8m81_9/w_91_512#
+ 018SRAM_cell1_2x_3v64x8m81_324/018SRAM_cell1_3v64x8m81_1/a_430_96# VSUBS 018SRAM_cell1_2x_3v64x8m81_324/018SRAM_cell1_3v64x8m81_1/a_110_96#
+ x018SRAM_cell1_2x_3v64x8m81
X018SRAM_cell1_2x_3v64x8m81_313 m3_n1397_247# 018SRAM_strap1_bndry_3v64x8m81_9/w_91_512#
+ m3_n1397_247# VSUBS 018SRAM_strap1_bndry_3v64x8m81_9/w_91_512# m3_n1397_1009# m3_n1397_1009#
+ VSUBS 018SRAM_strap1_bndry_3v64x8m81_9/w_91_512# 018SRAM_strap1_bndry_3v64x8m81_9/w_91_512#
+ 018SRAM_cell1_2x_3v64x8m81_315/018SRAM_cell1_3v64x8m81_1/a_430_96# VSUBS 018SRAM_cell1_2x_3v64x8m81_315/018SRAM_cell1_3v64x8m81_1/a_110_96#
+ x018SRAM_cell1_2x_3v64x8m81
X018SRAM_cell1_2x_3v64x8m81_110 m3_n1397_1507# 018SRAM_strap1_bndry_3v64x8m81_9/w_91_512#
+ m3_n1397_1507# VSUBS 018SRAM_strap1_bndry_3v64x8m81_9/w_91_512# m3_n1397_2221# m3_n1397_2221#
+ VSUBS 018SRAM_strap1_bndry_3v64x8m81_9/w_91_512# 018SRAM_strap1_bndry_3v64x8m81_9/w_91_512#
+ 018SRAM_cell1_2x_3v64x8m81_73/018SRAM_cell1_3v64x8m81_1/a_430_96# VSUBS 018SRAM_cell1_2x_3v64x8m81_73/018SRAM_cell1_3v64x8m81_1/a_110_96#
+ x018SRAM_cell1_2x_3v64x8m81
X018SRAM_cell1_2x_3v64x8m81_347 m3_n1397_247# 018SRAM_strap1_bndry_3v64x8m81_9/w_91_512#
+ m3_n1397_247# VSUBS 018SRAM_strap1_bndry_3v64x8m81_9/w_91_512# m3_n1397_1009# m3_n1397_1009#
+ VSUBS 018SRAM_strap1_bndry_3v64x8m81_9/w_91_512# 018SRAM_strap1_bndry_3v64x8m81_9/w_91_512#
+ 018SRAM_cell1_2x_3v64x8m81_349/018SRAM_cell1_3v64x8m81_1/a_430_96# VSUBS 018SRAM_cell1_2x_3v64x8m81_349/018SRAM_cell1_3v64x8m81_1/a_110_96#
+ x018SRAM_cell1_2x_3v64x8m81
X018SRAM_cell1_2x_3v64x8m81_336 m3_n1397_2719# 018SRAM_strap1_bndry_3v64x8m81_9/w_91_512#
+ m3_n1397_2719# VSUBS 018SRAM_strap1_bndry_3v64x8m81_9/w_91_512# m3_n1397_3433# m3_n1397_3433#
+ VSUBS 018SRAM_strap1_bndry_3v64x8m81_9/w_91_512# 018SRAM_strap1_bndry_3v64x8m81_9/w_91_512#
+ 018SRAM_cell1_2x_3v64x8m81_343/018SRAM_cell1_3v64x8m81_1/a_430_96# VSUBS 018SRAM_cell1_2x_3v64x8m81_343/018SRAM_cell1_3v64x8m81_1/a_110_96#
+ x018SRAM_cell1_2x_3v64x8m81
X018SRAM_cell1_2x_3v64x8m81_314 m3_n1397_2719# 018SRAM_strap1_bndry_3v64x8m81_9/w_91_512#
+ m3_n1397_2719# VSUBS 018SRAM_strap1_bndry_3v64x8m81_9/w_91_512# m3_n1397_3433# m3_n1397_3433#
+ VSUBS 018SRAM_strap1_bndry_3v64x8m81_9/w_91_512# 018SRAM_strap1_bndry_3v64x8m81_9/w_91_512#
+ 018SRAM_cell1_2x_3v64x8m81_315/018SRAM_cell1_3v64x8m81_1/a_430_96# VSUBS 018SRAM_cell1_2x_3v64x8m81_315/018SRAM_cell1_3v64x8m81_1/a_110_96#
+ x018SRAM_cell1_2x_3v64x8m81
X018SRAM_cell1_2x_3v64x8m81_111 m3_n1397_247# 018SRAM_strap1_bndry_3v64x8m81_9/w_91_512#
+ m3_n1397_247# VSUBS 018SRAM_strap1_bndry_3v64x8m81_9/w_91_512# m3_n1397_1009# m3_n1397_1009#
+ VSUBS 018SRAM_strap1_bndry_3v64x8m81_9/w_91_512# 018SRAM_strap1_bndry_3v64x8m81_9/w_91_512#
+ 018SRAM_cell1_2x_3v64x8m81_73/018SRAM_cell1_3v64x8m81_1/a_430_96# VSUBS 018SRAM_cell1_2x_3v64x8m81_73/018SRAM_cell1_3v64x8m81_1/a_110_96#
+ x018SRAM_cell1_2x_3v64x8m81
X018SRAM_cell1_2x_3v64x8m81_100 m3_n1397_1507# 018SRAM_strap1_bndry_3v64x8m81_9/w_91_512#
+ m3_n1397_1507# VSUBS 018SRAM_strap1_bndry_3v64x8m81_9/w_91_512# m3_n1397_2221# m3_n1397_2221#
+ VSUBS 018SRAM_strap1_bndry_3v64x8m81_9/w_91_512# 018SRAM_strap1_bndry_3v64x8m81_9/w_91_512#
+ 018SRAM_cell1_2x_3v64x8m81_103/018SRAM_cell1_3v64x8m81_1/a_430_96# VSUBS 018SRAM_cell1_2x_3v64x8m81_103/018SRAM_cell1_3v64x8m81_1/a_110_96#
+ x018SRAM_cell1_2x_3v64x8m81
X018SRAM_cell1_2x_3v64x8m81_348 m3_n1397_2719# 018SRAM_strap1_bndry_3v64x8m81_9/w_91_512#
+ m3_n1397_2719# VSUBS 018SRAM_strap1_bndry_3v64x8m81_9/w_91_512# m3_n1397_3433# m3_n1397_3433#
+ VSUBS 018SRAM_strap1_bndry_3v64x8m81_9/w_91_512# 018SRAM_strap1_bndry_3v64x8m81_9/w_91_512#
+ 018SRAM_cell1_2x_3v64x8m81_349/018SRAM_cell1_3v64x8m81_1/a_430_96# VSUBS 018SRAM_cell1_2x_3v64x8m81_349/018SRAM_cell1_3v64x8m81_1/a_110_96#
+ x018SRAM_cell1_2x_3v64x8m81
X018SRAM_cell1_2x_3v64x8m81_337 m3_n1397_3931# 018SRAM_strap1_bndry_3v64x8m81_9/w_91_512#
+ m3_n1397_3931# VSUBS 018SRAM_strap1_bndry_3v64x8m81_9/w_91_512# m3_n1397_4645# m3_n1397_4645#
+ VSUBS 018SRAM_strap1_bndry_3v64x8m81_9/w_91_512# 018SRAM_strap1_bndry_3v64x8m81_9/w_91_512#
+ 018SRAM_cell1_2x_3v64x8m81_343/018SRAM_cell1_3v64x8m81_1/a_430_96# VSUBS 018SRAM_cell1_2x_3v64x8m81_343/018SRAM_cell1_3v64x8m81_1/a_110_96#
+ x018SRAM_cell1_2x_3v64x8m81
X018SRAM_cell1_2x_3v64x8m81_315 m3_n1397_3931# 018SRAM_strap1_bndry_3v64x8m81_9/w_91_512#
+ m3_n1397_3931# VSUBS 018SRAM_strap1_bndry_3v64x8m81_9/w_91_512# m3_n1397_4645# m3_n1397_4645#
+ VSUBS 018SRAM_strap1_bndry_3v64x8m81_9/w_91_512# 018SRAM_strap1_bndry_3v64x8m81_9/w_91_512#
+ 018SRAM_cell1_2x_3v64x8m81_315/018SRAM_cell1_3v64x8m81_1/a_430_96# VSUBS 018SRAM_cell1_2x_3v64x8m81_315/018SRAM_cell1_3v64x8m81_1/a_110_96#
+ x018SRAM_cell1_2x_3v64x8m81
X018SRAM_cell1_2x_3v64x8m81_101 m3_n1397_247# 018SRAM_strap1_bndry_3v64x8m81_9/w_91_512#
+ m3_n1397_247# VSUBS 018SRAM_strap1_bndry_3v64x8m81_9/w_91_512# m3_n1397_1009# m3_n1397_1009#
+ VSUBS 018SRAM_strap1_bndry_3v64x8m81_9/w_91_512# 018SRAM_strap1_bndry_3v64x8m81_9/w_91_512#
+ 018SRAM_cell1_2x_3v64x8m81_103/018SRAM_cell1_3v64x8m81_1/a_430_96# VSUBS 018SRAM_cell1_2x_3v64x8m81_103/018SRAM_cell1_3v64x8m81_1/a_110_96#
+ x018SRAM_cell1_2x_3v64x8m81
X018SRAM_cell1_2x_3v64x8m81_349 m3_n1397_3931# 018SRAM_strap1_bndry_3v64x8m81_9/w_91_512#
+ m3_n1397_3931# VSUBS 018SRAM_strap1_bndry_3v64x8m81_9/w_91_512# m3_n1397_4645# m3_n1397_4645#
+ VSUBS 018SRAM_strap1_bndry_3v64x8m81_9/w_91_512# 018SRAM_strap1_bndry_3v64x8m81_9/w_91_512#
+ 018SRAM_cell1_2x_3v64x8m81_349/018SRAM_cell1_3v64x8m81_1/a_430_96# VSUBS 018SRAM_cell1_2x_3v64x8m81_349/018SRAM_cell1_3v64x8m81_1/a_110_96#
+ x018SRAM_cell1_2x_3v64x8m81
X018SRAM_cell1_2x_3v64x8m81_327 m3_n1397_1507# 018SRAM_strap1_bndry_3v64x8m81_9/w_91_512#
+ m3_n1397_1507# VSUBS 018SRAM_strap1_bndry_3v64x8m81_9/w_91_512# m3_n1397_2221# m3_n1397_2221#
+ VSUBS 018SRAM_strap1_bndry_3v64x8m81_9/w_91_512# 018SRAM_strap1_bndry_3v64x8m81_9/w_91_512#
+ 018SRAM_cell1_2x_3v64x8m81_330/018SRAM_cell1_3v64x8m81_1/a_430_96# VSUBS 018SRAM_cell1_2x_3v64x8m81_330/018SRAM_cell1_3v64x8m81_1/a_110_96#
+ x018SRAM_cell1_2x_3v64x8m81
X018SRAM_cell1_2x_3v64x8m81_102 m3_n1397_2719# 018SRAM_strap1_bndry_3v64x8m81_9/w_91_512#
+ m3_n1397_2719# VSUBS 018SRAM_strap1_bndry_3v64x8m81_9/w_91_512# m3_n1397_3433# m3_n1397_3433#
+ VSUBS 018SRAM_strap1_bndry_3v64x8m81_9/w_91_512# 018SRAM_strap1_bndry_3v64x8m81_9/w_91_512#
+ 018SRAM_cell1_2x_3v64x8m81_103/018SRAM_cell1_3v64x8m81_1/a_430_96# VSUBS 018SRAM_cell1_2x_3v64x8m81_103/018SRAM_cell1_3v64x8m81_1/a_110_96#
+ x018SRAM_cell1_2x_3v64x8m81
X018SRAM_cell1_2x_3v64x8m81_328 m3_n1397_247# 018SRAM_strap1_bndry_3v64x8m81_9/w_91_512#
+ m3_n1397_247# VSUBS 018SRAM_strap1_bndry_3v64x8m81_9/w_91_512# m3_n1397_1009# m3_n1397_1009#
+ VSUBS 018SRAM_strap1_bndry_3v64x8m81_9/w_91_512# 018SRAM_strap1_bndry_3v64x8m81_9/w_91_512#
+ 018SRAM_cell1_2x_3v64x8m81_330/018SRAM_cell1_3v64x8m81_1/a_430_96# VSUBS 018SRAM_cell1_2x_3v64x8m81_330/018SRAM_cell1_3v64x8m81_1/a_110_96#
+ x018SRAM_cell1_2x_3v64x8m81
X018SRAM_cell1_2x_3v64x8m81_103 m3_n1397_3931# 018SRAM_strap1_bndry_3v64x8m81_9/w_91_512#
+ m3_n1397_3931# VSUBS 018SRAM_strap1_bndry_3v64x8m81_9/w_91_512# m3_n1397_4645# m3_n1397_4645#
+ VSUBS 018SRAM_strap1_bndry_3v64x8m81_9/w_91_512# 018SRAM_strap1_bndry_3v64x8m81_9/w_91_512#
+ 018SRAM_cell1_2x_3v64x8m81_103/018SRAM_cell1_3v64x8m81_1/a_430_96# VSUBS 018SRAM_cell1_2x_3v64x8m81_103/018SRAM_cell1_3v64x8m81_1/a_110_96#
+ x018SRAM_cell1_2x_3v64x8m81
X018SRAM_cell1_2x_3v64x8m81_329 m3_n1397_2719# 018SRAM_strap1_bndry_3v64x8m81_9/w_91_512#
+ m3_n1397_2719# VSUBS 018SRAM_strap1_bndry_3v64x8m81_9/w_91_512# m3_n1397_3433# m3_n1397_3433#
+ VSUBS 018SRAM_strap1_bndry_3v64x8m81_9/w_91_512# 018SRAM_strap1_bndry_3v64x8m81_9/w_91_512#
+ 018SRAM_cell1_2x_3v64x8m81_330/018SRAM_cell1_3v64x8m81_1/a_430_96# VSUBS 018SRAM_cell1_2x_3v64x8m81_330/018SRAM_cell1_3v64x8m81_1/a_110_96#
+ x018SRAM_cell1_2x_3v64x8m81
X018SRAM_cell1_2x_3v64x8m81_319 m3_n1397_3931# 018SRAM_strap1_bndry_3v64x8m81_9/w_91_512#
+ m3_n1397_3931# VSUBS 018SRAM_strap1_bndry_3v64x8m81_9/w_91_512# m3_n1397_4645# m3_n1397_4645#
+ VSUBS 018SRAM_strap1_bndry_3v64x8m81_9/w_91_512# 018SRAM_strap1_bndry_3v64x8m81_9/w_91_512#
+ 018SRAM_cell1_2x_3v64x8m81_319/018SRAM_cell1_3v64x8m81_1/a_430_96# VSUBS 018SRAM_cell1_2x_3v64x8m81_319/018SRAM_cell1_3v64x8m81_1/a_110_96#
+ x018SRAM_cell1_2x_3v64x8m81
X018SRAM_cell1_2x_3v64x8m81_309 m3_n1397_1507# 018SRAM_strap1_bndry_3v64x8m81_9/w_91_512#
+ m3_n1397_1507# VSUBS 018SRAM_strap1_bndry_3v64x8m81_9/w_91_512# m3_n1397_2221# m3_n1397_2221#
+ VSUBS 018SRAM_strap1_bndry_3v64x8m81_9/w_91_512# 018SRAM_strap1_bndry_3v64x8m81_9/w_91_512#
+ 018SRAM_cell1_2x_3v64x8m81_319/018SRAM_cell1_3v64x8m81_1/a_430_96# VSUBS 018SRAM_cell1_2x_3v64x8m81_319/018SRAM_cell1_3v64x8m81_1/a_110_96#
+ x018SRAM_cell1_2x_3v64x8m81
X018SRAM_cell1_2x_3v64x8m81_106 m3_n1397_1507# 018SRAM_strap1_bndry_3v64x8m81_9/w_91_512#
+ m3_n1397_1507# VSUBS 018SRAM_strap1_bndry_3v64x8m81_9/w_91_512# m3_n1397_2221# m3_n1397_2221#
+ VSUBS 018SRAM_strap1_bndry_3v64x8m81_9/w_91_512# 018SRAM_strap1_bndry_3v64x8m81_9/w_91_512#
+ 018SRAM_cell1_2x_3v64x8m81_109/018SRAM_cell1_3v64x8m81_1/a_430_96# VSUBS 018SRAM_cell1_2x_3v64x8m81_109/018SRAM_cell1_3v64x8m81_1/a_110_96#
+ x018SRAM_cell1_2x_3v64x8m81
X018SRAM_cell1_2x_3v64x8m81_107 m3_n1397_247# 018SRAM_strap1_bndry_3v64x8m81_9/w_91_512#
+ m3_n1397_247# VSUBS 018SRAM_strap1_bndry_3v64x8m81_9/w_91_512# m3_n1397_1009# m3_n1397_1009#
+ VSUBS 018SRAM_strap1_bndry_3v64x8m81_9/w_91_512# 018SRAM_strap1_bndry_3v64x8m81_9/w_91_512#
+ 018SRAM_cell1_2x_3v64x8m81_109/018SRAM_cell1_3v64x8m81_1/a_430_96# VSUBS 018SRAM_cell1_2x_3v64x8m81_109/018SRAM_cell1_3v64x8m81_1/a_110_96#
+ x018SRAM_cell1_2x_3v64x8m81
X018SRAM_cell1_2x_3v64x8m81_108 m3_n1397_2719# 018SRAM_strap1_bndry_3v64x8m81_9/w_91_512#
+ m3_n1397_2719# VSUBS 018SRAM_strap1_bndry_3v64x8m81_9/w_91_512# m3_n1397_3433# m3_n1397_3433#
+ VSUBS 018SRAM_strap1_bndry_3v64x8m81_9/w_91_512# 018SRAM_strap1_bndry_3v64x8m81_9/w_91_512#
+ 018SRAM_cell1_2x_3v64x8m81_109/018SRAM_cell1_3v64x8m81_1/a_430_96# VSUBS 018SRAM_cell1_2x_3v64x8m81_109/018SRAM_cell1_3v64x8m81_1/a_110_96#
+ x018SRAM_cell1_2x_3v64x8m81
X018SRAM_cell1_2x_3v64x8m81_280 m3_n1397_2719# 018SRAM_strap1_bndry_3v64x8m81_9/w_91_512#
+ m3_n1397_2719# VSUBS 018SRAM_strap1_bndry_3v64x8m81_9/w_91_512# m3_n1397_3433# m3_n1397_3433#
+ VSUBS 018SRAM_strap1_bndry_3v64x8m81_9/w_91_512# 018SRAM_strap1_bndry_3v64x8m81_9/w_91_512#
+ 018SRAM_cell1_2x_3v64x8m81_281/018SRAM_cell1_3v64x8m81_1/a_430_96# VSUBS 018SRAM_cell1_2x_3v64x8m81_281/018SRAM_cell1_3v64x8m81_1/a_110_96#
+ x018SRAM_cell1_2x_3v64x8m81
X018SRAM_cell1_2x_3v64x8m81_109 m3_n1397_3931# 018SRAM_strap1_bndry_3v64x8m81_9/w_91_512#
+ m3_n1397_3931# VSUBS 018SRAM_strap1_bndry_3v64x8m81_9/w_91_512# m3_n1397_4645# m3_n1397_4645#
+ VSUBS 018SRAM_strap1_bndry_3v64x8m81_9/w_91_512# 018SRAM_strap1_bndry_3v64x8m81_9/w_91_512#
+ 018SRAM_cell1_2x_3v64x8m81_109/018SRAM_cell1_3v64x8m81_1/a_430_96# VSUBS 018SRAM_cell1_2x_3v64x8m81_109/018SRAM_cell1_3v64x8m81_1/a_110_96#
+ x018SRAM_cell1_2x_3v64x8m81
X018SRAM_cell1_2x_3v64x8m81_4 m3_n1397_3931# 018SRAM_strap1_bndry_3v64x8m81_9/w_91_512#
+ m3_n1397_3931# VSUBS 018SRAM_strap1_bndry_3v64x8m81_9/w_91_512# m3_n1397_4645# m3_n1397_4645#
+ VSUBS 018SRAM_strap1_bndry_3v64x8m81_9/w_91_512# 018SRAM_strap1_bndry_3v64x8m81_9/w_91_512#
+ 018SRAM_cell1_2x_3v64x8m81_9/018SRAM_cell1_3v64x8m81_1/a_430_96# VSUBS 018SRAM_cell1_2x_3v64x8m81_9/018SRAM_cell1_3v64x8m81_1/a_110_96#
+ x018SRAM_cell1_2x_3v64x8m81
X018SRAM_cell1_2x_3v64x8m81_292 m3_n1397_3931# 018SRAM_strap1_bndry_3v64x8m81_9/w_91_512#
+ m3_n1397_3931# VSUBS 018SRAM_strap1_bndry_3v64x8m81_9/w_91_512# m3_n1397_4645# m3_n1397_4645#
+ VSUBS 018SRAM_strap1_bndry_3v64x8m81_9/w_91_512# 018SRAM_strap1_bndry_3v64x8m81_9/w_91_512#
+ 018SRAM_cell1_2x_3v64x8m81_292/018SRAM_cell1_3v64x8m81_1/a_430_96# VSUBS 018SRAM_cell1_2x_3v64x8m81_292/018SRAM_cell1_3v64x8m81_1/a_110_96#
+ x018SRAM_cell1_2x_3v64x8m81
X018SRAM_cell1_2x_3v64x8m81_281 m3_n1397_3931# 018SRAM_strap1_bndry_3v64x8m81_9/w_91_512#
+ m3_n1397_3931# VSUBS 018SRAM_strap1_bndry_3v64x8m81_9/w_91_512# m3_n1397_4645# m3_n1397_4645#
+ VSUBS 018SRAM_strap1_bndry_3v64x8m81_9/w_91_512# 018SRAM_strap1_bndry_3v64x8m81_9/w_91_512#
+ 018SRAM_cell1_2x_3v64x8m81_281/018SRAM_cell1_3v64x8m81_1/a_430_96# VSUBS 018SRAM_cell1_2x_3v64x8m81_281/018SRAM_cell1_3v64x8m81_1/a_110_96#
+ x018SRAM_cell1_2x_3v64x8m81
X018SRAM_cell1_2x_3v64x8m81_5 m3_n1397_2719# 018SRAM_strap1_bndry_3v64x8m81_9/w_91_512#
+ m3_n1397_2719# VSUBS 018SRAM_strap1_bndry_3v64x8m81_9/w_91_512# m3_n1397_3433# m3_n1397_3433#
+ VSUBS 018SRAM_strap1_bndry_3v64x8m81_9/w_91_512# 018SRAM_strap1_bndry_3v64x8m81_9/w_91_512#
+ 018SRAM_cell1_2x_3v64x8m81_9/018SRAM_cell1_3v64x8m81_1/a_430_96# VSUBS 018SRAM_cell1_2x_3v64x8m81_9/018SRAM_cell1_3v64x8m81_1/a_110_96#
+ x018SRAM_cell1_2x_3v64x8m81
X018SRAM_cell1_2x_3v64x8m81_260 m3_n1397_3931# 018SRAM_strap1_bndry_3v64x8m81_9/w_91_512#
+ m3_n1397_3931# VSUBS 018SRAM_strap1_bndry_3v64x8m81_9/w_91_512# m3_n1397_4645# m3_n1397_4645#
+ VSUBS 018SRAM_strap1_bndry_3v64x8m81_9/w_91_512# 018SRAM_strap1_bndry_3v64x8m81_9/w_91_512#
+ 018SRAM_cell1_2x_3v64x8m81_260/018SRAM_cell1_3v64x8m81_1/a_430_96# VSUBS 018SRAM_cell1_2x_3v64x8m81_260/018SRAM_cell1_3v64x8m81_1/a_110_96#
+ x018SRAM_cell1_2x_3v64x8m81
X018SRAM_cell1_2x_3v64x8m81_282 m3_n1397_1507# 018SRAM_strap1_bndry_3v64x8m81_9/w_91_512#
+ m3_n1397_1507# VSUBS 018SRAM_strap1_bndry_3v64x8m81_9/w_91_512# m3_n1397_2221# m3_n1397_2221#
+ VSUBS 018SRAM_strap1_bndry_3v64x8m81_9/w_91_512# 018SRAM_strap1_bndry_3v64x8m81_9/w_91_512#
+ 018SRAM_cell1_2x_3v64x8m81_285/018SRAM_cell1_3v64x8m81_1/a_430_96# VSUBS 018SRAM_cell1_2x_3v64x8m81_285/018SRAM_cell1_3v64x8m81_1/a_110_96#
+ x018SRAM_cell1_2x_3v64x8m81
X018SRAM_cell1_2x_3v64x8m81_271 m3_n1397_1507# 018SRAM_strap1_bndry_3v64x8m81_9/w_91_512#
+ m3_n1397_1507# VSUBS 018SRAM_strap1_bndry_3v64x8m81_9/w_91_512# m3_n1397_2221# m3_n1397_2221#
+ VSUBS 018SRAM_strap1_bndry_3v64x8m81_9/w_91_512# 018SRAM_strap1_bndry_3v64x8m81_9/w_91_512#
+ 018SRAM_cell1_2x_3v64x8m81_274/018SRAM_cell1_3v64x8m81_1/a_430_96# VSUBS 018SRAM_cell1_2x_3v64x8m81_274/018SRAM_cell1_3v64x8m81_1/a_110_96#
+ x018SRAM_cell1_2x_3v64x8m81
X018SRAM_cell1_2x_3v64x8m81_6 m3_n1397_247# 018SRAM_strap1_bndry_3v64x8m81_9/w_91_512#
+ m3_n1397_247# VSUBS 018SRAM_strap1_bndry_3v64x8m81_9/w_91_512# m3_n1397_1009# m3_n1397_1009#
+ VSUBS 018SRAM_strap1_bndry_3v64x8m81_9/w_91_512# 018SRAM_strap1_bndry_3v64x8m81_9/w_91_512#
+ 018SRAM_cell1_2x_3v64x8m81_6/018SRAM_cell1_3v64x8m81_1/a_430_96# VSUBS 018SRAM_cell1_2x_3v64x8m81_6/018SRAM_cell1_3v64x8m81_1/a_110_96#
+ x018SRAM_cell1_2x_3v64x8m81
X018SRAM_cell1_2x_3v64x8m81_283 m3_n1397_247# 018SRAM_strap1_bndry_3v64x8m81_9/w_91_512#
+ m3_n1397_247# VSUBS 018SRAM_strap1_bndry_3v64x8m81_9/w_91_512# m3_n1397_1009# m3_n1397_1009#
+ VSUBS 018SRAM_strap1_bndry_3v64x8m81_9/w_91_512# 018SRAM_strap1_bndry_3v64x8m81_9/w_91_512#
+ 018SRAM_cell1_2x_3v64x8m81_285/018SRAM_cell1_3v64x8m81_1/a_430_96# VSUBS 018SRAM_cell1_2x_3v64x8m81_285/018SRAM_cell1_3v64x8m81_1/a_110_96#
+ x018SRAM_cell1_2x_3v64x8m81
X018SRAM_cell1_2x_3v64x8m81_250 m3_n1397_1507# 018SRAM_strap1_bndry_3v64x8m81_9/w_91_512#
+ m3_n1397_1507# VSUBS 018SRAM_strap1_bndry_3v64x8m81_9/w_91_512# m3_n1397_2221# m3_n1397_2221#
+ VSUBS 018SRAM_strap1_bndry_3v64x8m81_9/w_91_512# 018SRAM_strap1_bndry_3v64x8m81_9/w_91_512#
+ 018SRAM_cell1_2x_3v64x8m81_253/018SRAM_cell1_3v64x8m81_1/a_430_96# VSUBS 018SRAM_cell1_2x_3v64x8m81_253/018SRAM_cell1_3v64x8m81_1/a_110_96#
+ x018SRAM_cell1_2x_3v64x8m81
X018SRAM_cell1_2x_3v64x8m81_272 m3_n1397_247# 018SRAM_strap1_bndry_3v64x8m81_9/w_91_512#
+ m3_n1397_247# VSUBS 018SRAM_strap1_bndry_3v64x8m81_9/w_91_512# m3_n1397_1009# m3_n1397_1009#
+ VSUBS 018SRAM_strap1_bndry_3v64x8m81_9/w_91_512# 018SRAM_strap1_bndry_3v64x8m81_9/w_91_512#
+ 018SRAM_cell1_2x_3v64x8m81_274/018SRAM_cell1_3v64x8m81_1/a_430_96# VSUBS 018SRAM_cell1_2x_3v64x8m81_274/018SRAM_cell1_3v64x8m81_1/a_110_96#
+ x018SRAM_cell1_2x_3v64x8m81
X018SRAM_cell1_2x_3v64x8m81_7 m3_n1397_247# 018SRAM_strap1_bndry_3v64x8m81_9/w_91_512#
+ m3_n1397_247# VSUBS 018SRAM_strap1_bndry_3v64x8m81_9/w_91_512# m3_n1397_1009# m3_n1397_1009#
+ VSUBS 018SRAM_strap1_bndry_3v64x8m81_9/w_91_512# 018SRAM_strap1_bndry_3v64x8m81_9/w_91_512#
+ 018SRAM_cell1_2x_3v64x8m81_9/018SRAM_cell1_3v64x8m81_1/a_430_96# VSUBS 018SRAM_cell1_2x_3v64x8m81_9/018SRAM_cell1_3v64x8m81_1/a_110_96#
+ x018SRAM_cell1_2x_3v64x8m81
X018SRAM_cell1_2x_3v64x8m81_284 m3_n1397_2719# 018SRAM_strap1_bndry_3v64x8m81_9/w_91_512#
+ m3_n1397_2719# VSUBS 018SRAM_strap1_bndry_3v64x8m81_9/w_91_512# m3_n1397_3433# m3_n1397_3433#
+ VSUBS 018SRAM_strap1_bndry_3v64x8m81_9/w_91_512# 018SRAM_strap1_bndry_3v64x8m81_9/w_91_512#
+ 018SRAM_cell1_2x_3v64x8m81_285/018SRAM_cell1_3v64x8m81_1/a_430_96# VSUBS 018SRAM_cell1_2x_3v64x8m81_285/018SRAM_cell1_3v64x8m81_1/a_110_96#
+ x018SRAM_cell1_2x_3v64x8m81
X018SRAM_cell1_2x_3v64x8m81_251 m3_n1397_247# 018SRAM_strap1_bndry_3v64x8m81_9/w_91_512#
+ m3_n1397_247# VSUBS 018SRAM_strap1_bndry_3v64x8m81_9/w_91_512# m3_n1397_1009# m3_n1397_1009#
+ VSUBS 018SRAM_strap1_bndry_3v64x8m81_9/w_91_512# 018SRAM_strap1_bndry_3v64x8m81_9/w_91_512#
+ 018SRAM_cell1_2x_3v64x8m81_253/018SRAM_cell1_3v64x8m81_1/a_430_96# VSUBS 018SRAM_cell1_2x_3v64x8m81_253/018SRAM_cell1_3v64x8m81_1/a_110_96#
+ x018SRAM_cell1_2x_3v64x8m81
X018SRAM_cell1_2x_3v64x8m81_240 m3_n1397_1507# 018SRAM_strap1_bndry_3v64x8m81_9/w_91_512#
+ m3_n1397_1507# VSUBS 018SRAM_strap1_bndry_3v64x8m81_9/w_91_512# m3_n1397_2221# m3_n1397_2221#
+ VSUBS 018SRAM_strap1_bndry_3v64x8m81_9/w_91_512# 018SRAM_strap1_bndry_3v64x8m81_9/w_91_512#
+ 018SRAM_cell1_2x_3v64x8m81_243/018SRAM_cell1_3v64x8m81_1/a_430_96# VSUBS 018SRAM_cell1_2x_3v64x8m81_243/018SRAM_cell1_3v64x8m81_1/a_110_96#
+ x018SRAM_cell1_2x_3v64x8m81
X018SRAM_cell1_2x_3v64x8m81_273 m3_n1397_2719# 018SRAM_strap1_bndry_3v64x8m81_9/w_91_512#
+ m3_n1397_2719# VSUBS 018SRAM_strap1_bndry_3v64x8m81_9/w_91_512# m3_n1397_3433# m3_n1397_3433#
+ VSUBS 018SRAM_strap1_bndry_3v64x8m81_9/w_91_512# 018SRAM_strap1_bndry_3v64x8m81_9/w_91_512#
+ 018SRAM_cell1_2x_3v64x8m81_274/018SRAM_cell1_3v64x8m81_1/a_430_96# VSUBS 018SRAM_cell1_2x_3v64x8m81_274/018SRAM_cell1_3v64x8m81_1/a_110_96#
+ x018SRAM_cell1_2x_3v64x8m81
X018SRAM_cell1_2x_3v64x8m81_8 m3_n1397_1507# 018SRAM_strap1_bndry_3v64x8m81_9/w_91_512#
+ m3_n1397_1507# VSUBS 018SRAM_strap1_bndry_3v64x8m81_9/w_91_512# m3_n1397_2221# m3_n1397_2221#
+ VSUBS 018SRAM_strap1_bndry_3v64x8m81_9/w_91_512# 018SRAM_strap1_bndry_3v64x8m81_9/w_91_512#
+ 018SRAM_cell1_2x_3v64x8m81_8/018SRAM_cell1_3v64x8m81_1/a_430_96# VSUBS 018SRAM_cell1_2x_3v64x8m81_8/018SRAM_cell1_3v64x8m81_1/a_110_96#
+ x018SRAM_cell1_2x_3v64x8m81
X018SRAM_cell1_2x_3v64x8m81_285 m3_n1397_3931# 018SRAM_strap1_bndry_3v64x8m81_9/w_91_512#
+ m3_n1397_3931# VSUBS 018SRAM_strap1_bndry_3v64x8m81_9/w_91_512# m3_n1397_4645# m3_n1397_4645#
+ VSUBS 018SRAM_strap1_bndry_3v64x8m81_9/w_91_512# 018SRAM_strap1_bndry_3v64x8m81_9/w_91_512#
+ 018SRAM_cell1_2x_3v64x8m81_285/018SRAM_cell1_3v64x8m81_1/a_430_96# VSUBS 018SRAM_cell1_2x_3v64x8m81_285/018SRAM_cell1_3v64x8m81_1/a_110_96#
+ x018SRAM_cell1_2x_3v64x8m81
X018SRAM_cell1_2x_3v64x8m81_252 m3_n1397_2719# 018SRAM_strap1_bndry_3v64x8m81_9/w_91_512#
+ m3_n1397_2719# VSUBS 018SRAM_strap1_bndry_3v64x8m81_9/w_91_512# m3_n1397_3433# m3_n1397_3433#
+ VSUBS 018SRAM_strap1_bndry_3v64x8m81_9/w_91_512# 018SRAM_strap1_bndry_3v64x8m81_9/w_91_512#
+ 018SRAM_cell1_2x_3v64x8m81_253/018SRAM_cell1_3v64x8m81_1/a_430_96# VSUBS 018SRAM_cell1_2x_3v64x8m81_253/018SRAM_cell1_3v64x8m81_1/a_110_96#
+ x018SRAM_cell1_2x_3v64x8m81
X018SRAM_cell1_2x_3v64x8m81_241 m3_n1397_247# 018SRAM_strap1_bndry_3v64x8m81_9/w_91_512#
+ m3_n1397_247# VSUBS 018SRAM_strap1_bndry_3v64x8m81_9/w_91_512# m3_n1397_1009# m3_n1397_1009#
+ VSUBS 018SRAM_strap1_bndry_3v64x8m81_9/w_91_512# 018SRAM_strap1_bndry_3v64x8m81_9/w_91_512#
+ 018SRAM_cell1_2x_3v64x8m81_243/018SRAM_cell1_3v64x8m81_1/a_430_96# VSUBS 018SRAM_cell1_2x_3v64x8m81_243/018SRAM_cell1_3v64x8m81_1/a_110_96#
+ x018SRAM_cell1_2x_3v64x8m81
X018SRAM_cell1_2x_3v64x8m81_274 m3_n1397_3931# 018SRAM_strap1_bndry_3v64x8m81_9/w_91_512#
+ m3_n1397_3931# VSUBS 018SRAM_strap1_bndry_3v64x8m81_9/w_91_512# m3_n1397_4645# m3_n1397_4645#
+ VSUBS 018SRAM_strap1_bndry_3v64x8m81_9/w_91_512# 018SRAM_strap1_bndry_3v64x8m81_9/w_91_512#
+ 018SRAM_cell1_2x_3v64x8m81_274/018SRAM_cell1_3v64x8m81_1/a_430_96# VSUBS 018SRAM_cell1_2x_3v64x8m81_274/018SRAM_cell1_3v64x8m81_1/a_110_96#
+ x018SRAM_cell1_2x_3v64x8m81
X018SRAM_cell1_2x_3v64x8m81_9 m3_n1397_1507# 018SRAM_strap1_bndry_3v64x8m81_9/w_91_512#
+ m3_n1397_1507# VSUBS 018SRAM_strap1_bndry_3v64x8m81_9/w_91_512# m3_n1397_2221# m3_n1397_2221#
+ VSUBS 018SRAM_strap1_bndry_3v64x8m81_9/w_91_512# 018SRAM_strap1_bndry_3v64x8m81_9/w_91_512#
+ 018SRAM_cell1_2x_3v64x8m81_9/018SRAM_cell1_3v64x8m81_1/a_430_96# VSUBS 018SRAM_cell1_2x_3v64x8m81_9/018SRAM_cell1_3v64x8m81_1/a_110_96#
+ x018SRAM_cell1_2x_3v64x8m81
X018SRAM_cell1_2x_3v64x8m81_297 m3_n1397_247# 018SRAM_strap1_bndry_3v64x8m81_9/w_91_512#
+ m3_n1397_247# VSUBS 018SRAM_strap1_bndry_3v64x8m81_9/w_91_512# m3_n1397_1009# m3_n1397_1009#
+ VSUBS 018SRAM_strap1_bndry_3v64x8m81_9/w_91_512# 018SRAM_strap1_bndry_3v64x8m81_9/w_91_512#
+ 018SRAM_cell1_2x_3v64x8m81_346/018SRAM_cell1_3v64x8m81_1/a_430_96# VSUBS 018SRAM_cell1_2x_3v64x8m81_346/018SRAM_cell1_3v64x8m81_1/a_110_96#
+ x018SRAM_cell1_2x_3v64x8m81
X018SRAM_cell1_2x_3v64x8m81_253 m3_n1397_3931# 018SRAM_strap1_bndry_3v64x8m81_9/w_91_512#
+ m3_n1397_3931# VSUBS 018SRAM_strap1_bndry_3v64x8m81_9/w_91_512# m3_n1397_4645# m3_n1397_4645#
+ VSUBS 018SRAM_strap1_bndry_3v64x8m81_9/w_91_512# 018SRAM_strap1_bndry_3v64x8m81_9/w_91_512#
+ 018SRAM_cell1_2x_3v64x8m81_253/018SRAM_cell1_3v64x8m81_1/a_430_96# VSUBS 018SRAM_cell1_2x_3v64x8m81_253/018SRAM_cell1_3v64x8m81_1/a_110_96#
+ x018SRAM_cell1_2x_3v64x8m81
X018SRAM_cell1_2x_3v64x8m81_275 m3_n1397_1507# 018SRAM_strap1_bndry_3v64x8m81_9/w_91_512#
+ m3_n1397_1507# VSUBS 018SRAM_strap1_bndry_3v64x8m81_9/w_91_512# m3_n1397_2221# m3_n1397_2221#
+ VSUBS 018SRAM_strap1_bndry_3v64x8m81_9/w_91_512# 018SRAM_strap1_bndry_3v64x8m81_9/w_91_512#
+ 018SRAM_cell1_2x_3v64x8m81_292/018SRAM_cell1_3v64x8m81_1/a_430_96# VSUBS 018SRAM_cell1_2x_3v64x8m81_292/018SRAM_cell1_3v64x8m81_1/a_110_96#
+ x018SRAM_cell1_2x_3v64x8m81
X018SRAM_cell1_2x_3v64x8m81_242 m3_n1397_2719# 018SRAM_strap1_bndry_3v64x8m81_9/w_91_512#
+ m3_n1397_2719# VSUBS 018SRAM_strap1_bndry_3v64x8m81_9/w_91_512# m3_n1397_3433# m3_n1397_3433#
+ VSUBS 018SRAM_strap1_bndry_3v64x8m81_9/w_91_512# 018SRAM_strap1_bndry_3v64x8m81_9/w_91_512#
+ 018SRAM_cell1_2x_3v64x8m81_243/018SRAM_cell1_3v64x8m81_1/a_430_96# VSUBS 018SRAM_cell1_2x_3v64x8m81_243/018SRAM_cell1_3v64x8m81_1/a_110_96#
+ x018SRAM_cell1_2x_3v64x8m81
X018SRAM_cell1_2x_3v64x8m81_264 m3_n1397_3931# 018SRAM_strap1_bndry_3v64x8m81_9/w_91_512#
+ m3_n1397_3931# VSUBS 018SRAM_strap1_bndry_3v64x8m81_9/w_91_512# m3_n1397_4645# m3_n1397_4645#
+ VSUBS 018SRAM_strap1_bndry_3v64x8m81_9/w_91_512# 018SRAM_strap1_bndry_3v64x8m81_9/w_91_512#
+ 018SRAM_cell1_2x_3v64x8m81_264/018SRAM_cell1_3v64x8m81_1/a_430_96# VSUBS 018SRAM_cell1_2x_3v64x8m81_264/018SRAM_cell1_3v64x8m81_1/a_110_96#
+ x018SRAM_cell1_2x_3v64x8m81
X018SRAM_cell1_2x_3v64x8m81_298 m3_n1397_2719# 018SRAM_strap1_bndry_3v64x8m81_9/w_91_512#
+ m3_n1397_2719# VSUBS 018SRAM_strap1_bndry_3v64x8m81_9/w_91_512# m3_n1397_3433# m3_n1397_3433#
+ VSUBS 018SRAM_strap1_bndry_3v64x8m81_9/w_91_512# 018SRAM_strap1_bndry_3v64x8m81_9/w_91_512#
+ 018SRAM_cell1_2x_3v64x8m81_346/018SRAM_cell1_3v64x8m81_1/a_430_96# VSUBS 018SRAM_cell1_2x_3v64x8m81_346/018SRAM_cell1_3v64x8m81_1/a_110_96#
+ x018SRAM_cell1_2x_3v64x8m81
X018SRAM_cell1_2x_3v64x8m81_276 m3_n1397_247# 018SRAM_strap1_bndry_3v64x8m81_9/w_91_512#
+ m3_n1397_247# VSUBS 018SRAM_strap1_bndry_3v64x8m81_9/w_91_512# m3_n1397_1009# m3_n1397_1009#
+ VSUBS 018SRAM_strap1_bndry_3v64x8m81_9/w_91_512# 018SRAM_strap1_bndry_3v64x8m81_9/w_91_512#
+ 018SRAM_cell1_2x_3v64x8m81_292/018SRAM_cell1_3v64x8m81_1/a_430_96# VSUBS 018SRAM_cell1_2x_3v64x8m81_292/018SRAM_cell1_3v64x8m81_1/a_110_96#
+ x018SRAM_cell1_2x_3v64x8m81
X018SRAM_cell1_2x_3v64x8m81_243 m3_n1397_3931# 018SRAM_strap1_bndry_3v64x8m81_9/w_91_512#
+ m3_n1397_3931# VSUBS 018SRAM_strap1_bndry_3v64x8m81_9/w_91_512# m3_n1397_4645# m3_n1397_4645#
+ VSUBS 018SRAM_strap1_bndry_3v64x8m81_9/w_91_512# 018SRAM_strap1_bndry_3v64x8m81_9/w_91_512#
+ 018SRAM_cell1_2x_3v64x8m81_243/018SRAM_cell1_3v64x8m81_1/a_430_96# VSUBS 018SRAM_cell1_2x_3v64x8m81_243/018SRAM_cell1_3v64x8m81_1/a_110_96#
+ x018SRAM_cell1_2x_3v64x8m81
X018SRAM_cell1_2x_3v64x8m81_70 m3_n1397_3931# 018SRAM_strap1_bndry_3v64x8m81_9/w_91_512#
+ m3_n1397_3931# VSUBS 018SRAM_strap1_bndry_3v64x8m81_9/w_91_512# m3_n1397_4645# m3_n1397_4645#
+ VSUBS 018SRAM_strap1_bndry_3v64x8m81_9/w_91_512# 018SRAM_strap1_bndry_3v64x8m81_9/w_91_512#
+ 018SRAM_cell1_2x_3v64x8m81_70/018SRAM_cell1_3v64x8m81_1/a_430_96# VSUBS 018SRAM_cell1_2x_3v64x8m81_70/018SRAM_cell1_3v64x8m81_1/a_110_96#
+ x018SRAM_cell1_2x_3v64x8m81
X018SRAM_cell1_2x_3v64x8m81_299 m3_n1397_3931# 018SRAM_strap1_bndry_3v64x8m81_9/w_91_512#
+ m3_n1397_3931# VSUBS 018SRAM_strap1_bndry_3v64x8m81_9/w_91_512# m3_n1397_4645# m3_n1397_4645#
+ VSUBS 018SRAM_strap1_bndry_3v64x8m81_9/w_91_512# 018SRAM_strap1_bndry_3v64x8m81_9/w_91_512#
+ 018SRAM_cell1_2x_3v64x8m81_346/018SRAM_cell1_3v64x8m81_1/a_430_96# VSUBS 018SRAM_cell1_2x_3v64x8m81_346/018SRAM_cell1_3v64x8m81_1/a_110_96#
+ x018SRAM_cell1_2x_3v64x8m81
X018SRAM_cell1_2x_3v64x8m81_277 m3_n1397_2719# 018SRAM_strap1_bndry_3v64x8m81_9/w_91_512#
+ m3_n1397_2719# VSUBS 018SRAM_strap1_bndry_3v64x8m81_9/w_91_512# m3_n1397_3433# m3_n1397_3433#
+ VSUBS 018SRAM_strap1_bndry_3v64x8m81_9/w_91_512# 018SRAM_strap1_bndry_3v64x8m81_9/w_91_512#
+ 018SRAM_cell1_2x_3v64x8m81_292/018SRAM_cell1_3v64x8m81_1/a_430_96# VSUBS 018SRAM_cell1_2x_3v64x8m81_292/018SRAM_cell1_3v64x8m81_1/a_110_96#
+ x018SRAM_cell1_2x_3v64x8m81
X018SRAM_cell1_2x_3v64x8m81_93 m3_n1397_1507# 018SRAM_strap1_bndry_3v64x8m81_9/w_91_512#
+ m3_n1397_1507# VSUBS 018SRAM_strap1_bndry_3v64x8m81_9/w_91_512# m3_n1397_2221# m3_n1397_2221#
+ VSUBS 018SRAM_strap1_bndry_3v64x8m81_9/w_91_512# 018SRAM_strap1_bndry_3v64x8m81_9/w_91_512#
+ 018SRAM_cell1_2x_3v64x8m81_96/018SRAM_cell1_3v64x8m81_1/a_430_96# VSUBS 018SRAM_cell1_2x_3v64x8m81_96/018SRAM_cell1_3v64x8m81_1/a_110_96#
+ x018SRAM_cell1_2x_3v64x8m81
X018SRAM_cell1_2x_3v64x8m81_278 m3_n1397_1507# 018SRAM_strap1_bndry_3v64x8m81_9/w_91_512#
+ m3_n1397_1507# VSUBS 018SRAM_strap1_bndry_3v64x8m81_9/w_91_512# m3_n1397_2221# m3_n1397_2221#
+ VSUBS 018SRAM_strap1_bndry_3v64x8m81_9/w_91_512# 018SRAM_strap1_bndry_3v64x8m81_9/w_91_512#
+ 018SRAM_cell1_2x_3v64x8m81_281/018SRAM_cell1_3v64x8m81_1/a_430_96# VSUBS 018SRAM_cell1_2x_3v64x8m81_281/018SRAM_cell1_3v64x8m81_1/a_110_96#
+ x018SRAM_cell1_2x_3v64x8m81
X018SRAM_cell1_2x_3v64x8m81_50 m3_n1397_3931# 018SRAM_strap1_bndry_3v64x8m81_9/w_91_512#
+ m3_n1397_3931# VSUBS 018SRAM_strap1_bndry_3v64x8m81_9/w_91_512# m3_n1397_4645# m3_n1397_4645#
+ VSUBS 018SRAM_strap1_bndry_3v64x8m81_9/w_91_512# 018SRAM_strap1_bndry_3v64x8m81_9/w_91_512#
+ 018SRAM_cell1_2x_3v64x8m81_6/018SRAM_cell1_3v64x8m81_1/a_430_96# VSUBS 018SRAM_cell1_2x_3v64x8m81_6/018SRAM_cell1_3v64x8m81_1/a_110_96#
+ x018SRAM_cell1_2x_3v64x8m81
X018SRAM_cell1_2x_3v64x8m81_94 m3_n1397_247# 018SRAM_strap1_bndry_3v64x8m81_9/w_91_512#
+ m3_n1397_247# VSUBS 018SRAM_strap1_bndry_3v64x8m81_9/w_91_512# m3_n1397_1009# m3_n1397_1009#
+ VSUBS 018SRAM_strap1_bndry_3v64x8m81_9/w_91_512# 018SRAM_strap1_bndry_3v64x8m81_9/w_91_512#
+ 018SRAM_cell1_2x_3v64x8m81_96/018SRAM_cell1_3v64x8m81_1/a_430_96# VSUBS 018SRAM_cell1_2x_3v64x8m81_96/018SRAM_cell1_3v64x8m81_1/a_110_96#
+ x018SRAM_cell1_2x_3v64x8m81
X018SRAM_cell1_2x_3v64x8m81_72 m3_n1397_2719# 018SRAM_strap1_bndry_3v64x8m81_9/w_91_512#
+ m3_n1397_2719# VSUBS 018SRAM_strap1_bndry_3v64x8m81_9/w_91_512# m3_n1397_3433# m3_n1397_3433#
+ VSUBS 018SRAM_strap1_bndry_3v64x8m81_9/w_91_512# 018SRAM_strap1_bndry_3v64x8m81_9/w_91_512#
+ 018SRAM_cell1_2x_3v64x8m81_73/018SRAM_cell1_3v64x8m81_1/a_430_96# VSUBS 018SRAM_cell1_2x_3v64x8m81_73/018SRAM_cell1_3v64x8m81_1/a_110_96#
+ x018SRAM_cell1_2x_3v64x8m81
X018SRAM_cell1_2x_3v64x8m81_257 m3_n1397_1507# 018SRAM_strap1_bndry_3v64x8m81_9/w_91_512#
+ m3_n1397_1507# VSUBS 018SRAM_strap1_bndry_3v64x8m81_9/w_91_512# m3_n1397_2221# m3_n1397_2221#
+ VSUBS 018SRAM_strap1_bndry_3v64x8m81_9/w_91_512# 018SRAM_strap1_bndry_3v64x8m81_9/w_91_512#
+ 018SRAM_cell1_2x_3v64x8m81_260/018SRAM_cell1_3v64x8m81_1/a_430_96# VSUBS 018SRAM_cell1_2x_3v64x8m81_260/018SRAM_cell1_3v64x8m81_1/a_110_96#
+ x018SRAM_cell1_2x_3v64x8m81
X018SRAM_cell1_2x_3v64x8m81_279 m3_n1397_247# 018SRAM_strap1_bndry_3v64x8m81_9/w_91_512#
+ m3_n1397_247# VSUBS 018SRAM_strap1_bndry_3v64x8m81_9/w_91_512# m3_n1397_1009# m3_n1397_1009#
+ VSUBS 018SRAM_strap1_bndry_3v64x8m81_9/w_91_512# 018SRAM_strap1_bndry_3v64x8m81_9/w_91_512#
+ 018SRAM_cell1_2x_3v64x8m81_281/018SRAM_cell1_3v64x8m81_1/a_430_96# VSUBS 018SRAM_cell1_2x_3v64x8m81_281/018SRAM_cell1_3v64x8m81_1/a_110_96#
+ x018SRAM_cell1_2x_3v64x8m81
X018SRAM_cell1_2x_3v64x8m81_40 m3_n1397_1507# 018SRAM_strap1_bndry_3v64x8m81_9/w_91_512#
+ m3_n1397_1507# VSUBS 018SRAM_strap1_bndry_3v64x8m81_9/w_91_512# m3_n1397_2221# m3_n1397_2221#
+ VSUBS 018SRAM_strap1_bndry_3v64x8m81_9/w_91_512# 018SRAM_strap1_bndry_3v64x8m81_9/w_91_512#
+ 018SRAM_cell1_2x_3v64x8m81_43/018SRAM_cell1_3v64x8m81_1/a_430_96# VSUBS 018SRAM_cell1_2x_3v64x8m81_43/018SRAM_cell1_3v64x8m81_1/a_110_96#
+ x018SRAM_cell1_2x_3v64x8m81
X018SRAM_cell1_2x_3v64x8m81_51 m3_n1397_1507# 018SRAM_strap1_bndry_3v64x8m81_9/w_91_512#
+ m3_n1397_1507# VSUBS 018SRAM_strap1_bndry_3v64x8m81_9/w_91_512# m3_n1397_2221# m3_n1397_2221#
+ VSUBS 018SRAM_strap1_bndry_3v64x8m81_9/w_91_512# 018SRAM_strap1_bndry_3v64x8m81_9/w_91_512#
+ 018SRAM_cell1_2x_3v64x8m81_54/018SRAM_cell1_3v64x8m81_1/a_430_96# VSUBS 018SRAM_cell1_2x_3v64x8m81_54/018SRAM_cell1_3v64x8m81_1/a_110_96#
+ x018SRAM_cell1_2x_3v64x8m81
X018SRAM_cell1_2x_3v64x8m81_95 m3_n1397_2719# 018SRAM_strap1_bndry_3v64x8m81_9/w_91_512#
+ m3_n1397_2719# VSUBS 018SRAM_strap1_bndry_3v64x8m81_9/w_91_512# m3_n1397_3433# m3_n1397_3433#
+ VSUBS 018SRAM_strap1_bndry_3v64x8m81_9/w_91_512# 018SRAM_strap1_bndry_3v64x8m81_9/w_91_512#
+ 018SRAM_cell1_2x_3v64x8m81_96/018SRAM_cell1_3v64x8m81_1/a_430_96# VSUBS 018SRAM_cell1_2x_3v64x8m81_96/018SRAM_cell1_3v64x8m81_1/a_110_96#
+ x018SRAM_cell1_2x_3v64x8m81
X018SRAM_cell1_2x_3v64x8m81_73 m3_n1397_3931# 018SRAM_strap1_bndry_3v64x8m81_9/w_91_512#
+ m3_n1397_3931# VSUBS 018SRAM_strap1_bndry_3v64x8m81_9/w_91_512# m3_n1397_4645# m3_n1397_4645#
+ VSUBS 018SRAM_strap1_bndry_3v64x8m81_9/w_91_512# 018SRAM_strap1_bndry_3v64x8m81_9/w_91_512#
+ 018SRAM_cell1_2x_3v64x8m81_73/018SRAM_cell1_3v64x8m81_1/a_430_96# VSUBS 018SRAM_cell1_2x_3v64x8m81_73/018SRAM_cell1_3v64x8m81_1/a_110_96#
+ x018SRAM_cell1_2x_3v64x8m81
X018SRAM_cell1_2x_3v64x8m81_84 m3_n1397_1507# 018SRAM_strap1_bndry_3v64x8m81_9/w_91_512#
+ m3_n1397_1507# VSUBS 018SRAM_strap1_bndry_3v64x8m81_9/w_91_512# m3_n1397_2221# m3_n1397_2221#
+ VSUBS 018SRAM_strap1_bndry_3v64x8m81_9/w_91_512# 018SRAM_strap1_bndry_3v64x8m81_9/w_91_512#
+ 018SRAM_cell1_2x_3v64x8m81_87/018SRAM_cell1_3v64x8m81_1/a_430_96# VSUBS 018SRAM_cell1_2x_3v64x8m81_87/018SRAM_cell1_3v64x8m81_1/a_110_96#
+ x018SRAM_cell1_2x_3v64x8m81
X018SRAM_cell1_2x_3v64x8m81_258 m3_n1397_247# 018SRAM_strap1_bndry_3v64x8m81_9/w_91_512#
+ m3_n1397_247# VSUBS 018SRAM_strap1_bndry_3v64x8m81_9/w_91_512# m3_n1397_1009# m3_n1397_1009#
+ VSUBS 018SRAM_strap1_bndry_3v64x8m81_9/w_91_512# 018SRAM_strap1_bndry_3v64x8m81_9/w_91_512#
+ 018SRAM_cell1_2x_3v64x8m81_260/018SRAM_cell1_3v64x8m81_1/a_430_96# VSUBS 018SRAM_cell1_2x_3v64x8m81_260/018SRAM_cell1_3v64x8m81_1/a_110_96#
+ x018SRAM_cell1_2x_3v64x8m81
X018SRAM_cell1_2x_3v64x8m81_247 m3_n1397_1507# 018SRAM_strap1_bndry_3v64x8m81_9/w_91_512#
+ m3_n1397_1507# VSUBS 018SRAM_strap1_bndry_3v64x8m81_9/w_91_512# m3_n1397_2221# m3_n1397_2221#
+ VSUBS 018SRAM_strap1_bndry_3v64x8m81_9/w_91_512# 018SRAM_strap1_bndry_3v64x8m81_9/w_91_512#
+ 018SRAM_cell1_2x_3v64x8m81_264/018SRAM_cell1_3v64x8m81_1/a_430_96# VSUBS 018SRAM_cell1_2x_3v64x8m81_264/018SRAM_cell1_3v64x8m81_1/a_110_96#
+ x018SRAM_cell1_2x_3v64x8m81
X018SRAM_cell1_2x_3v64x8m81_41 m3_n1397_247# 018SRAM_strap1_bndry_3v64x8m81_9/w_91_512#
+ m3_n1397_247# VSUBS 018SRAM_strap1_bndry_3v64x8m81_9/w_91_512# m3_n1397_1009# m3_n1397_1009#
+ VSUBS 018SRAM_strap1_bndry_3v64x8m81_9/w_91_512# 018SRAM_strap1_bndry_3v64x8m81_9/w_91_512#
+ 018SRAM_cell1_2x_3v64x8m81_43/018SRAM_cell1_3v64x8m81_1/a_430_96# VSUBS 018SRAM_cell1_2x_3v64x8m81_43/018SRAM_cell1_3v64x8m81_1/a_110_96#
+ x018SRAM_cell1_2x_3v64x8m81
X018SRAM_cell1_2x_3v64x8m81_52 m3_n1397_247# 018SRAM_strap1_bndry_3v64x8m81_9/w_91_512#
+ m3_n1397_247# VSUBS 018SRAM_strap1_bndry_3v64x8m81_9/w_91_512# m3_n1397_1009# m3_n1397_1009#
+ VSUBS 018SRAM_strap1_bndry_3v64x8m81_9/w_91_512# 018SRAM_strap1_bndry_3v64x8m81_9/w_91_512#
+ 018SRAM_cell1_2x_3v64x8m81_54/018SRAM_cell1_3v64x8m81_1/a_430_96# VSUBS 018SRAM_cell1_2x_3v64x8m81_54/018SRAM_cell1_3v64x8m81_1/a_110_96#
+ x018SRAM_cell1_2x_3v64x8m81
X018SRAM_cell1_2x_3v64x8m81_96 m3_n1397_3931# 018SRAM_strap1_bndry_3v64x8m81_9/w_91_512#
+ m3_n1397_3931# VSUBS 018SRAM_strap1_bndry_3v64x8m81_9/w_91_512# m3_n1397_4645# m3_n1397_4645#
+ VSUBS 018SRAM_strap1_bndry_3v64x8m81_9/w_91_512# 018SRAM_strap1_bndry_3v64x8m81_9/w_91_512#
+ 018SRAM_cell1_2x_3v64x8m81_96/018SRAM_cell1_3v64x8m81_1/a_430_96# VSUBS 018SRAM_cell1_2x_3v64x8m81_96/018SRAM_cell1_3v64x8m81_1/a_110_96#
+ x018SRAM_cell1_2x_3v64x8m81
X018SRAM_cell1_2x_3v64x8m81_85 m3_n1397_247# 018SRAM_strap1_bndry_3v64x8m81_9/w_91_512#
+ m3_n1397_247# VSUBS 018SRAM_strap1_bndry_3v64x8m81_9/w_91_512# m3_n1397_1009# m3_n1397_1009#
+ VSUBS 018SRAM_strap1_bndry_3v64x8m81_9/w_91_512# 018SRAM_strap1_bndry_3v64x8m81_9/w_91_512#
+ 018SRAM_cell1_2x_3v64x8m81_87/018SRAM_cell1_3v64x8m81_1/a_430_96# VSUBS 018SRAM_cell1_2x_3v64x8m81_87/018SRAM_cell1_3v64x8m81_1/a_110_96#
+ x018SRAM_cell1_2x_3v64x8m81
X018SRAM_cell1_2x_3v64x8m81_259 m3_n1397_2719# 018SRAM_strap1_bndry_3v64x8m81_9/w_91_512#
+ m3_n1397_2719# VSUBS 018SRAM_strap1_bndry_3v64x8m81_9/w_91_512# m3_n1397_3433# m3_n1397_3433#
+ VSUBS 018SRAM_strap1_bndry_3v64x8m81_9/w_91_512# 018SRAM_strap1_bndry_3v64x8m81_9/w_91_512#
+ 018SRAM_cell1_2x_3v64x8m81_260/018SRAM_cell1_3v64x8m81_1/a_430_96# VSUBS 018SRAM_cell1_2x_3v64x8m81_260/018SRAM_cell1_3v64x8m81_1/a_110_96#
+ x018SRAM_cell1_2x_3v64x8m81
X018SRAM_cell1_2x_3v64x8m81_248 m3_n1397_247# 018SRAM_strap1_bndry_3v64x8m81_9/w_91_512#
+ m3_n1397_247# VSUBS 018SRAM_strap1_bndry_3v64x8m81_9/w_91_512# m3_n1397_1009# m3_n1397_1009#
+ VSUBS 018SRAM_strap1_bndry_3v64x8m81_9/w_91_512# 018SRAM_strap1_bndry_3v64x8m81_9/w_91_512#
+ 018SRAM_cell1_2x_3v64x8m81_264/018SRAM_cell1_3v64x8m81_1/a_430_96# VSUBS 018SRAM_cell1_2x_3v64x8m81_264/018SRAM_cell1_3v64x8m81_1/a_110_96#
+ x018SRAM_cell1_2x_3v64x8m81
X018SRAM_cell1_2x_3v64x8m81_42 m3_n1397_2719# 018SRAM_strap1_bndry_3v64x8m81_9/w_91_512#
+ m3_n1397_2719# VSUBS 018SRAM_strap1_bndry_3v64x8m81_9/w_91_512# m3_n1397_3433# m3_n1397_3433#
+ VSUBS 018SRAM_strap1_bndry_3v64x8m81_9/w_91_512# 018SRAM_strap1_bndry_3v64x8m81_9/w_91_512#
+ 018SRAM_cell1_2x_3v64x8m81_43/018SRAM_cell1_3v64x8m81_1/a_430_96# VSUBS 018SRAM_cell1_2x_3v64x8m81_43/018SRAM_cell1_3v64x8m81_1/a_110_96#
+ x018SRAM_cell1_2x_3v64x8m81
X018SRAM_cell1_2x_3v64x8m81_53 m3_n1397_2719# 018SRAM_strap1_bndry_3v64x8m81_9/w_91_512#
+ m3_n1397_2719# VSUBS 018SRAM_strap1_bndry_3v64x8m81_9/w_91_512# m3_n1397_3433# m3_n1397_3433#
+ VSUBS 018SRAM_strap1_bndry_3v64x8m81_9/w_91_512# 018SRAM_strap1_bndry_3v64x8m81_9/w_91_512#
+ 018SRAM_cell1_2x_3v64x8m81_54/018SRAM_cell1_3v64x8m81_1/a_430_96# VSUBS 018SRAM_cell1_2x_3v64x8m81_54/018SRAM_cell1_3v64x8m81_1/a_110_96#
+ x018SRAM_cell1_2x_3v64x8m81
X018SRAM_cell1_2x_3v64x8m81_20 m3_n1397_3931# 018SRAM_strap1_bndry_3v64x8m81_9/w_91_512#
+ m3_n1397_3931# VSUBS 018SRAM_strap1_bndry_3v64x8m81_9/w_91_512# m3_n1397_4645# m3_n1397_4645#
+ VSUBS 018SRAM_strap1_bndry_3v64x8m81_9/w_91_512# 018SRAM_strap1_bndry_3v64x8m81_9/w_91_512#
+ 018SRAM_cell1_2x_3v64x8m81_20/018SRAM_cell1_3v64x8m81_1/a_430_96# VSUBS 018SRAM_cell1_2x_3v64x8m81_20/018SRAM_cell1_3v64x8m81_1/a_110_96#
+ x018SRAM_cell1_2x_3v64x8m81
X018SRAM_cell1_2x_3v64x8m81_86 m3_n1397_2719# 018SRAM_strap1_bndry_3v64x8m81_9/w_91_512#
+ m3_n1397_2719# VSUBS 018SRAM_strap1_bndry_3v64x8m81_9/w_91_512# m3_n1397_3433# m3_n1397_3433#
+ VSUBS 018SRAM_strap1_bndry_3v64x8m81_9/w_91_512# 018SRAM_strap1_bndry_3v64x8m81_9/w_91_512#
+ 018SRAM_cell1_2x_3v64x8m81_87/018SRAM_cell1_3v64x8m81_1/a_430_96# VSUBS 018SRAM_cell1_2x_3v64x8m81_87/018SRAM_cell1_3v64x8m81_1/a_110_96#
+ x018SRAM_cell1_2x_3v64x8m81
X018SRAM_cell1_2x_3v64x8m81_249 m3_n1397_2719# 018SRAM_strap1_bndry_3v64x8m81_9/w_91_512#
+ m3_n1397_2719# VSUBS 018SRAM_strap1_bndry_3v64x8m81_9/w_91_512# m3_n1397_3433# m3_n1397_3433#
+ VSUBS 018SRAM_strap1_bndry_3v64x8m81_9/w_91_512# 018SRAM_strap1_bndry_3v64x8m81_9/w_91_512#
+ 018SRAM_cell1_2x_3v64x8m81_264/018SRAM_cell1_3v64x8m81_1/a_430_96# VSUBS 018SRAM_cell1_2x_3v64x8m81_264/018SRAM_cell1_3v64x8m81_1/a_110_96#
+ x018SRAM_cell1_2x_3v64x8m81
X018SRAM_cell1_2x_3v64x8m81_43 m3_n1397_3931# 018SRAM_strap1_bndry_3v64x8m81_9/w_91_512#
+ m3_n1397_3931# VSUBS 018SRAM_strap1_bndry_3v64x8m81_9/w_91_512# m3_n1397_4645# m3_n1397_4645#
+ VSUBS 018SRAM_strap1_bndry_3v64x8m81_9/w_91_512# 018SRAM_strap1_bndry_3v64x8m81_9/w_91_512#
+ 018SRAM_cell1_2x_3v64x8m81_43/018SRAM_cell1_3v64x8m81_1/a_430_96# VSUBS 018SRAM_cell1_2x_3v64x8m81_43/018SRAM_cell1_3v64x8m81_1/a_110_96#
+ x018SRAM_cell1_2x_3v64x8m81
X018SRAM_cell1_2x_3v64x8m81_10 m3_n1397_247# 018SRAM_strap1_bndry_3v64x8m81_9/w_91_512#
+ m3_n1397_247# VSUBS 018SRAM_strap1_bndry_3v64x8m81_9/w_91_512# m3_n1397_1009# m3_n1397_1009#
+ VSUBS 018SRAM_strap1_bndry_3v64x8m81_9/w_91_512# 018SRAM_strap1_bndry_3v64x8m81_9/w_91_512#
+ 018SRAM_cell1_2x_3v64x8m81_8/018SRAM_cell1_3v64x8m81_1/a_430_96# VSUBS 018SRAM_cell1_2x_3v64x8m81_8/018SRAM_cell1_3v64x8m81_1/a_110_96#
+ x018SRAM_cell1_2x_3v64x8m81
X018SRAM_cell1_2x_3v64x8m81_54 m3_n1397_3931# 018SRAM_strap1_bndry_3v64x8m81_9/w_91_512#
+ m3_n1397_3931# VSUBS 018SRAM_strap1_bndry_3v64x8m81_9/w_91_512# m3_n1397_4645# m3_n1397_4645#
+ VSUBS 018SRAM_strap1_bndry_3v64x8m81_9/w_91_512# 018SRAM_strap1_bndry_3v64x8m81_9/w_91_512#
+ 018SRAM_cell1_2x_3v64x8m81_54/018SRAM_cell1_3v64x8m81_1/a_430_96# VSUBS 018SRAM_cell1_2x_3v64x8m81_54/018SRAM_cell1_3v64x8m81_1/a_110_96#
+ x018SRAM_cell1_2x_3v64x8m81
X018SRAM_cell1_2x_3v64x8m81_76 m3_n1397_247# 018SRAM_strap1_bndry_3v64x8m81_9/w_91_512#
+ m3_n1397_247# VSUBS 018SRAM_strap1_bndry_3v64x8m81_9/w_91_512# m3_n1397_1009# m3_n1397_1009#
+ VSUBS 018SRAM_strap1_bndry_3v64x8m81_9/w_91_512# 018SRAM_strap1_bndry_3v64x8m81_9/w_91_512#
+ 018SRAM_cell1_2x_3v64x8m81_78/018SRAM_cell1_3v64x8m81_1/a_430_96# VSUBS 018SRAM_cell1_2x_3v64x8m81_78/018SRAM_cell1_3v64x8m81_1/a_110_96#
+ x018SRAM_cell1_2x_3v64x8m81
X018SRAM_cell1_2x_3v64x8m81_87 m3_n1397_3931# 018SRAM_strap1_bndry_3v64x8m81_9/w_91_512#
+ m3_n1397_3931# VSUBS 018SRAM_strap1_bndry_3v64x8m81_9/w_91_512# m3_n1397_4645# m3_n1397_4645#
+ VSUBS 018SRAM_strap1_bndry_3v64x8m81_9/w_91_512# 018SRAM_strap1_bndry_3v64x8m81_9/w_91_512#
+ 018SRAM_cell1_2x_3v64x8m81_87/018SRAM_cell1_3v64x8m81_1/a_430_96# VSUBS 018SRAM_cell1_2x_3v64x8m81_87/018SRAM_cell1_3v64x8m81_1/a_110_96#
+ x018SRAM_cell1_2x_3v64x8m81
X018SRAM_cell1_2x_3v64x8m81_11 m3_n1397_2719# 018SRAM_strap1_bndry_3v64x8m81_9/w_91_512#
+ m3_n1397_2719# VSUBS 018SRAM_strap1_bndry_3v64x8m81_9/w_91_512# m3_n1397_3433# m3_n1397_3433#
+ VSUBS 018SRAM_strap1_bndry_3v64x8m81_9/w_91_512# 018SRAM_strap1_bndry_3v64x8m81_9/w_91_512#
+ 018SRAM_cell1_2x_3v64x8m81_8/018SRAM_cell1_3v64x8m81_1/a_430_96# VSUBS 018SRAM_cell1_2x_3v64x8m81_8/018SRAM_cell1_3v64x8m81_1/a_110_96#
+ x018SRAM_cell1_2x_3v64x8m81
X018SRAM_cell1_2x_3v64x8m81_77 m3_n1397_2719# 018SRAM_strap1_bndry_3v64x8m81_9/w_91_512#
+ m3_n1397_2719# VSUBS 018SRAM_strap1_bndry_3v64x8m81_9/w_91_512# m3_n1397_3433# m3_n1397_3433#
+ VSUBS 018SRAM_strap1_bndry_3v64x8m81_9/w_91_512# 018SRAM_strap1_bndry_3v64x8m81_9/w_91_512#
+ 018SRAM_cell1_2x_3v64x8m81_78/018SRAM_cell1_3v64x8m81_1/a_430_96# VSUBS 018SRAM_cell1_2x_3v64x8m81_78/018SRAM_cell1_3v64x8m81_1/a_110_96#
+ x018SRAM_cell1_2x_3v64x8m81
X018SRAM_cell1_2x_3v64x8m81_66 m3_n1397_1507# 018SRAM_strap1_bndry_3v64x8m81_9/w_91_512#
+ m3_n1397_1507# VSUBS 018SRAM_strap1_bndry_3v64x8m81_9/w_91_512# m3_n1397_2221# m3_n1397_2221#
+ VSUBS 018SRAM_strap1_bndry_3v64x8m81_9/w_91_512# 018SRAM_strap1_bndry_3v64x8m81_9/w_91_512#
+ 018SRAM_cell1_2x_3v64x8m81_70/018SRAM_cell1_3v64x8m81_1/a_430_96# VSUBS 018SRAM_cell1_2x_3v64x8m81_70/018SRAM_cell1_3v64x8m81_1/a_110_96#
+ x018SRAM_cell1_2x_3v64x8m81
X018SRAM_cell1_2x_3v64x8m81_12 m3_n1397_3931# 018SRAM_strap1_bndry_3v64x8m81_9/w_91_512#
+ m3_n1397_3931# VSUBS 018SRAM_strap1_bndry_3v64x8m81_9/w_91_512# m3_n1397_4645# m3_n1397_4645#
+ VSUBS 018SRAM_strap1_bndry_3v64x8m81_9/w_91_512# 018SRAM_strap1_bndry_3v64x8m81_9/w_91_512#
+ 018SRAM_cell1_2x_3v64x8m81_8/018SRAM_cell1_3v64x8m81_1/a_430_96# VSUBS 018SRAM_cell1_2x_3v64x8m81_8/018SRAM_cell1_3v64x8m81_1/a_110_96#
+ x018SRAM_cell1_2x_3v64x8m81
X018SRAM_cell1_2x_3v64x8m81_78 m3_n1397_3931# 018SRAM_strap1_bndry_3v64x8m81_9/w_91_512#
+ m3_n1397_3931# VSUBS 018SRAM_strap1_bndry_3v64x8m81_9/w_91_512# m3_n1397_4645# m3_n1397_4645#
+ VSUBS 018SRAM_strap1_bndry_3v64x8m81_9/w_91_512# 018SRAM_strap1_bndry_3v64x8m81_9/w_91_512#
+ 018SRAM_cell1_2x_3v64x8m81_78/018SRAM_cell1_3v64x8m81_1/a_430_96# VSUBS 018SRAM_cell1_2x_3v64x8m81_78/018SRAM_cell1_3v64x8m81_1/a_110_96#
+ x018SRAM_cell1_2x_3v64x8m81
X018SRAM_cell1_2x_3v64x8m81_56 m3_n1397_1507# 018SRAM_strap1_bndry_3v64x8m81_9/w_91_512#
+ m3_n1397_1507# VSUBS 018SRAM_strap1_bndry_3v64x8m81_9/w_91_512# m3_n1397_2221# m3_n1397_2221#
+ VSUBS 018SRAM_strap1_bndry_3v64x8m81_9/w_91_512# 018SRAM_strap1_bndry_3v64x8m81_9/w_91_512#
+ 018SRAM_cell1_2x_3v64x8m81_59/018SRAM_cell1_3v64x8m81_1/a_430_96# VSUBS 018SRAM_cell1_2x_3v64x8m81_59/018SRAM_cell1_3v64x8m81_1/a_110_96#
+ x018SRAM_cell1_2x_3v64x8m81
X018SRAM_cell1_2x_3v64x8m81_67 m3_n1397_1507# 018SRAM_strap1_bndry_3v64x8m81_9/w_91_512#
+ m3_n1397_1507# VSUBS 018SRAM_strap1_bndry_3v64x8m81_9/w_91_512# m3_n1397_2221# m3_n1397_2221#
+ VSUBS 018SRAM_strap1_bndry_3v64x8m81_9/w_91_512# 018SRAM_strap1_bndry_3v64x8m81_9/w_91_512#
+ 018SRAM_cell1_2x_3v64x8m81_78/018SRAM_cell1_3v64x8m81_1/a_430_96# VSUBS 018SRAM_cell1_2x_3v64x8m81_78/018SRAM_cell1_3v64x8m81_1/a_110_96#
+ x018SRAM_cell1_2x_3v64x8m81
X018SRAM_cell1_2x_3v64x8m81_24 m3_n1397_247# 018SRAM_strap1_bndry_3v64x8m81_9/w_91_512#
+ m3_n1397_247# VSUBS 018SRAM_strap1_bndry_3v64x8m81_9/w_91_512# m3_n1397_1009# m3_n1397_1009#
+ VSUBS 018SRAM_strap1_bndry_3v64x8m81_9/w_91_512# 018SRAM_strap1_bndry_3v64x8m81_9/w_91_512#
+ 018SRAM_cell1_2x_3v64x8m81_28/018SRAM_cell1_3v64x8m81_1/a_430_96# VSUBS 018SRAM_cell1_2x_3v64x8m81_28/018SRAM_cell1_3v64x8m81_1/a_110_96#
+ x018SRAM_cell1_2x_3v64x8m81
X018SRAM_cell1_2x_3v64x8m81_68 m3_n1397_247# 018SRAM_strap1_bndry_3v64x8m81_9/w_91_512#
+ m3_n1397_247# VSUBS 018SRAM_strap1_bndry_3v64x8m81_9/w_91_512# m3_n1397_1009# m3_n1397_1009#
+ VSUBS 018SRAM_strap1_bndry_3v64x8m81_9/w_91_512# 018SRAM_strap1_bndry_3v64x8m81_9/w_91_512#
+ 018SRAM_cell1_2x_3v64x8m81_70/018SRAM_cell1_3v64x8m81_1/a_430_96# VSUBS 018SRAM_cell1_2x_3v64x8m81_70/018SRAM_cell1_3v64x8m81_1/a_110_96#
+ x018SRAM_cell1_2x_3v64x8m81
X018SRAM_cell1_2x_3v64x8m81_57 m3_n1397_247# 018SRAM_strap1_bndry_3v64x8m81_9/w_91_512#
+ m3_n1397_247# VSUBS 018SRAM_strap1_bndry_3v64x8m81_9/w_91_512# m3_n1397_1009# m3_n1397_1009#
+ VSUBS 018SRAM_strap1_bndry_3v64x8m81_9/w_91_512# 018SRAM_strap1_bndry_3v64x8m81_9/w_91_512#
+ 018SRAM_cell1_2x_3v64x8m81_59/018SRAM_cell1_3v64x8m81_1/a_430_96# VSUBS 018SRAM_cell1_2x_3v64x8m81_59/018SRAM_cell1_3v64x8m81_1/a_110_96#
+ x018SRAM_cell1_2x_3v64x8m81
X018SRAM_cell1_2x_3v64x8m81_36 m3_n1397_1507# 018SRAM_strap1_bndry_3v64x8m81_9/w_91_512#
+ m3_n1397_1507# VSUBS 018SRAM_strap1_bndry_3v64x8m81_9/w_91_512# m3_n1397_2221# m3_n1397_2221#
+ VSUBS 018SRAM_strap1_bndry_3v64x8m81_9/w_91_512# 018SRAM_strap1_bndry_3v64x8m81_9/w_91_512#
+ 018SRAM_cell1_2x_3v64x8m81_39/018SRAM_cell1_3v64x8m81_1/a_430_96# VSUBS 018SRAM_cell1_2x_3v64x8m81_39/018SRAM_cell1_3v64x8m81_1/a_110_96#
+ x018SRAM_cell1_2x_3v64x8m81
X018SRAM_cell1_2x_3v64x8m81_25 m3_n1397_1507# 018SRAM_strap1_bndry_3v64x8m81_9/w_91_512#
+ m3_n1397_1507# VSUBS 018SRAM_strap1_bndry_3v64x8m81_9/w_91_512# m3_n1397_2221# m3_n1397_2221#
+ VSUBS 018SRAM_strap1_bndry_3v64x8m81_9/w_91_512# 018SRAM_strap1_bndry_3v64x8m81_9/w_91_512#
+ 018SRAM_cell1_2x_3v64x8m81_6/018SRAM_cell1_3v64x8m81_1/a_430_96# VSUBS 018SRAM_cell1_2x_3v64x8m81_6/018SRAM_cell1_3v64x8m81_1/a_110_96#
+ x018SRAM_cell1_2x_3v64x8m81
X018SRAM_cell1_2x_3v64x8m81_69 m3_n1397_2719# 018SRAM_strap1_bndry_3v64x8m81_9/w_91_512#
+ m3_n1397_2719# VSUBS 018SRAM_strap1_bndry_3v64x8m81_9/w_91_512# m3_n1397_3433# m3_n1397_3433#
+ VSUBS 018SRAM_strap1_bndry_3v64x8m81_9/w_91_512# 018SRAM_strap1_bndry_3v64x8m81_9/w_91_512#
+ 018SRAM_cell1_2x_3v64x8m81_70/018SRAM_cell1_3v64x8m81_1/a_430_96# VSUBS 018SRAM_cell1_2x_3v64x8m81_70/018SRAM_cell1_3v64x8m81_1/a_110_96#
+ x018SRAM_cell1_2x_3v64x8m81
X018SRAM_cell1_2x_3v64x8m81_58 m3_n1397_2719# 018SRAM_strap1_bndry_3v64x8m81_9/w_91_512#
+ m3_n1397_2719# VSUBS 018SRAM_strap1_bndry_3v64x8m81_9/w_91_512# m3_n1397_3433# m3_n1397_3433#
+ VSUBS 018SRAM_strap1_bndry_3v64x8m81_9/w_91_512# 018SRAM_strap1_bndry_3v64x8m81_9/w_91_512#
+ 018SRAM_cell1_2x_3v64x8m81_59/018SRAM_cell1_3v64x8m81_1/a_430_96# VSUBS 018SRAM_cell1_2x_3v64x8m81_59/018SRAM_cell1_3v64x8m81_1/a_110_96#
+ x018SRAM_cell1_2x_3v64x8m81
X018SRAM_cell1_2x_3v64x8m81_37 m3_n1397_247# 018SRAM_strap1_bndry_3v64x8m81_9/w_91_512#
+ m3_n1397_247# VSUBS 018SRAM_strap1_bndry_3v64x8m81_9/w_91_512# m3_n1397_1009# m3_n1397_1009#
+ VSUBS 018SRAM_strap1_bndry_3v64x8m81_9/w_91_512# 018SRAM_strap1_bndry_3v64x8m81_9/w_91_512#
+ 018SRAM_cell1_2x_3v64x8m81_39/018SRAM_cell1_3v64x8m81_1/a_430_96# VSUBS 018SRAM_cell1_2x_3v64x8m81_39/018SRAM_cell1_3v64x8m81_1/a_110_96#
+ x018SRAM_cell1_2x_3v64x8m81
X018SRAM_cell1_2x_3v64x8m81_26 m3_n1397_2719# 018SRAM_strap1_bndry_3v64x8m81_9/w_91_512#
+ m3_n1397_2719# VSUBS 018SRAM_strap1_bndry_3v64x8m81_9/w_91_512# m3_n1397_3433# m3_n1397_3433#
+ VSUBS 018SRAM_strap1_bndry_3v64x8m81_9/w_91_512# 018SRAM_strap1_bndry_3v64x8m81_9/w_91_512#
+ 018SRAM_cell1_2x_3v64x8m81_28/018SRAM_cell1_3v64x8m81_1/a_430_96# VSUBS 018SRAM_cell1_2x_3v64x8m81_28/018SRAM_cell1_3v64x8m81_1/a_110_96#
+ x018SRAM_cell1_2x_3v64x8m81
X018SRAM_cell1_2x_3v64x8m81_59 m3_n1397_3931# 018SRAM_strap1_bndry_3v64x8m81_9/w_91_512#
+ m3_n1397_3931# VSUBS 018SRAM_strap1_bndry_3v64x8m81_9/w_91_512# m3_n1397_4645# m3_n1397_4645#
+ VSUBS 018SRAM_strap1_bndry_3v64x8m81_9/w_91_512# 018SRAM_strap1_bndry_3v64x8m81_9/w_91_512#
+ 018SRAM_cell1_2x_3v64x8m81_59/018SRAM_cell1_3v64x8m81_1/a_430_96# VSUBS 018SRAM_cell1_2x_3v64x8m81_59/018SRAM_cell1_3v64x8m81_1/a_110_96#
+ x018SRAM_cell1_2x_3v64x8m81
X018SRAM_cell1_2x_3v64x8m81_38 m3_n1397_2719# 018SRAM_strap1_bndry_3v64x8m81_9/w_91_512#
+ m3_n1397_2719# VSUBS 018SRAM_strap1_bndry_3v64x8m81_9/w_91_512# m3_n1397_3433# m3_n1397_3433#
+ VSUBS 018SRAM_strap1_bndry_3v64x8m81_9/w_91_512# 018SRAM_strap1_bndry_3v64x8m81_9/w_91_512#
+ 018SRAM_cell1_2x_3v64x8m81_39/018SRAM_cell1_3v64x8m81_1/a_430_96# VSUBS 018SRAM_cell1_2x_3v64x8m81_39/018SRAM_cell1_3v64x8m81_1/a_110_96#
+ x018SRAM_cell1_2x_3v64x8m81
X018SRAM_cell1_2x_3v64x8m81_27 m3_n1397_2719# 018SRAM_strap1_bndry_3v64x8m81_9/w_91_512#
+ m3_n1397_2719# VSUBS 018SRAM_strap1_bndry_3v64x8m81_9/w_91_512# m3_n1397_3433# m3_n1397_3433#
+ VSUBS 018SRAM_strap1_bndry_3v64x8m81_9/w_91_512# 018SRAM_strap1_bndry_3v64x8m81_9/w_91_512#
+ 018SRAM_cell1_2x_3v64x8m81_6/018SRAM_cell1_3v64x8m81_1/a_430_96# VSUBS 018SRAM_cell1_2x_3v64x8m81_6/018SRAM_cell1_3v64x8m81_1/a_110_96#
+ x018SRAM_cell1_2x_3v64x8m81
X018SRAM_cell1_2x_3v64x8m81_16 m3_n1397_1507# 018SRAM_strap1_bndry_3v64x8m81_9/w_91_512#
+ m3_n1397_1507# VSUBS 018SRAM_strap1_bndry_3v64x8m81_9/w_91_512# m3_n1397_2221# m3_n1397_2221#
+ VSUBS 018SRAM_strap1_bndry_3v64x8m81_9/w_91_512# 018SRAM_strap1_bndry_3v64x8m81_9/w_91_512#
+ 018SRAM_cell1_2x_3v64x8m81_28/018SRAM_cell1_3v64x8m81_1/a_430_96# VSUBS 018SRAM_cell1_2x_3v64x8m81_28/018SRAM_cell1_3v64x8m81_1/a_110_96#
+ x018SRAM_cell1_2x_3v64x8m81
X018SRAM_cell1_2x_3v64x8m81_39 m3_n1397_3931# 018SRAM_strap1_bndry_3v64x8m81_9/w_91_512#
+ m3_n1397_3931# VSUBS 018SRAM_strap1_bndry_3v64x8m81_9/w_91_512# m3_n1397_4645# m3_n1397_4645#
+ VSUBS 018SRAM_strap1_bndry_3v64x8m81_9/w_91_512# 018SRAM_strap1_bndry_3v64x8m81_9/w_91_512#
+ 018SRAM_cell1_2x_3v64x8m81_39/018SRAM_cell1_3v64x8m81_1/a_430_96# VSUBS 018SRAM_cell1_2x_3v64x8m81_39/018SRAM_cell1_3v64x8m81_1/a_110_96#
+ x018SRAM_cell1_2x_3v64x8m81
X018SRAM_cell1_2x_3v64x8m81_17 m3_n1397_1507# 018SRAM_strap1_bndry_3v64x8m81_9/w_91_512#
+ m3_n1397_1507# VSUBS 018SRAM_strap1_bndry_3v64x8m81_9/w_91_512# m3_n1397_2221# m3_n1397_2221#
+ VSUBS 018SRAM_strap1_bndry_3v64x8m81_9/w_91_512# 018SRAM_strap1_bndry_3v64x8m81_9/w_91_512#
+ 018SRAM_cell1_2x_3v64x8m81_20/018SRAM_cell1_3v64x8m81_1/a_430_96# VSUBS 018SRAM_cell1_2x_3v64x8m81_20/018SRAM_cell1_3v64x8m81_1/a_110_96#
+ x018SRAM_cell1_2x_3v64x8m81
X018SRAM_cell1_2x_3v64x8m81_28 m3_n1397_3931# 018SRAM_strap1_bndry_3v64x8m81_9/w_91_512#
+ m3_n1397_3931# VSUBS 018SRAM_strap1_bndry_3v64x8m81_9/w_91_512# m3_n1397_4645# m3_n1397_4645#
+ VSUBS 018SRAM_strap1_bndry_3v64x8m81_9/w_91_512# 018SRAM_strap1_bndry_3v64x8m81_9/w_91_512#
+ 018SRAM_cell1_2x_3v64x8m81_28/018SRAM_cell1_3v64x8m81_1/a_430_96# VSUBS 018SRAM_cell1_2x_3v64x8m81_28/018SRAM_cell1_3v64x8m81_1/a_110_96#
+ x018SRAM_cell1_2x_3v64x8m81
X018SRAM_cell1_2x_3v64x8m81_330 m3_n1397_3931# 018SRAM_strap1_bndry_3v64x8m81_9/w_91_512#
+ m3_n1397_3931# VSUBS 018SRAM_strap1_bndry_3v64x8m81_9/w_91_512# m3_n1397_4645# m3_n1397_4645#
+ VSUBS 018SRAM_strap1_bndry_3v64x8m81_9/w_91_512# 018SRAM_strap1_bndry_3v64x8m81_9/w_91_512#
+ 018SRAM_cell1_2x_3v64x8m81_330/018SRAM_cell1_3v64x8m81_1/a_430_96# VSUBS 018SRAM_cell1_2x_3v64x8m81_330/018SRAM_cell1_3v64x8m81_1/a_110_96#
+ x018SRAM_cell1_2x_3v64x8m81
X018SRAM_cell1_2x_3v64x8m81_341 m3_n1397_1507# 018SRAM_strap1_bndry_3v64x8m81_9/w_91_512#
+ m3_n1397_1507# VSUBS 018SRAM_strap1_bndry_3v64x8m81_9/w_91_512# m3_n1397_2221# m3_n1397_2221#
+ VSUBS 018SRAM_strap1_bndry_3v64x8m81_9/w_91_512# 018SRAM_strap1_bndry_3v64x8m81_9/w_91_512#
+ 018SRAM_cell1_2x_3v64x8m81_341/018SRAM_cell1_3v64x8m81_1/a_430_96# VSUBS 018SRAM_cell1_2x_3v64x8m81_341/018SRAM_cell1_3v64x8m81_1/a_110_96#
+ x018SRAM_cell1_2x_3v64x8m81
X018SRAM_cell1_2x_3v64x8m81_18 m3_n1397_247# 018SRAM_strap1_bndry_3v64x8m81_9/w_91_512#
+ m3_n1397_247# VSUBS 018SRAM_strap1_bndry_3v64x8m81_9/w_91_512# m3_n1397_1009# m3_n1397_1009#
+ VSUBS 018SRAM_strap1_bndry_3v64x8m81_9/w_91_512# 018SRAM_strap1_bndry_3v64x8m81_9/w_91_512#
+ 018SRAM_cell1_2x_3v64x8m81_20/018SRAM_cell1_3v64x8m81_1/a_430_96# VSUBS 018SRAM_cell1_2x_3v64x8m81_20/018SRAM_cell1_3v64x8m81_1/a_110_96#
+ x018SRAM_cell1_2x_3v64x8m81
X018SRAM_cell1_2x_3v64x8m81_342 m3_n1397_1507# 018SRAM_strap1_bndry_3v64x8m81_9/w_91_512#
+ m3_n1397_1507# VSUBS 018SRAM_strap1_bndry_3v64x8m81_9/w_91_512# m3_n1397_2221# m3_n1397_2221#
+ VSUBS 018SRAM_strap1_bndry_3v64x8m81_9/w_91_512# 018SRAM_strap1_bndry_3v64x8m81_9/w_91_512#
+ 018SRAM_cell1_2x_3v64x8m81_343/018SRAM_cell1_3v64x8m81_1/a_430_96# VSUBS 018SRAM_cell1_2x_3v64x8m81_343/018SRAM_cell1_3v64x8m81_1/a_110_96#
+ x018SRAM_cell1_2x_3v64x8m81
X018SRAM_cell1_2x_3v64x8m81_19 m3_n1397_2719# 018SRAM_strap1_bndry_3v64x8m81_9/w_91_512#
+ m3_n1397_2719# VSUBS 018SRAM_strap1_bndry_3v64x8m81_9/w_91_512# m3_n1397_3433# m3_n1397_3433#
+ VSUBS 018SRAM_strap1_bndry_3v64x8m81_9/w_91_512# 018SRAM_strap1_bndry_3v64x8m81_9/w_91_512#
+ 018SRAM_cell1_2x_3v64x8m81_20/018SRAM_cell1_3v64x8m81_1/a_430_96# VSUBS 018SRAM_cell1_2x_3v64x8m81_20/018SRAM_cell1_3v64x8m81_1/a_110_96#
+ x018SRAM_cell1_2x_3v64x8m81
X018SRAM_cell1_2x_3v64x8m81_310 m3_n1397_247# 018SRAM_strap1_bndry_3v64x8m81_9/w_91_512#
+ m3_n1397_247# VSUBS 018SRAM_strap1_bndry_3v64x8m81_9/w_91_512# m3_n1397_1009# m3_n1397_1009#
+ VSUBS 018SRAM_strap1_bndry_3v64x8m81_9/w_91_512# 018SRAM_strap1_bndry_3v64x8m81_9/w_91_512#
+ 018SRAM_cell1_2x_3v64x8m81_319/018SRAM_cell1_3v64x8m81_1/a_430_96# VSUBS 018SRAM_cell1_2x_3v64x8m81_319/018SRAM_cell1_3v64x8m81_1/a_110_96#
+ x018SRAM_cell1_2x_3v64x8m81
X018SRAM_cell1_2x_3v64x8m81_343 m3_n1397_247# 018SRAM_strap1_bndry_3v64x8m81_9/w_91_512#
+ m3_n1397_247# VSUBS 018SRAM_strap1_bndry_3v64x8m81_9/w_91_512# m3_n1397_1009# m3_n1397_1009#
+ VSUBS 018SRAM_strap1_bndry_3v64x8m81_9/w_91_512# 018SRAM_strap1_bndry_3v64x8m81_9/w_91_512#
+ 018SRAM_cell1_2x_3v64x8m81_343/018SRAM_cell1_3v64x8m81_1/a_430_96# VSUBS 018SRAM_cell1_2x_3v64x8m81_343/018SRAM_cell1_3v64x8m81_1/a_110_96#
+ x018SRAM_cell1_2x_3v64x8m81
X018SRAM_cell1_2x_3v64x8m81_321 m3_n1397_1507# 018SRAM_strap1_bndry_3v64x8m81_9/w_91_512#
+ m3_n1397_1507# VSUBS 018SRAM_strap1_bndry_3v64x8m81_9/w_91_512# m3_n1397_2221# m3_n1397_2221#
+ VSUBS 018SRAM_strap1_bndry_3v64x8m81_9/w_91_512# 018SRAM_strap1_bndry_3v64x8m81_9/w_91_512#
+ 018SRAM_cell1_2x_3v64x8m81_324/018SRAM_cell1_3v64x8m81_1/a_430_96# VSUBS 018SRAM_cell1_2x_3v64x8m81_324/018SRAM_cell1_3v64x8m81_1/a_110_96#
+ x018SRAM_cell1_2x_3v64x8m81
X018SRAM_cell1_2x_3v64x8m81_311 m3_n1397_2719# 018SRAM_strap1_bndry_3v64x8m81_9/w_91_512#
+ m3_n1397_2719# VSUBS 018SRAM_strap1_bndry_3v64x8m81_9/w_91_512# m3_n1397_3433# m3_n1397_3433#
+ VSUBS 018SRAM_strap1_bndry_3v64x8m81_9/w_91_512# 018SRAM_strap1_bndry_3v64x8m81_9/w_91_512#
+ 018SRAM_cell1_2x_3v64x8m81_319/018SRAM_cell1_3v64x8m81_1/a_430_96# VSUBS 018SRAM_cell1_2x_3v64x8m81_319/018SRAM_cell1_3v64x8m81_1/a_110_96#
+ x018SRAM_cell1_2x_3v64x8m81
X018SRAM_cell1_2x_3v64x8m81_300 m3_n1397_247# 018SRAM_strap1_bndry_3v64x8m81_9/w_91_512#
+ m3_n1397_247# VSUBS 018SRAM_strap1_bndry_3v64x8m81_9/w_91_512# m3_n1397_1009# m3_n1397_1009#
+ VSUBS 018SRAM_strap1_bndry_3v64x8m81_9/w_91_512# 018SRAM_strap1_bndry_3v64x8m81_9/w_91_512#
+ 018SRAM_cell1_2x_3v64x8m81_341/018SRAM_cell1_3v64x8m81_1/a_430_96# VSUBS 018SRAM_cell1_2x_3v64x8m81_341/018SRAM_cell1_3v64x8m81_1/a_110_96#
+ x018SRAM_cell1_2x_3v64x8m81
X018SRAM_cell1_2x_3v64x8m81_322 m3_n1397_247# 018SRAM_strap1_bndry_3v64x8m81_9/w_91_512#
+ m3_n1397_247# VSUBS 018SRAM_strap1_bndry_3v64x8m81_9/w_91_512# m3_n1397_1009# m3_n1397_1009#
+ VSUBS 018SRAM_strap1_bndry_3v64x8m81_9/w_91_512# 018SRAM_strap1_bndry_3v64x8m81_9/w_91_512#
+ 018SRAM_cell1_2x_3v64x8m81_324/018SRAM_cell1_3v64x8m81_1/a_430_96# VSUBS 018SRAM_cell1_2x_3v64x8m81_324/018SRAM_cell1_3v64x8m81_1/a_110_96#
+ x018SRAM_cell1_2x_3v64x8m81
.ends

.subckt x018SRAM_cell1_dummy_R_3v64x8m81 m3_82_330# a_248_342# a_62_178# w_30_512#
+ a_430_96# a_110_96# a_192_298# VSUBS
X0 a_192_298# a_192_298# a_110_250# w_30_512# pfet_03v3 ad=0.1613p pd=1.39u as=0.1238p ps=1.44u w=0.28u l=0.28u
X1 a_248_342# a_192_298# a_110_250# VSUBS nfet_03v3 ad=0.171p pd=1.33u as=0.15665p ps=1.32u w=0.45u l=0.28u
X2 a_408_342# a_248_342# a_192_298# w_30_512# pfet_03v3 ad=0.1238p pd=1.44u as=0.1613p ps=1.39u w=0.28u l=0.28u
X3 a_408_342# a_248_342# a_248_342# VSUBS nfet_03v3 ad=0.15665p pd=1.32u as=0.171p ps=1.33u w=0.45u l=0.28u
X4 a_110_250# a_62_178# a_110_96# VSUBS nfet_03v3 ad=0.15665p pd=1.32u as=0.1208p ps=1.42u w=0.28u l=0.36u
X5 a_408_342# a_62_178# a_430_96# VSUBS nfet_03v3 ad=0.15665p pd=1.32u as=0.1208p ps=1.42u w=0.28u l=0.36u
.ends

.subckt pmos_5p04310591302097_3v64x8m81 D a_n28_n44# a_132_n44# w_n202_n86# S_uq0
+ S
X0 D a_n28_n44# S w_n202_n86# pfet_03v3 ad=1.2909p pd=5.485u as=2.1846p ps=10.81u w=4.965u l=0.28u
X1 S_uq0 a_132_n44# D w_n202_n86# pfet_03v3 ad=2.1846p pd=10.81u as=1.2909p ps=5.485u w=4.965u l=0.28u
.ends

.subckt pmos_5p04310591302095_3v64x8m81 D a_n28_n44# a_132_n44# w_n202_n86# S_uq0
+ S
X0 D a_n28_n44# S w_n202_n86# pfet_03v3 ad=0.4251p pd=2.155u as=0.7194p ps=4.15u w=1.635u l=0.28u
X1 S_uq0 a_132_n44# D w_n202_n86# pfet_03v3 ad=0.7194p pd=4.15u as=0.4251p ps=2.155u w=1.635u l=0.28u
.ends

.subckt ypass_gate_3v64x8m81_0 bb db ypass d pcb vdd_uq0 m3_0_2091# m3_0_2831# a_64_1295#
+ VSUBS m3_0_3056# b m3_0_3781# m3_0_1632# m3_0_3536# vss m3_0_3291# m3_0_2331# pmos_5p0431059130201_3v64x8m81_0/D
+ vdd m3_0_2581# pmos_5p0431059130201_3v64x8m81_2/D
Xnmos_5p0431059130202_3v64x8m81_0 ypassb a_64_1295# a_64_1295# VSUBS VSUBS VSUBS nmos_5p0431059130202_3v64x8m81
Xnmos_5p0431059130200_3v64x8m81_0 pmos_5p0431059130201_3v64x8m81_2/D a_64_1295# bb
+ VSUBS nmos_5p0431059130200_3v64x8m81
Xnmos_5p0431059130200_3v64x8m81_1 pmos_5p0431059130201_3v64x8m81_0/D a_64_1295# b
+ VSUBS nmos_5p0431059130200_3v64x8m81
Xpmos_5p0431059130201_3v64x8m81_0 pmos_5p0431059130201_3v64x8m81_0/D ypassb vdd_uq0
+ b pmos_5p0431059130201_3v64x8m81
Xpmos_5p0431059130201_3v64x8m81_1 b pcb vdd bb pmos_5p0431059130201_3v64x8m81
Xpmos_5p0431059130201_3v64x8m81_2 pmos_5p0431059130201_3v64x8m81_2/D ypassb vdd bb
+ pmos_5p0431059130201_3v64x8m81
X0 vdd pcb b vdd pfet_03v3 ad=0.94105p pd=4.37u as=0.51437p ps=2.24u w=1.595u l=0.28u
X1 bb pcb vdd vdd pfet_03v3 ad=0.51437p pd=2.24u as=1.13245p ps=4.61u w=1.595u l=0.28u
X2 ypassb a_64_1295# vdd_uq0 vdd_uq0 pfet_03v3 ad=0.1946p pd=1.255u as=0.38225p ps=2.49u w=0.695u l=0.28u
X3 vdd_uq0 a_64_1295# ypassb vdd_uq0 pfet_03v3 ad=0.50735p pd=2.85u as=0.1946p ps=1.255u w=0.695u l=0.28u
X4 b pcb vdd vdd pfet_03v3 ad=0.51437p pd=2.24u as=1.13245p ps=4.61u w=1.595u l=0.28u
X5 vdd pcb bb vdd pfet_03v3 ad=0.94105p pd=4.37u as=0.51437p ps=2.24u w=1.595u l=0.28u
.ends

.subckt nmos_5p04310591302098_3v64x8m81 D a_n28_n44# a_132_n44# S_uq0 S VSUBS
X0 D a_n28_n44# S VSUBS nfet_03v3 ad=0.1664p pd=1.16u as=0.2816p ps=2.16u w=0.64u l=0.28u
X1 S_uq0 a_132_n44# D VSUBS nfet_03v3 ad=0.2816p pd=2.16u as=0.1664p ps=1.16u w=0.64u l=0.28u
.ends

.subckt nmos_5p04310591302096_3v64x8m81 D a_n28_n44# a_132_n44# S_uq0 S VSUBS
X0 D a_n28_n44# S VSUBS nfet_03v3 ad=1.0309p pd=4.485u as=1.7446p ps=8.81u w=3.965u l=0.28u
X1 S_uq0 a_132_n44# D VSUBS nfet_03v3 ad=1.7446p pd=8.81u as=1.0309p ps=4.485u w=3.965u l=0.28u
.ends

.subckt rdummy_3v64x4_3v64x8m81 018SRAM_cell1_dummy_3v64x8m81_40/m2_346_89# 018SRAM_cell1_dummy_3v64x8m81_40/m2_134_89#
+ 018SRAM_cell1_dummy_R_3v64x8m81_10/m3_82_330# pmos_5p04310591302097_3v64x8m81_0/D
+ 018SRAM_cell1_dummy_3v64x8m81_50/m2_346_89# 018SRAM_cell1_dummy_3v64x8m81_11/m2_346_89#
+ 018SRAM_cell1_dummy_R_3v64x8m81_10/a_248_342# m3_15667_n5798# 018SRAM_cell1_2x_3v64x8m81_6/018SRAM_cell1_3v64x8m81_1/w_30_512#
+ 018SRAM_cell1_dummy_R_3v64x8m81_2/m3_82_330# 018SRAM_cell1_dummy_3v64x8m81_50/m2_134_89#
+ 018SRAM_cell1_dummy_3v64x8m81_11/m2_134_89# 018SRAM_cell1_dummy_R_3v64x8m81_2/a_248_342#
+ 018SRAM_cell1_dummy_3v64x8m81_21/m2_346_89# 018SRAM_cell1_dummy_3v64x8m81_60/m2_346_89#
+ 018SRAM_cell1_dummy_3v64x8m81_60/m2_134_89# 018SRAM_cell1_dummy_3v64x8m81_21/m2_134_89#
+ 018SRAM_cell1_dummy_3v64x8m81_7/m2_346_89# 018SRAM_cell1_dummy_3v64x8m81_7/m2_134_89#
+ 018SRAM_cell1_dummy_3v64x8m81_31/m2_346_89# w_15880_n13729# 018SRAM_cell1_dummy_3v64x8m81_31/m2_134_89#
+ 018SRAM_cell1_dummy_3v64x8m81_41/m2_346_89# 018SRAM_cell1_dummy_3v64x8m81_41/m2_134_89#
+ ypass_gate_3v64x8m81_0_0/pcb 018SRAM_cell1_dummy_R_3v64x8m81_11/m3_82_330# 018SRAM_cell1_dummy_R_3v64x8m81_11/a_248_342#
+ 018SRAM_cell1_dummy_3v64x8m81_12/m2_346_89# 018SRAM_cell1_dummy_3v64x8m81_51/m2_346_89#
+ 018SRAM_cell1_dummy_R_3v64x8m81_2/a_192_298# 018SRAM_cell1_dummy_3v64x8m81_51/m2_134_89#
+ 018SRAM_cell1_dummy_3v64x8m81_12/m2_134_89# 018SRAM_cell1_dummy_R_3v64x8m81_3/m3_82_330#
+ 018SRAM_cell1_dummy_R_3v64x8m81_3/a_248_342# 018SRAM_cell1_dummy_3v64x8m81_61/m2_346_89#
+ 018SRAM_cell1_dummy_3v64x8m81_22/m2_346_89# 018SRAM_cell1_dummy_3v64x8m81_61/m2_134_89#
+ 018SRAM_cell1_dummy_3v64x8m81_22/m2_134_89# ypass_gate_3v64x8m81_0_0/b 018SRAM_cell1_dummy_3v64x8m81_8/m2_346_89#
+ 018SRAM_cell1_dummy_3v64x8m81_8/m2_134_89# m1_16100_n16182# 018SRAM_cell1_dummy_3v64x8m81_32/m2_346_89#
+ 018SRAM_cell1_dummy_3v64x8m81_32/m2_134_89# 018SRAM_cell1_dummy_3v64x8m81_42/m2_346_89#
+ 018SRAM_cell1_dummy_3v64x8m81_42/m2_134_89# 018SRAM_cell1_2x_3v64x8m81_7/018SRAM_cell1_3v64x8m81_0/w_30_512#
+ 018SRAM_cell1_dummy_3v64x8m81_52/m2_346_89# 018SRAM_cell1_dummy_3v64x8m81_13/m2_346_89#
+ 018SRAM_cell1_dummy_3v64x8m81_13/m2_134_89# 018SRAM_cell1_dummy_3v64x8m81_52/m2_134_89#
+ 018SRAM_cell1_dummy_3v64x8m81_62/m2_346_89# 018SRAM_cell1_dummy_3v64x8m81_23/m2_346_89#
+ 018SRAM_cell1_dummy_3v64x8m81_62/m2_134_89# 018SRAM_cell1_dummy_3v64x8m81_23/m2_134_89#
+ 018SRAM_cell1_dummy_3v64x8m81_9/m2_346_89# 018SRAM_cell1_dummy_3v64x8m81_9/m2_134_89#
+ 018SRAM_cell1_dummy_3v64x8m81_33/m2_346_89# 018SRAM_cell1_dummy_3v64x8m81_33/m2_134_89#
+ 018SRAM_cell1_dummy_3v64x8m81_43/m2_346_89# 018SRAM_cell1_dummy_3v64x8m81_43/m2_134_89#
+ 018SRAM_cell1_dummy_3v64x8m81_53/m2_346_89# 018SRAM_cell1_dummy_3v64x8m81_14/m2_346_89#
+ 018SRAM_cell1_dummy_3v64x8m81_14/m2_134_89# 018SRAM_cell1_dummy_3v64x8m81_53/m2_134_89#
+ 018SRAM_cell1_dummy_3v64x8m81_24/m2_346_89# 018SRAM_cell1_dummy_3v64x8m81_63/m2_346_89#
+ 018SRAM_cell1_dummy_3v64x8m81_24/m2_134_89# 018SRAM_cell1_dummy_3v64x8m81_63/m2_134_89#
+ 018SRAM_cell1_dummy_3v64x8m81_34/m2_346_89# ypass_gate_3v64x8m81_0_0/vss 018SRAM_cell1_dummy_3v64x8m81_34/m2_134_89#
+ 018SRAM_cell1_dummy_3v64x8m81_44/m2_346_89# m3_15667_n5552# 018SRAM_cell1_2x_3v64x8m81_8/018SRAM_cell1_3v64x8m81_1/w_30_512#
+ 018SRAM_cell1_dummy_3v64x8m81_44/m2_134_89# 018SRAM_cell1_dummy_R_3v64x8m81_14/m3_82_330#
+ 018SRAM_cell1_dummy_R_3v64x8m81_14/a_248_342# 018SRAM_cell1_dummy_3v64x8m81_54/m2_346_89#
+ 018SRAM_cell1_dummy_3v64x8m81_15/m2_346_89# 018SRAM_cell1_dummy_3v64x8m81_54/m2_134_89#
+ 018SRAM_cell1_dummy_3v64x8m81_15/m2_134_89# 018SRAM_cell1_2x_3v64x8m81_1/018SRAM_cell1_3v64x8m81_0/a_248_342#
+ 018SRAM_cell1_2x_3v64x8m81_1/018SRAM_cell1_3v64x8m81_0/m3_82_330# 018SRAM_cell1_dummy_3v64x8m81_64/m2_134_89#
+ 018SRAM_cell1_dummy_3v64x8m81_25/m2_346_89# 018SRAM_cell1_dummy_3v64x8m81_64/m2_346_89#
+ 018SRAM_cell1_dummy_3v64x8m81_0/m2_346_89# 018SRAM_cell1_dummy_3v64x8m81_25/m2_134_89#
+ 018SRAM_cell1_dummy_3v64x8m81_0/m2_134_89# 018SRAM_cell1_dummy_3v64x8m81_35/m2_134_89#
+ 018SRAM_cell1_dummy_3v64x8m81_35/m2_346_89# m3_15667_n6510# 018SRAM_cell1_dummy_3v64x8m81_45/m2_346_89#
+ 018SRAM_cell1_dummy_3v64x8m81_45/m2_134_89# 018SRAM_cell1_dummy_R_3v64x8m81_3/w_30_512#
+ ypass_gate_3v64x8m81_0_0/vdd 018SRAM_cell1_dummy_3v64x8m81_16/m2_346_89# 018SRAM_cell1_dummy_3v64x8m81_55/m2_346_89#
+ 018SRAM_cell1_dummy_3v64x8m81_55/m2_134_89# 018SRAM_cell1_dummy_R_3v64x8m81_3/a_192_298#
+ 018SRAM_cell1_dummy_3v64x8m81_16/m2_134_89# m3_15667_n6288# 018SRAM_cell1_dummy_3v64x8m81_26/m2_346_89#
+ 018SRAM_cell1_2x_3v64x8m81_1/018SRAM_cell1_3v64x8m81_1/m3_82_330# 018SRAM_cell1_dummy_R_3v64x8m81_2/w_30_512#
+ 018SRAM_cell1_2x_3v64x8m81_1/018SRAM_cell1_3v64x8m81_1/a_248_342# 018SRAM_cell1_dummy_3v64x8m81_26/m2_134_89#
+ 018SRAM_cell1_dummy_3v64x8m81_1/m2_346_89# 018SRAM_cell1_dummy_3v64x8m81_1/m2_134_89#
+ 018SRAM_cell1_dummy_3v64x8m81_36/m2_346_89# 018SRAM_cell1_dummy_R_3v64x8m81_0/w_30_512#
+ 018SRAM_cell1_dummy_3v64x8m81_36/m2_134_89# 018SRAM_cell1_2x_3v64x8m81_7/018SRAM_cell1_3v64x8m81_0/a_248_592#
+ 018SRAM_cell1_dummy_3v64x8m81_46/m2_346_89# 018SRAM_cell1_dummy_3v64x8m81_46/m2_134_89#
+ ypass_gate_3v64x8m81_0_0/pmos_5p0431059130201_3v64x8m81_0/D 018SRAM_cell1_dummy_3v64x8m81_56/m2_346_89#
+ m3_15698_n15942# 018SRAM_cell1_dummy_3v64x8m81_17/m2_346_89# 018SRAM_cell1_dummy_3v64x8m81_17/m2_134_89#
+ 018SRAM_cell1_dummy_3v64x8m81_56/m2_134_89# 018SRAM_cell1_dummy_3v64x8m81_27/m2_346_89#
+ m3_15667_n7247# 018SRAM_cell1_dummy_3v64x8m81_27/m2_134_89# 018SRAM_cell1_dummy_3v64x8m81_2/m2_346_89#
+ ypass_gate_3v64x8m81_0_0/vdd_uq0 018SRAM_cell1_dummy_3v64x8m81_2/m2_134_89# 018SRAM_cell1_dummy_3v64x8m81_37/m2_346_89#
+ 018SRAM_cell1_dummy_3v64x8m81_37/m2_134_89# 018SRAM_cell1_2x_3v64x8m81_6/018SRAM_cell1_3v64x8m81_0/a_248_342#
+ 018SRAM_cell1_2x_3v64x8m81_6/018SRAM_cell1_3v64x8m81_0/m3_82_330# 018SRAM_cell1_dummy_3v64x8m81_47/m2_346_89#
+ 018SRAM_cell1_dummy_3v64x8m81_47/m2_134_89# 018SRAM_cell1_dummy_3v64x8m81_18/m2_346_89#
+ 018SRAM_cell1_dummy_3v64x8m81_57/m2_346_89# 018SRAM_cell1_dummy_3v64x8m81_57/m2_134_89#
+ 018SRAM_cell1_2x_3v64x8m81_7/018SRAM_cell1_3v64x8m81_0/m3_82_330# 018SRAM_cell1_dummy_R_3v64x8m81_9/m3_82_330#
+ 018SRAM_cell1_dummy_3v64x8m81_18/m2_134_89# 018SRAM_cell1_dummy_R_3v64x8m81_9/a_248_342#
+ 018SRAM_cell1_2x_3v64x8m81_7/018SRAM_cell1_3v64x8m81_0/a_248_342# 018SRAM_cell1_dummy_3v64x8m81_28/m2_346_89#
+ 018SRAM_cell1_dummy_3v64x8m81_28/m2_134_89# 018SRAM_cell1_dummy_3v64x8m81_3/m2_346_89#
+ 018SRAM_cell1_dummy_3v64x8m81_3/m2_134_89# 018SRAM_cell1_dummy_3v64x8m81_38/m2_134_89#
+ m3_15645_n13711# 018SRAM_cell1_dummy_3v64x8m81_38/m2_346_89# 018SRAM_cell1_2x_3v64x8m81_6/018SRAM_cell1_3v64x8m81_1/m3_82_330#
+ 018SRAM_cell1_2x_3v64x8m81_8/018SRAM_cell1_3v64x8m81_0/m3_82_330# 018SRAM_cell1_dummy_3v64x8m81_48/m2_346_89#
+ 018SRAM_cell1_2x_3v64x8m81_6/018SRAM_cell1_3v64x8m81_1/a_248_342# 018SRAM_cell1_2x_3v64x8m81_8/018SRAM_cell1_3v64x8m81_0/a_248_342#
+ 018SRAM_cell1_dummy_3v64x8m81_48/m2_134_89# pmos_5p04310591302097_3v64x8m81_0/S
+ 018SRAM_cell1_dummy_R_3v64x8m81_18/m3_82_330# 018SRAM_cell1_dummy_3v64x8m81_19/m2_346_89#
+ 018SRAM_cell1_dummy_R_3v64x8m81_18/a_248_342# 018SRAM_cell1_dummy_R_3v64x8m81_0/a_192_298#
+ 018SRAM_cell1_dummy_3v64x8m81_19/m2_134_89# 018SRAM_cell1_2x_3v64x8m81_7/018SRAM_cell1_3v64x8m81_1/m3_82_330#
+ 018SRAM_cell1_2x_3v64x8m81_6/018SRAM_cell1_3v64x8m81_1/a_248_592# 018SRAM_cell1_2x_3v64x8m81_7/018SRAM_cell1_3v64x8m81_1/a_248_342#
+ 018SRAM_cell1_dummy_3v64x8m81_29/m2_346_89# 018SRAM_cell1_dummy_3v64x8m81_4/m2_346_89#
+ 018SRAM_cell1_dummy_3v64x8m81_29/m2_134_89# 018SRAM_cell1_dummy_3v64x8m81_4/m2_134_89#
+ 018SRAM_cell1_dummy_3v64x8m81_39/m2_346_89# 018SRAM_cell1_dummy_3v64x8m81_39/m2_134_89#
+ 018SRAM_cell1_2x_3v64x8m81_8/018SRAM_cell1_3v64x8m81_1/m3_82_330# 018SRAM_cell1_2x_3v64x8m81_8/018SRAM_cell1_3v64x8m81_1/a_248_342#
+ 018SRAM_cell1_dummy_3v64x8m81_49/m2_346_89# 018SRAM_cell1_dummy_3v64x8m81_49/m2_134_89#
+ 018SRAM_cell1_dummy_3v64x8m81_59/m2_346_89# 018SRAM_cell1_3v64x8m81_1/w_30_512#
+ m3_15667_n6043# 018SRAM_cell1_dummy_R_3v64x8m81_0/m3_82_330# 018SRAM_cell1_dummy_R_3v64x8m81_0/a_248_342#
+ 018SRAM_cell1_dummy_3v64x8m81_59/m2_134_89# 018SRAM_cell1_2x_3v64x8m81_8/018SRAM_cell1_3v64x8m81_1/a_248_592#
+ 018SRAM_cell1_dummy_3v64x8m81_5/m2_346_89# m2_16574_21# 018SRAM_cell1_dummy_3v64x8m81_5/m2_134_89#
+ 018SRAM_cell1_dummy_3v64x8m81_10/m2_346_89# 018SRAM_cell1_dummy_3v64x8m81_10/m2_134_89#
+ pmos_5p04310591302095_3v64x8m81_0/S m2_16574_4850# m3_15667_n7002# 018SRAM_cell1_dummy_3v64x8m81_20/m2_134_89#
+ 018SRAM_cell1_dummy_3v64x8m81_6/m2_346_89# a_n547_178# 018SRAM_cell1_dummy_3v64x8m81_20/m2_346_89#
+ 018SRAM_cell1_dummy_3v64x8m81_6/m2_134_89# 018SRAM_cell1_dummy_3v64x8m81_30/m2_346_89#
+ VSUBS m3_n631_83# 018SRAM_cell1_3v64x8m81_0/w_30_512# 018SRAM_cell1_dummy_3v64x8m81_30/m2_134_89#
+ m3_15667_n6752#
X018SRAM_cell1_dummy_R_3v64x8m81_19 a_n547_178# VSUBS m2_16574_21# 018SRAM_cell1_3v64x8m81_0/w_30_512#
+ ypass_gate_3v64x8m81_0_0/bb ypass_gate_3v64x8m81_0_0/b 018SRAM_cell1_3v64x8m81_0/w_30_512#
+ VSUBS x018SRAM_cell1_dummy_R_3v64x8m81
X018SRAM_cell1_dummy_3v64x8m81_60 m2_16574_4850# VSUBS 018SRAM_cell1_3v64x8m81_1/w_30_512#
+ 018SRAM_cell1_3v64x8m81_1/w_30_512# m2_16574_4850# 018SRAM_cell1_dummy_3v64x8m81_60/m2_346_89#
+ 018SRAM_cell1_dummy_3v64x8m81_60/m2_134_89# VSUBS x018SRAM_cell1_dummy_3v64x8m81
X018SRAM_cell1_dummy_3v64x8m81_61 m2_16574_4850# VSUBS 018SRAM_cell1_3v64x8m81_1/w_30_512#
+ 018SRAM_cell1_3v64x8m81_1/w_30_512# m2_16574_4850# 018SRAM_cell1_dummy_3v64x8m81_61/m2_346_89#
+ 018SRAM_cell1_dummy_3v64x8m81_61/m2_134_89# VSUBS x018SRAM_cell1_dummy_3v64x8m81
X018SRAM_cell1_dummy_3v64x8m81_50 m2_16574_4850# VSUBS 018SRAM_cell1_3v64x8m81_1/w_30_512#
+ 018SRAM_cell1_3v64x8m81_1/w_30_512# m2_16574_4850# 018SRAM_cell1_dummy_3v64x8m81_50/m2_346_89#
+ 018SRAM_cell1_dummy_3v64x8m81_50/m2_134_89# VSUBS x018SRAM_cell1_dummy_3v64x8m81
X018SRAM_cell1_dummy_3v64x8m81_62 m2_16574_4850# VSUBS 018SRAM_cell1_3v64x8m81_1/w_30_512#
+ 018SRAM_cell1_3v64x8m81_1/w_30_512# m2_16574_4850# 018SRAM_cell1_dummy_3v64x8m81_62/m2_346_89#
+ 018SRAM_cell1_dummy_3v64x8m81_62/m2_134_89# VSUBS x018SRAM_cell1_dummy_3v64x8m81
X018SRAM_cell1_dummy_3v64x8m81_51 m2_16574_4850# VSUBS 018SRAM_cell1_3v64x8m81_1/w_30_512#
+ 018SRAM_cell1_3v64x8m81_1/w_30_512# m2_16574_4850# 018SRAM_cell1_dummy_3v64x8m81_51/m2_346_89#
+ 018SRAM_cell1_dummy_3v64x8m81_51/m2_134_89# VSUBS x018SRAM_cell1_dummy_3v64x8m81
X018SRAM_cell1_dummy_3v64x8m81_40 m2_16574_4850# VSUBS 018SRAM_cell1_3v64x8m81_1/w_30_512#
+ 018SRAM_cell1_3v64x8m81_1/w_30_512# m2_16574_4850# 018SRAM_cell1_dummy_3v64x8m81_40/m2_346_89#
+ 018SRAM_cell1_dummy_3v64x8m81_40/m2_134_89# VSUBS x018SRAM_cell1_dummy_3v64x8m81
X018SRAM_cell1_2x_3v64x8m81_1 m3_n631_83# 018SRAM_cell1_2x_3v64x8m81_6/018SRAM_cell1_3v64x8m81_1/w_30_512#
+ 018SRAM_cell1_2x_3v64x8m81_1/018SRAM_cell1_3v64x8m81_0/m3_82_330# 018SRAM_cell1_2x_3v64x8m81_1/018SRAM_cell1_3v64x8m81_0/a_248_342#
+ 018SRAM_cell1_2x_3v64x8m81_6/018SRAM_cell1_3v64x8m81_1/a_248_592# m3_n631_83# 018SRAM_cell1_2x_3v64x8m81_1/018SRAM_cell1_3v64x8m81_1/m3_82_330#
+ 018SRAM_cell1_2x_3v64x8m81_1/018SRAM_cell1_3v64x8m81_1/a_248_342# 018SRAM_cell1_2x_3v64x8m81_7/018SRAM_cell1_3v64x8m81_0/w_30_512#
+ 018SRAM_cell1_2x_3v64x8m81_7/018SRAM_cell1_3v64x8m81_0/a_248_592# 018SRAM_cell1_3v64x8m81_1/a_430_96#
+ VSUBS 018SRAM_cell1_3v64x8m81_1/a_110_96# x018SRAM_cell1_2x_3v64x8m81
X018SRAM_cell1_dummy_3v64x8m81_63 m2_16574_4850# VSUBS 018SRAM_cell1_3v64x8m81_1/w_30_512#
+ 018SRAM_cell1_3v64x8m81_1/w_30_512# m2_16574_4850# 018SRAM_cell1_dummy_3v64x8m81_63/m2_346_89#
+ 018SRAM_cell1_dummy_3v64x8m81_63/m2_134_89# VSUBS x018SRAM_cell1_dummy_3v64x8m81
X018SRAM_cell1_dummy_3v64x8m81_52 m2_16574_4850# VSUBS 018SRAM_cell1_3v64x8m81_1/w_30_512#
+ 018SRAM_cell1_3v64x8m81_1/w_30_512# m2_16574_4850# 018SRAM_cell1_dummy_3v64x8m81_52/m2_346_89#
+ 018SRAM_cell1_dummy_3v64x8m81_52/m2_134_89# VSUBS x018SRAM_cell1_dummy_3v64x8m81
X018SRAM_cell1_dummy_3v64x8m81_41 m2_16574_4850# VSUBS 018SRAM_cell1_3v64x8m81_1/w_30_512#
+ 018SRAM_cell1_3v64x8m81_1/w_30_512# m2_16574_4850# 018SRAM_cell1_dummy_3v64x8m81_41/m2_346_89#
+ 018SRAM_cell1_dummy_3v64x8m81_41/m2_134_89# VSUBS x018SRAM_cell1_dummy_3v64x8m81
X018SRAM_cell1_dummy_3v64x8m81_30 a_n547_178# VSUBS 018SRAM_cell1_3v64x8m81_0/w_30_512#
+ 018SRAM_cell1_3v64x8m81_0/w_30_512# a_n547_178# 018SRAM_cell1_dummy_3v64x8m81_30/m2_346_89#
+ 018SRAM_cell1_dummy_3v64x8m81_30/m2_134_89# VSUBS x018SRAM_cell1_dummy_3v64x8m81
X018SRAM_cell1_dummy_3v64x8m81_64 m2_16574_4850# VSUBS 018SRAM_cell1_3v64x8m81_1/w_30_512#
+ 018SRAM_cell1_3v64x8m81_1/w_30_512# m2_16574_4850# 018SRAM_cell1_dummy_3v64x8m81_64/m2_346_89#
+ 018SRAM_cell1_dummy_3v64x8m81_64/m2_134_89# VSUBS x018SRAM_cell1_dummy_3v64x8m81
X018SRAM_cell1_dummy_3v64x8m81_53 m2_16574_4850# VSUBS 018SRAM_cell1_3v64x8m81_1/w_30_512#
+ 018SRAM_cell1_3v64x8m81_1/w_30_512# m2_16574_4850# 018SRAM_cell1_dummy_3v64x8m81_53/m2_346_89#
+ 018SRAM_cell1_dummy_3v64x8m81_53/m2_134_89# VSUBS x018SRAM_cell1_dummy_3v64x8m81
X018SRAM_cell1_dummy_3v64x8m81_31 a_n547_178# VSUBS 018SRAM_cell1_3v64x8m81_0/w_30_512#
+ 018SRAM_cell1_3v64x8m81_0/w_30_512# a_n547_178# 018SRAM_cell1_dummy_3v64x8m81_31/m2_346_89#
+ 018SRAM_cell1_dummy_3v64x8m81_31/m2_134_89# VSUBS x018SRAM_cell1_dummy_3v64x8m81
X018SRAM_cell1_dummy_3v64x8m81_20 a_n547_178# VSUBS 018SRAM_cell1_3v64x8m81_0/w_30_512#
+ 018SRAM_cell1_3v64x8m81_0/w_30_512# a_n547_178# 018SRAM_cell1_dummy_3v64x8m81_20/m2_346_89#
+ 018SRAM_cell1_dummy_3v64x8m81_20/m2_134_89# VSUBS x018SRAM_cell1_dummy_3v64x8m81
X018SRAM_cell1_dummy_3v64x8m81_42 m2_16574_4850# VSUBS 018SRAM_cell1_3v64x8m81_1/w_30_512#
+ 018SRAM_cell1_3v64x8m81_1/w_30_512# m2_16574_4850# 018SRAM_cell1_dummy_3v64x8m81_42/m2_346_89#
+ 018SRAM_cell1_dummy_3v64x8m81_42/m2_134_89# VSUBS x018SRAM_cell1_dummy_3v64x8m81
X018SRAM_cell1_dummy_3v64x8m81_54 m2_16574_4850# VSUBS 018SRAM_cell1_3v64x8m81_1/w_30_512#
+ 018SRAM_cell1_3v64x8m81_1/w_30_512# m2_16574_4850# 018SRAM_cell1_dummy_3v64x8m81_54/m2_346_89#
+ 018SRAM_cell1_dummy_3v64x8m81_54/m2_134_89# VSUBS x018SRAM_cell1_dummy_3v64x8m81
X018SRAM_cell1_dummy_3v64x8m81_43 m2_16574_4850# VSUBS 018SRAM_cell1_3v64x8m81_1/w_30_512#
+ 018SRAM_cell1_3v64x8m81_1/w_30_512# m2_16574_4850# 018SRAM_cell1_dummy_3v64x8m81_43/m2_346_89#
+ 018SRAM_cell1_dummy_3v64x8m81_43/m2_134_89# VSUBS x018SRAM_cell1_dummy_3v64x8m81
X018SRAM_cell1_dummy_3v64x8m81_21 a_n547_178# VSUBS 018SRAM_cell1_3v64x8m81_0/w_30_512#
+ 018SRAM_cell1_3v64x8m81_0/w_30_512# a_n547_178# 018SRAM_cell1_dummy_3v64x8m81_21/m2_346_89#
+ 018SRAM_cell1_dummy_3v64x8m81_21/m2_134_89# VSUBS x018SRAM_cell1_dummy_3v64x8m81
X018SRAM_cell1_dummy_3v64x8m81_10 a_n547_178# VSUBS 018SRAM_cell1_3v64x8m81_0/w_30_512#
+ 018SRAM_cell1_3v64x8m81_0/w_30_512# a_n547_178# 018SRAM_cell1_dummy_3v64x8m81_10/m2_346_89#
+ 018SRAM_cell1_dummy_3v64x8m81_10/m2_134_89# VSUBS x018SRAM_cell1_dummy_3v64x8m81
X018SRAM_cell1_dummy_3v64x8m81_32 m2_16574_4850# VSUBS 018SRAM_cell1_3v64x8m81_1/w_30_512#
+ 018SRAM_cell1_3v64x8m81_1/w_30_512# m2_16574_4850# 018SRAM_cell1_dummy_3v64x8m81_32/m2_346_89#
+ 018SRAM_cell1_dummy_3v64x8m81_32/m2_134_89# VSUBS x018SRAM_cell1_dummy_3v64x8m81
Xpmos_5p04310591302097_3v64x8m81_0 pmos_5p04310591302097_3v64x8m81_0/D pmos_5p04310591302095_3v64x8m81_0/D
+ pmos_5p04310591302095_3v64x8m81_0/D w_15880_n13729# pmos_5p04310591302097_3v64x8m81_0/S
+ pmos_5p04310591302097_3v64x8m81_0/S pmos_5p04310591302097_3v64x8m81
X018SRAM_cell1_dummy_3v64x8m81_55 m2_16574_4850# VSUBS 018SRAM_cell1_3v64x8m81_1/w_30_512#
+ 018SRAM_cell1_3v64x8m81_1/w_30_512# m2_16574_4850# 018SRAM_cell1_dummy_3v64x8m81_55/m2_346_89#
+ 018SRAM_cell1_dummy_3v64x8m81_55/m2_134_89# VSUBS x018SRAM_cell1_dummy_3v64x8m81
X018SRAM_cell1_dummy_3v64x8m81_44 m2_16574_4850# VSUBS 018SRAM_cell1_3v64x8m81_1/w_30_512#
+ 018SRAM_cell1_3v64x8m81_1/w_30_512# m2_16574_4850# 018SRAM_cell1_dummy_3v64x8m81_44/m2_346_89#
+ 018SRAM_cell1_dummy_3v64x8m81_44/m2_134_89# VSUBS x018SRAM_cell1_dummy_3v64x8m81
X018SRAM_cell1_dummy_3v64x8m81_22 a_n547_178# VSUBS 018SRAM_cell1_3v64x8m81_0/w_30_512#
+ 018SRAM_cell1_3v64x8m81_0/w_30_512# a_n547_178# 018SRAM_cell1_dummy_3v64x8m81_22/m2_346_89#
+ 018SRAM_cell1_dummy_3v64x8m81_22/m2_134_89# VSUBS x018SRAM_cell1_dummy_3v64x8m81
X018SRAM_cell1_dummy_3v64x8m81_11 a_n547_178# VSUBS 018SRAM_cell1_3v64x8m81_0/w_30_512#
+ 018SRAM_cell1_3v64x8m81_0/w_30_512# a_n547_178# 018SRAM_cell1_dummy_3v64x8m81_11/m2_346_89#
+ 018SRAM_cell1_dummy_3v64x8m81_11/m2_134_89# VSUBS x018SRAM_cell1_dummy_3v64x8m81
X018SRAM_cell1_dummy_3v64x8m81_33 m2_16574_4850# VSUBS 018SRAM_cell1_3v64x8m81_1/w_30_512#
+ 018SRAM_cell1_3v64x8m81_1/w_30_512# m2_16574_4850# 018SRAM_cell1_dummy_3v64x8m81_33/m2_346_89#
+ 018SRAM_cell1_dummy_3v64x8m81_33/m2_134_89# VSUBS x018SRAM_cell1_dummy_3v64x8m81
X018SRAM_cell1_dummy_3v64x8m81_56 m2_16574_4850# VSUBS 018SRAM_cell1_3v64x8m81_1/w_30_512#
+ 018SRAM_cell1_3v64x8m81_1/w_30_512# m2_16574_4850# 018SRAM_cell1_dummy_3v64x8m81_56/m2_346_89#
+ 018SRAM_cell1_dummy_3v64x8m81_56/m2_134_89# VSUBS x018SRAM_cell1_dummy_3v64x8m81
X018SRAM_cell1_dummy_3v64x8m81_45 m2_16574_4850# VSUBS 018SRAM_cell1_3v64x8m81_1/w_30_512#
+ 018SRAM_cell1_3v64x8m81_1/w_30_512# m2_16574_4850# 018SRAM_cell1_dummy_3v64x8m81_45/m2_346_89#
+ 018SRAM_cell1_dummy_3v64x8m81_45/m2_134_89# VSUBS x018SRAM_cell1_dummy_3v64x8m81
X018SRAM_cell1_dummy_3v64x8m81_23 a_n547_178# VSUBS 018SRAM_cell1_3v64x8m81_0/w_30_512#
+ 018SRAM_cell1_3v64x8m81_0/w_30_512# a_n547_178# 018SRAM_cell1_dummy_3v64x8m81_23/m2_346_89#
+ 018SRAM_cell1_dummy_3v64x8m81_23/m2_134_89# VSUBS x018SRAM_cell1_dummy_3v64x8m81
X018SRAM_cell1_dummy_3v64x8m81_12 a_n547_178# VSUBS 018SRAM_cell1_3v64x8m81_0/w_30_512#
+ 018SRAM_cell1_3v64x8m81_0/w_30_512# a_n547_178# 018SRAM_cell1_dummy_3v64x8m81_12/m2_346_89#
+ 018SRAM_cell1_dummy_3v64x8m81_12/m2_134_89# VSUBS x018SRAM_cell1_dummy_3v64x8m81
X018SRAM_cell1_dummy_3v64x8m81_34 m2_16574_4850# VSUBS 018SRAM_cell1_3v64x8m81_1/w_30_512#
+ 018SRAM_cell1_3v64x8m81_1/w_30_512# m2_16574_4850# 018SRAM_cell1_dummy_3v64x8m81_34/m2_346_89#
+ 018SRAM_cell1_dummy_3v64x8m81_34/m2_134_89# VSUBS x018SRAM_cell1_dummy_3v64x8m81
Xpmos_5p04310591302095_3v64x8m81_0 pmos_5p04310591302095_3v64x8m81_0/D ypass_gate_3v64x8m81_0_0/pmos_5p0431059130201_3v64x8m81_0/D
+ ypass_gate_3v64x8m81_0_0/pmos_5p0431059130201_3v64x8m81_0/D pmos_5p04310591302095_3v64x8m81_0/S
+ pmos_5p04310591302095_3v64x8m81_0/S pmos_5p04310591302095_3v64x8m81_0/S pmos_5p04310591302095_3v64x8m81
X018SRAM_cell1_3v64x8m81_0 a_n547_178# VSUBS 018SRAM_cell1_3v64x8m81_0/w_30_512# a_n547_178#
+ 018SRAM_cell1_3v64x8m81_0/w_30_512# 018SRAM_cell1_3v64x8m81_1/a_430_96# 018SRAM_cell1_3v64x8m81_1/a_110_96#
+ VSUBS x018SRAM_cell1_3v64x8m81
X018SRAM_cell1_2x_3v64x8m81_6 m3_n631_83# 018SRAM_cell1_2x_3v64x8m81_8/018SRAM_cell1_3v64x8m81_1/w_30_512#
+ 018SRAM_cell1_2x_3v64x8m81_6/018SRAM_cell1_3v64x8m81_0/m3_82_330# 018SRAM_cell1_2x_3v64x8m81_6/018SRAM_cell1_3v64x8m81_0/a_248_342#
+ 018SRAM_cell1_2x_3v64x8m81_8/018SRAM_cell1_3v64x8m81_1/a_248_592# m3_n631_83# 018SRAM_cell1_2x_3v64x8m81_6/018SRAM_cell1_3v64x8m81_1/m3_82_330#
+ 018SRAM_cell1_2x_3v64x8m81_6/018SRAM_cell1_3v64x8m81_1/a_248_342# 018SRAM_cell1_2x_3v64x8m81_6/018SRAM_cell1_3v64x8m81_1/w_30_512#
+ 018SRAM_cell1_2x_3v64x8m81_6/018SRAM_cell1_3v64x8m81_1/a_248_592# 018SRAM_cell1_3v64x8m81_1/a_430_96#
+ VSUBS 018SRAM_cell1_3v64x8m81_1/a_110_96# x018SRAM_cell1_2x_3v64x8m81
X018SRAM_cell1_dummy_3v64x8m81_57 m2_16574_4850# VSUBS 018SRAM_cell1_3v64x8m81_1/w_30_512#
+ 018SRAM_cell1_3v64x8m81_1/w_30_512# m2_16574_4850# 018SRAM_cell1_dummy_3v64x8m81_57/m2_346_89#
+ 018SRAM_cell1_dummy_3v64x8m81_57/m2_134_89# VSUBS x018SRAM_cell1_dummy_3v64x8m81
X018SRAM_cell1_dummy_3v64x8m81_46 m2_16574_4850# VSUBS 018SRAM_cell1_3v64x8m81_1/w_30_512#
+ 018SRAM_cell1_3v64x8m81_1/w_30_512# m2_16574_4850# 018SRAM_cell1_dummy_3v64x8m81_46/m2_346_89#
+ 018SRAM_cell1_dummy_3v64x8m81_46/m2_134_89# VSUBS x018SRAM_cell1_dummy_3v64x8m81
X018SRAM_cell1_dummy_3v64x8m81_24 a_n547_178# VSUBS 018SRAM_cell1_3v64x8m81_0/w_30_512#
+ 018SRAM_cell1_3v64x8m81_0/w_30_512# a_n547_178# 018SRAM_cell1_dummy_3v64x8m81_24/m2_346_89#
+ 018SRAM_cell1_dummy_3v64x8m81_24/m2_134_89# VSUBS x018SRAM_cell1_dummy_3v64x8m81
X018SRAM_cell1_dummy_3v64x8m81_13 a_n547_178# VSUBS 018SRAM_cell1_3v64x8m81_0/w_30_512#
+ 018SRAM_cell1_3v64x8m81_0/w_30_512# a_n547_178# 018SRAM_cell1_dummy_3v64x8m81_13/m2_346_89#
+ 018SRAM_cell1_dummy_3v64x8m81_13/m2_134_89# VSUBS x018SRAM_cell1_dummy_3v64x8m81
X018SRAM_cell1_dummy_3v64x8m81_35 m2_16574_4850# VSUBS 018SRAM_cell1_3v64x8m81_1/w_30_512#
+ 018SRAM_cell1_3v64x8m81_1/w_30_512# m2_16574_4850# 018SRAM_cell1_dummy_3v64x8m81_35/m2_346_89#
+ 018SRAM_cell1_dummy_3v64x8m81_35/m2_134_89# VSUBS x018SRAM_cell1_dummy_3v64x8m81
X018SRAM_cell1_3v64x8m81_1 m2_16574_4850# VSUBS 018SRAM_cell1_3v64x8m81_1/w_30_512#
+ m3_n631_83# 018SRAM_cell1_3v64x8m81_1/w_30_512# 018SRAM_cell1_3v64x8m81_1/a_430_96#
+ 018SRAM_cell1_3v64x8m81_1/a_110_96# VSUBS x018SRAM_cell1_3v64x8m81
X018SRAM_cell1_2x_3v64x8m81_7 m3_n631_83# 018SRAM_cell1_2x_3v64x8m81_7/018SRAM_cell1_3v64x8m81_0/w_30_512#
+ 018SRAM_cell1_2x_3v64x8m81_7/018SRAM_cell1_3v64x8m81_0/m3_82_330# 018SRAM_cell1_2x_3v64x8m81_7/018SRAM_cell1_3v64x8m81_0/a_248_342#
+ 018SRAM_cell1_2x_3v64x8m81_7/018SRAM_cell1_3v64x8m81_0/a_248_592# m3_n631_83# 018SRAM_cell1_2x_3v64x8m81_7/018SRAM_cell1_3v64x8m81_1/m3_82_330#
+ 018SRAM_cell1_2x_3v64x8m81_7/018SRAM_cell1_3v64x8m81_1/a_248_342# 018SRAM_cell1_3v64x8m81_1/w_30_512#
+ 018SRAM_cell1_3v64x8m81_1/w_30_512# 018SRAM_cell1_3v64x8m81_1/a_430_96# VSUBS 018SRAM_cell1_3v64x8m81_1/a_110_96#
+ x018SRAM_cell1_2x_3v64x8m81
X018SRAM_cell1_dummy_3v64x8m81_25 a_n547_178# VSUBS 018SRAM_cell1_3v64x8m81_0/w_30_512#
+ 018SRAM_cell1_3v64x8m81_0/w_30_512# a_n547_178# 018SRAM_cell1_dummy_3v64x8m81_25/m2_346_89#
+ 018SRAM_cell1_dummy_3v64x8m81_25/m2_134_89# VSUBS x018SRAM_cell1_dummy_3v64x8m81
X018SRAM_cell1_dummy_3v64x8m81_14 a_n547_178# VSUBS 018SRAM_cell1_3v64x8m81_0/w_30_512#
+ 018SRAM_cell1_3v64x8m81_0/w_30_512# a_n547_178# 018SRAM_cell1_dummy_3v64x8m81_14/m2_346_89#
+ 018SRAM_cell1_dummy_3v64x8m81_14/m2_134_89# VSUBS x018SRAM_cell1_dummy_3v64x8m81
X018SRAM_cell1_dummy_3v64x8m81_36 m2_16574_4850# VSUBS 018SRAM_cell1_3v64x8m81_1/w_30_512#
+ 018SRAM_cell1_3v64x8m81_1/w_30_512# m2_16574_4850# 018SRAM_cell1_dummy_3v64x8m81_36/m2_346_89#
+ 018SRAM_cell1_dummy_3v64x8m81_36/m2_134_89# VSUBS x018SRAM_cell1_dummy_3v64x8m81
X018SRAM_cell1_dummy_3v64x8m81_47 m2_16574_4850# VSUBS 018SRAM_cell1_3v64x8m81_1/w_30_512#
+ 018SRAM_cell1_3v64x8m81_1/w_30_512# m2_16574_4850# 018SRAM_cell1_dummy_3v64x8m81_47/m2_346_89#
+ 018SRAM_cell1_dummy_3v64x8m81_47/m2_134_89# VSUBS x018SRAM_cell1_dummy_3v64x8m81
X018SRAM_cell1_2x_3v64x8m81_8 m3_n631_83# 018SRAM_cell1_3v64x8m81_0/w_30_512# 018SRAM_cell1_2x_3v64x8m81_8/018SRAM_cell1_3v64x8m81_0/m3_82_330#
+ 018SRAM_cell1_2x_3v64x8m81_8/018SRAM_cell1_3v64x8m81_0/a_248_342# 018SRAM_cell1_3v64x8m81_0/w_30_512#
+ m3_n631_83# 018SRAM_cell1_2x_3v64x8m81_8/018SRAM_cell1_3v64x8m81_1/m3_82_330# 018SRAM_cell1_2x_3v64x8m81_8/018SRAM_cell1_3v64x8m81_1/a_248_342#
+ 018SRAM_cell1_2x_3v64x8m81_8/018SRAM_cell1_3v64x8m81_1/w_30_512# 018SRAM_cell1_2x_3v64x8m81_8/018SRAM_cell1_3v64x8m81_1/a_248_592#
+ 018SRAM_cell1_3v64x8m81_1/a_430_96# VSUBS 018SRAM_cell1_3v64x8m81_1/a_110_96# x018SRAM_cell1_2x_3v64x8m81
X018SRAM_cell1_dummy_3v64x8m81_59 m2_16574_4850# VSUBS 018SRAM_cell1_3v64x8m81_1/w_30_512#
+ 018SRAM_cell1_3v64x8m81_1/w_30_512# m2_16574_4850# 018SRAM_cell1_dummy_3v64x8m81_59/m2_346_89#
+ 018SRAM_cell1_dummy_3v64x8m81_59/m2_134_89# VSUBS x018SRAM_cell1_dummy_3v64x8m81
X018SRAM_cell1_dummy_3v64x8m81_48 m2_16574_4850# VSUBS 018SRAM_cell1_3v64x8m81_1/w_30_512#
+ 018SRAM_cell1_3v64x8m81_1/w_30_512# m2_16574_4850# 018SRAM_cell1_dummy_3v64x8m81_48/m2_346_89#
+ 018SRAM_cell1_dummy_3v64x8m81_48/m2_134_89# VSUBS x018SRAM_cell1_dummy_3v64x8m81
X018SRAM_cell1_dummy_3v64x8m81_26 a_n547_178# VSUBS 018SRAM_cell1_3v64x8m81_0/w_30_512#
+ 018SRAM_cell1_3v64x8m81_0/w_30_512# a_n547_178# 018SRAM_cell1_dummy_3v64x8m81_26/m2_346_89#
+ 018SRAM_cell1_dummy_3v64x8m81_26/m2_134_89# VSUBS x018SRAM_cell1_dummy_3v64x8m81
X018SRAM_cell1_dummy_3v64x8m81_15 a_n547_178# VSUBS 018SRAM_cell1_3v64x8m81_0/w_30_512#
+ 018SRAM_cell1_3v64x8m81_0/w_30_512# a_n547_178# 018SRAM_cell1_dummy_3v64x8m81_15/m2_346_89#
+ 018SRAM_cell1_dummy_3v64x8m81_15/m2_134_89# VSUBS x018SRAM_cell1_dummy_3v64x8m81
X018SRAM_cell1_dummy_3v64x8m81_37 m2_16574_4850# VSUBS 018SRAM_cell1_3v64x8m81_1/w_30_512#
+ 018SRAM_cell1_3v64x8m81_1/w_30_512# m2_16574_4850# 018SRAM_cell1_dummy_3v64x8m81_37/m2_346_89#
+ 018SRAM_cell1_dummy_3v64x8m81_37/m2_134_89# VSUBS x018SRAM_cell1_dummy_3v64x8m81
X018SRAM_cell1_dummy_3v64x8m81_49 m2_16574_4850# VSUBS 018SRAM_cell1_3v64x8m81_1/w_30_512#
+ 018SRAM_cell1_3v64x8m81_1/w_30_512# m2_16574_4850# 018SRAM_cell1_dummy_3v64x8m81_49/m2_346_89#
+ 018SRAM_cell1_dummy_3v64x8m81_49/m2_134_89# VSUBS x018SRAM_cell1_dummy_3v64x8m81
X018SRAM_cell1_dummy_3v64x8m81_27 a_n547_178# VSUBS 018SRAM_cell1_3v64x8m81_0/w_30_512#
+ 018SRAM_cell1_3v64x8m81_0/w_30_512# a_n547_178# 018SRAM_cell1_dummy_3v64x8m81_27/m2_346_89#
+ 018SRAM_cell1_dummy_3v64x8m81_27/m2_134_89# VSUBS x018SRAM_cell1_dummy_3v64x8m81
X018SRAM_cell1_dummy_3v64x8m81_16 a_n547_178# VSUBS 018SRAM_cell1_3v64x8m81_0/w_30_512#
+ 018SRAM_cell1_3v64x8m81_0/w_30_512# a_n547_178# 018SRAM_cell1_dummy_3v64x8m81_16/m2_346_89#
+ 018SRAM_cell1_dummy_3v64x8m81_16/m2_134_89# VSUBS x018SRAM_cell1_dummy_3v64x8m81
X018SRAM_cell1_dummy_3v64x8m81_38 m2_16574_4850# VSUBS 018SRAM_cell1_3v64x8m81_1/w_30_512#
+ 018SRAM_cell1_3v64x8m81_1/w_30_512# m2_16574_4850# 018SRAM_cell1_dummy_3v64x8m81_38/m2_346_89#
+ 018SRAM_cell1_dummy_3v64x8m81_38/m2_134_89# VSUBS x018SRAM_cell1_dummy_3v64x8m81
X018SRAM_cell1_dummy_3v64x8m81_39 m2_16574_4850# VSUBS 018SRAM_cell1_3v64x8m81_1/w_30_512#
+ 018SRAM_cell1_3v64x8m81_1/w_30_512# m2_16574_4850# 018SRAM_cell1_dummy_3v64x8m81_39/m2_346_89#
+ 018SRAM_cell1_dummy_3v64x8m81_39/m2_134_89# VSUBS x018SRAM_cell1_dummy_3v64x8m81
X018SRAM_cell1_dummy_3v64x8m81_28 a_n547_178# VSUBS 018SRAM_cell1_3v64x8m81_0/w_30_512#
+ 018SRAM_cell1_3v64x8m81_0/w_30_512# a_n547_178# 018SRAM_cell1_dummy_3v64x8m81_28/m2_346_89#
+ 018SRAM_cell1_dummy_3v64x8m81_28/m2_134_89# VSUBS x018SRAM_cell1_dummy_3v64x8m81
X018SRAM_cell1_dummy_3v64x8m81_17 a_n547_178# VSUBS 018SRAM_cell1_3v64x8m81_0/w_30_512#
+ 018SRAM_cell1_3v64x8m81_0/w_30_512# a_n547_178# 018SRAM_cell1_dummy_3v64x8m81_17/m2_346_89#
+ 018SRAM_cell1_dummy_3v64x8m81_17/m2_134_89# VSUBS x018SRAM_cell1_dummy_3v64x8m81
X018SRAM_cell1_dummy_R_3v64x8m81_0 018SRAM_cell1_dummy_R_3v64x8m81_0/m3_82_330# 018SRAM_cell1_dummy_R_3v64x8m81_0/a_248_342#
+ m2_16574_4850# 018SRAM_cell1_dummy_R_3v64x8m81_0/w_30_512# ypass_gate_3v64x8m81_0_0/bb
+ ypass_gate_3v64x8m81_0_0/b 018SRAM_cell1_dummy_R_3v64x8m81_0/a_192_298# VSUBS x018SRAM_cell1_dummy_R_3v64x8m81
X018SRAM_cell1_dummy_3v64x8m81_29 a_n547_178# VSUBS 018SRAM_cell1_3v64x8m81_0/w_30_512#
+ 018SRAM_cell1_3v64x8m81_0/w_30_512# a_n547_178# 018SRAM_cell1_dummy_3v64x8m81_29/m2_346_89#
+ 018SRAM_cell1_dummy_3v64x8m81_29/m2_134_89# VSUBS x018SRAM_cell1_dummy_3v64x8m81
X018SRAM_cell1_dummy_3v64x8m81_18 a_n547_178# VSUBS 018SRAM_cell1_3v64x8m81_0/w_30_512#
+ 018SRAM_cell1_3v64x8m81_0/w_30_512# a_n547_178# 018SRAM_cell1_dummy_3v64x8m81_18/m2_346_89#
+ 018SRAM_cell1_dummy_3v64x8m81_18/m2_134_89# VSUBS x018SRAM_cell1_dummy_3v64x8m81
X018SRAM_cell1_dummy_3v64x8m81_0 a_n547_178# VSUBS 018SRAM_cell1_3v64x8m81_0/w_30_512#
+ 018SRAM_cell1_3v64x8m81_0/w_30_512# a_n547_178# 018SRAM_cell1_dummy_3v64x8m81_0/m2_346_89#
+ 018SRAM_cell1_dummy_3v64x8m81_0/m2_134_89# VSUBS x018SRAM_cell1_dummy_3v64x8m81
X018SRAM_cell1_dummy_3v64x8m81_19 a_n547_178# VSUBS 018SRAM_cell1_3v64x8m81_0/w_30_512#
+ 018SRAM_cell1_3v64x8m81_0/w_30_512# a_n547_178# 018SRAM_cell1_dummy_3v64x8m81_19/m2_346_89#
+ 018SRAM_cell1_dummy_3v64x8m81_19/m2_134_89# VSUBS x018SRAM_cell1_dummy_3v64x8m81
X018SRAM_cell1_dummy_3v64x8m81_1 a_n547_178# VSUBS 018SRAM_cell1_3v64x8m81_0/w_30_512#
+ 018SRAM_cell1_3v64x8m81_0/w_30_512# a_n547_178# 018SRAM_cell1_dummy_3v64x8m81_1/m2_346_89#
+ 018SRAM_cell1_dummy_3v64x8m81_1/m2_134_89# VSUBS x018SRAM_cell1_dummy_3v64x8m81
X018SRAM_cell1_dummy_R_3v64x8m81_2 018SRAM_cell1_dummy_R_3v64x8m81_2/m3_82_330# 018SRAM_cell1_dummy_R_3v64x8m81_2/a_248_342#
+ m2_16574_21# 018SRAM_cell1_dummy_R_3v64x8m81_2/w_30_512# ypass_gate_3v64x8m81_0_0/bb
+ ypass_gate_3v64x8m81_0_0/b 018SRAM_cell1_dummy_R_3v64x8m81_2/a_192_298# VSUBS x018SRAM_cell1_dummy_R_3v64x8m81
X018SRAM_cell1_dummy_3v64x8m81_2 a_n547_178# VSUBS 018SRAM_cell1_3v64x8m81_0/w_30_512#
+ 018SRAM_cell1_3v64x8m81_0/w_30_512# a_n547_178# 018SRAM_cell1_dummy_3v64x8m81_2/m2_346_89#
+ 018SRAM_cell1_dummy_3v64x8m81_2/m2_134_89# VSUBS x018SRAM_cell1_dummy_3v64x8m81
Xypass_gate_3v64x8m81_0_0 ypass_gate_3v64x8m81_0_0/bb ypass_gate_3v64x8m81_0_0/db
+ ypass_gate_3v64x8m81_0_0/ypass ypass_gate_3v64x8m81_0_0/d ypass_gate_3v64x8m81_0_0/pcb
+ ypass_gate_3v64x8m81_0_0/vdd_uq0 m3_15667_n7247# m3_15667_n6510# ypass_gate_3v64x8m81_0_0/vdd_uq0
+ VSUBS m3_15667_n6288# ypass_gate_3v64x8m81_0_0/b m3_15667_n5552# ypass_gate_3v64x8m81_0_0/vdd_uq0
+ m3_15667_n5798# ypass_gate_3v64x8m81_0_0/vss m3_15667_n6043# m3_15667_n7002# ypass_gate_3v64x8m81_0_0/pmos_5p0431059130201_3v64x8m81_0/D
+ ypass_gate_3v64x8m81_0_0/vdd m3_15667_n6752# ypass_gate_3v64x8m81_0_0/bb ypass_gate_3v64x8m81_0
X018SRAM_cell1_dummy_R_3v64x8m81_3 018SRAM_cell1_dummy_R_3v64x8m81_3/m3_82_330# 018SRAM_cell1_dummy_R_3v64x8m81_3/a_248_342#
+ m2_16574_21# 018SRAM_cell1_dummy_R_3v64x8m81_3/w_30_512# ypass_gate_3v64x8m81_0_0/bb
+ ypass_gate_3v64x8m81_0_0/b 018SRAM_cell1_dummy_R_3v64x8m81_3/a_192_298# VSUBS x018SRAM_cell1_dummy_R_3v64x8m81
X018SRAM_cell1_dummy_3v64x8m81_3 a_n547_178# VSUBS 018SRAM_cell1_3v64x8m81_0/w_30_512#
+ 018SRAM_cell1_3v64x8m81_0/w_30_512# a_n547_178# 018SRAM_cell1_dummy_3v64x8m81_3/m2_346_89#
+ 018SRAM_cell1_dummy_3v64x8m81_3/m2_134_89# VSUBS x018SRAM_cell1_dummy_3v64x8m81
X018SRAM_cell1_dummy_3v64x8m81_4 a_n547_178# VSUBS 018SRAM_cell1_3v64x8m81_0/w_30_512#
+ 018SRAM_cell1_3v64x8m81_0/w_30_512# a_n547_178# 018SRAM_cell1_dummy_3v64x8m81_4/m2_346_89#
+ 018SRAM_cell1_dummy_3v64x8m81_4/m2_134_89# VSUBS x018SRAM_cell1_dummy_3v64x8m81
X018SRAM_cell1_dummy_3v64x8m81_5 a_n547_178# VSUBS 018SRAM_cell1_3v64x8m81_0/w_30_512#
+ 018SRAM_cell1_3v64x8m81_0/w_30_512# a_n547_178# 018SRAM_cell1_dummy_3v64x8m81_5/m2_346_89#
+ 018SRAM_cell1_dummy_3v64x8m81_5/m2_134_89# VSUBS x018SRAM_cell1_dummy_3v64x8m81
X018SRAM_cell1_dummy_R_3v64x8m81_52 m2_16574_4850# VSUBS m2_16574_4850# 018SRAM_cell1_3v64x8m81_1/w_30_512#
+ ypass_gate_3v64x8m81_0_0/bb ypass_gate_3v64x8m81_0_0/b 018SRAM_cell1_3v64x8m81_1/w_30_512#
+ VSUBS x018SRAM_cell1_dummy_R_3v64x8m81
X018SRAM_cell1_dummy_3v64x8m81_6 a_n547_178# VSUBS 018SRAM_cell1_3v64x8m81_0/w_30_512#
+ 018SRAM_cell1_3v64x8m81_0/w_30_512# a_n547_178# 018SRAM_cell1_dummy_3v64x8m81_6/m2_346_89#
+ 018SRAM_cell1_dummy_3v64x8m81_6/m2_134_89# VSUBS x018SRAM_cell1_dummy_3v64x8m81
X018SRAM_cell1_dummy_3v64x8m81_7 a_n547_178# VSUBS 018SRAM_cell1_3v64x8m81_0/w_30_512#
+ 018SRAM_cell1_3v64x8m81_0/w_30_512# a_n547_178# 018SRAM_cell1_dummy_3v64x8m81_7/m2_346_89#
+ 018SRAM_cell1_dummy_3v64x8m81_7/m2_134_89# VSUBS x018SRAM_cell1_dummy_3v64x8m81
X018SRAM_cell1_dummy_R_3v64x8m81_10 018SRAM_cell1_dummy_R_3v64x8m81_10/m3_82_330#
+ 018SRAM_cell1_dummy_R_3v64x8m81_10/a_248_342# m2_16574_21# 018SRAM_cell1_dummy_R_3v64x8m81_0/w_30_512#
+ ypass_gate_3v64x8m81_0_0/bb ypass_gate_3v64x8m81_0_0/b 018SRAM_cell1_dummy_R_3v64x8m81_0/a_192_298#
+ VSUBS x018SRAM_cell1_dummy_R_3v64x8m81
Xnmos_5p04310591302098_3v64x8m81_0 pmos_5p04310591302095_3v64x8m81_0/D ypass_gate_3v64x8m81_0_0/pmos_5p0431059130201_3v64x8m81_0/D
+ ypass_gate_3v64x8m81_0_0/pmos_5p0431059130201_3v64x8m81_0/D VSUBS VSUBS VSUBS nmos_5p04310591302098_3v64x8m81
X018SRAM_cell1_dummy_3v64x8m81_8 a_n547_178# VSUBS 018SRAM_cell1_3v64x8m81_0/w_30_512#
+ 018SRAM_cell1_3v64x8m81_0/w_30_512# a_n547_178# 018SRAM_cell1_dummy_3v64x8m81_8/m2_346_89#
+ 018SRAM_cell1_dummy_3v64x8m81_8/m2_134_89# VSUBS x018SRAM_cell1_dummy_3v64x8m81
X018SRAM_cell1_dummy_R_3v64x8m81_11 018SRAM_cell1_dummy_R_3v64x8m81_11/m3_82_330#
+ 018SRAM_cell1_dummy_R_3v64x8m81_11/a_248_342# m2_16574_4850# 018SRAM_cell1_3v64x8m81_1/w_30_512#
+ ypass_gate_3v64x8m81_0_0/bb ypass_gate_3v64x8m81_0_0/b 018SRAM_cell1_3v64x8m81_1/w_30_512#
+ VSUBS x018SRAM_cell1_dummy_R_3v64x8m81
X018SRAM_cell1_dummy_R_3v64x8m81_9 018SRAM_cell1_dummy_R_3v64x8m81_9/m3_82_330# 018SRAM_cell1_dummy_R_3v64x8m81_9/a_248_342#
+ m2_16574_21# 018SRAM_cell1_3v64x8m81_0/w_30_512# ypass_gate_3v64x8m81_0_0/bb ypass_gate_3v64x8m81_0_0/b
+ 018SRAM_cell1_3v64x8m81_0/w_30_512# VSUBS x018SRAM_cell1_dummy_R_3v64x8m81
X018SRAM_cell1_dummy_3v64x8m81_9 a_n547_178# VSUBS 018SRAM_cell1_3v64x8m81_0/w_30_512#
+ 018SRAM_cell1_3v64x8m81_0/w_30_512# a_n547_178# 018SRAM_cell1_dummy_3v64x8m81_9/m2_346_89#
+ 018SRAM_cell1_dummy_3v64x8m81_9/m2_134_89# VSUBS x018SRAM_cell1_dummy_3v64x8m81
Xnmos_5p04310591302096_3v64x8m81_0 pmos_5p04310591302097_3v64x8m81_0/D pmos_5p04310591302095_3v64x8m81_0/D
+ pmos_5p04310591302095_3v64x8m81_0/D VSUBS VSUBS VSUBS nmos_5p04310591302096_3v64x8m81
X018SRAM_cell1_dummy_R_3v64x8m81_14 018SRAM_cell1_dummy_R_3v64x8m81_14/m3_82_330#
+ 018SRAM_cell1_dummy_R_3v64x8m81_14/a_248_342# m2_16574_21# 018SRAM_cell1_dummy_R_3v64x8m81_2/w_30_512#
+ ypass_gate_3v64x8m81_0_0/bb ypass_gate_3v64x8m81_0_0/b 018SRAM_cell1_dummy_R_3v64x8m81_2/a_192_298#
+ VSUBS x018SRAM_cell1_dummy_R_3v64x8m81
X018SRAM_cell1_dummy_R_3v64x8m81_18 018SRAM_cell1_dummy_R_3v64x8m81_18/m3_82_330#
+ 018SRAM_cell1_dummy_R_3v64x8m81_18/a_248_342# m2_16574_21# 018SRAM_cell1_dummy_R_3v64x8m81_3/w_30_512#
+ ypass_gate_3v64x8m81_0_0/bb ypass_gate_3v64x8m81_0_0/b 018SRAM_cell1_dummy_R_3v64x8m81_3/a_192_298#
+ VSUBS x018SRAM_cell1_dummy_R_3v64x8m81
.ends

.subckt rcol4_64_3v64x8m81 WL[8] WL[1] WL[6] tblhl din[7] q[5] q[6] q[7] din[5] din[6]
+ q[4] pcb[6] pcb[7] WEN[4] WEN[7] pcb[5] WEN[5] WEN[6] din[4] rarray4_64_3v64x8m81_0/m3_n1397_3931#
+ saout_m2_3v64x8m81_3/GWEN saout_m2_3v64x8m81_3/ypass[0] saout_m2_3v64x8m81_3/ypass[1]
+ saout_m2_3v64x8m81_3/ypass[2] WL[2] saout_m2_3v64x8m81_3/ypass[3] saout_m2_3v64x8m81_3/ypass[4]
+ rdummy_3v64x4_3v64x8m81_0/ypass_gate_3v64x8m81_0_0/pcb saout_m2_3v64x8m81_3/ypass[5]
+ saout_m2_3v64x8m81_3/ypass[6] saout_m2_3v64x8m81_3/ypass[7] WL[0] WL[4] WL[3] rdummy_3v64x4_3v64x8m81_0/m2_16574_4850#
+ rdummy_3v64x4_3v64x8m81_0/m2_16574_21# pcb[4] WL[5] VDD_uq4 VDD_uq5 saout_R_m2_3v64x8m81_3/men
+ VDD VDD_uq3 GWE VDD_uq1 WL[7] VDD_uq0 VDD_uq2 VSS VDD_uq6
Xrarray4_64_3v64x8m81_0 saout_m2_3v64x8m81_2/bb[5] saout_m2_3v64x8m81_3/b[2] saout_m2_3v64x8m81_3/b[3]
+ saout_R_m2_3v64x8m81_3/b[7] saout_R_m2_3v64x8m81_1/bb[4] saout_R_m2_3v64x8m81_1/bb[7]
+ saout_m2_3v64x8m81_2/b[5] saout_m2_3v64x8m81_2/b[3] saout_m2_3v64x8m81_3/bb[2] saout_R_m2_3v64x8m81_3/b[0]
+ saout_m2_3v64x8m81_3/b[4] saout_R_m2_3v64x8m81_3/b[3] WL[4] saout_R_m2_3v64x8m81_3/bb[7]
+ saout_R_m2_3v64x8m81_1/bb[2] saout_m2_3v64x8m81_3/b[7] WL[0] saout_R_m2_3v64x8m81_1/bb[3]
+ saout_m2_3v64x8m81_3/b[6] saout_R_m2_3v64x8m81_3/bb[6] saout_m2_3v64x8m81_2/bb[2]
+ saout_m2_3v64x8m81_2/bb[1] rarray4_64_3v64x8m81_0/m3_n1397_3931# saout_R_m2_3v64x8m81_1/bb[0]
+ saout_R_m2_3v64x8m81_1/bb[1] WL[1] saout_R_m2_3v64x8m81_3/bb[2] saout_m2_3v64x8m81_2/b[0]
+ saout_R_m2_3v64x8m81_1/b[4] saout_m2_3v64x8m81_3/b[0] saout_R_m2_3v64x8m81_3/bb[1]
+ saout_m2_3v64x8m81_2/b[6] saout_m2_3v64x8m81_2/b[4] saout_m2_3v64x8m81_2/b[7] saout_R_m2_3v64x8m81_3/b[5]
+ saout_R_m2_3v64x8m81_3/bb[4] saout_m2_3v64x8m81_3/b[5] saout_R_m2_3v64x8m81_1/b[6]
+ saout_R_m2_3v64x8m81_1/b[5] saout_m2_3v64x8m81_2/bb[3] WL[5] saout_R_m2_3v64x8m81_3/bb[3]
+ saout_m2_3v64x8m81_3/bb[4] saout_m2_3v64x8m81_3/b[1] saout_R_m2_3v64x8m81_1/b[2]
+ WL[3] saout_m2_3v64x8m81_3/bb[6] saout_R_m2_3v64x8m81_1/b[7] saout_m2_3v64x8m81_3/bb[7]
+ saout_R_m2_3v64x8m81_3/b[6] saout_R_m2_3v64x8m81_1/b[3] saout_m2_3v64x8m81_3/bb[5]
+ saout_m2_3v64x8m81_2/b[1] saout_m2_3v64x8m81_2/b[2] WL[2] saout_R_m2_3v64x8m81_3/bb[0]
+ saout_R_m2_3v64x8m81_1/b[0] saout_R_m2_3v64x8m81_1/b[1] saout_m2_3v64x8m81_3/bb[0]
+ saout_R_m2_3v64x8m81_3/b[2] saout_m2_3v64x8m81_2/bb[0] saout_m2_3v64x8m81_2/bb[6]
+ saout_R_m2_3v64x8m81_1/bb[5] saout_R_m2_3v64x8m81_1/bb[6] saout_m2_3v64x8m81_2/bb[4]
+ saout_m2_3v64x8m81_3/bb[3] saout_R_m2_3v64x8m81_3/b[1] saout_m2_3v64x8m81_3/bb[1]
+ saout_R_m2_3v64x8m81_3/bb[5] saout_m2_3v64x8m81_2/bb[7] saout_R_m2_3v64x8m81_3/b[4]
+ VDD_uq6 WL[7] VSS rarray4_64_3v64x8m81
Xsaout_m2_3v64x8m81_2 saout_m2_3v64x8m81_3/ypass[4] saout_m2_3v64x8m81_3/ypass[5]
+ saout_m2_3v64x8m81_2/men saout_m2_3v64x8m81_3/GWEN din[6] q[6] pcb[5] saout_m2_3v64x8m81_2/b[0]
+ saout_m2_3v64x8m81_2/b[3] VDD_uq3 saout_m2_3v64x8m81_2/vss_uq0 saout_m2_3v64x8m81_2/bb[1]
+ saout_m2_3v64x8m81_2/b[2] saout_m2_3v64x8m81_2/bb[5] saout_m2_3v64x8m81_2/b[5] saout_m2_3v64x8m81_2/bb[0]
+ saout_m2_3v64x8m81_2/bb[6] saout_m2_3v64x8m81_2/b[6] WEN[5] saout_m2_3v64x8m81_2/bb[2]
+ saout_m2_3v64x8m81_2/b[7] GWE saout_m2_3v64x8m81_2/bb[4] saout_m2_3v64x8m81_2/b[4]
+ saout_m2_3v64x8m81_3/ypass[0] VDD_uq4 saout_m2_3v64x8m81_3/ypass[1] saout_m2_3v64x8m81_3/ypass[7]
+ VDD saout_m2_3v64x8m81_3/ypass[2] saout_R_m2_3v64x8m81_3/men saout_m2_3v64x8m81_3/ypass[6]
+ VDD_uq0 VDD_uq2 VDD_uq6 VDD_uq1 VDD_uq5 VSS saout_m2_3v64x8m81_2/bb[3] saout_m2_3v64x8m81_2/bb[7]
+ saout_m2_3v64x8m81_2/b[1] saout_m2_3v64x8m81_3/ypass[3] saout_m2_3v64x8m81
Xsaout_m2_3v64x8m81_3 saout_m2_3v64x8m81_3/ypass[4] saout_m2_3v64x8m81_3/ypass[5]
+ saout_m2_3v64x8m81_3/men saout_m2_3v64x8m81_3/GWEN din[4] q[4] pcb[7] saout_m2_3v64x8m81_3/b[0]
+ saout_m2_3v64x8m81_3/b[3] VDD_uq3 saout_m2_3v64x8m81_3/vss_uq0 saout_m2_3v64x8m81_3/bb[1]
+ saout_m2_3v64x8m81_3/b[2] saout_m2_3v64x8m81_3/bb[5] saout_m2_3v64x8m81_3/b[5] saout_m2_3v64x8m81_3/bb[0]
+ saout_m2_3v64x8m81_3/bb[6] saout_m2_3v64x8m81_3/b[6] WEN[7] saout_m2_3v64x8m81_3/bb[2]
+ saout_m2_3v64x8m81_3/b[7] GWE saout_m2_3v64x8m81_3/bb[4] saout_m2_3v64x8m81_3/b[4]
+ saout_m2_3v64x8m81_3/ypass[0] VDD_uq4 saout_m2_3v64x8m81_3/ypass[1] saout_m2_3v64x8m81_3/ypass[7]
+ VDD saout_m2_3v64x8m81_3/ypass[2] saout_R_m2_3v64x8m81_3/men saout_m2_3v64x8m81_3/ypass[6]
+ VDD_uq0 VDD_uq2 VDD_uq6 VDD_uq1 VDD_uq5 VSS saout_m2_3v64x8m81_3/bb[3] saout_m2_3v64x8m81_3/bb[7]
+ saout_m2_3v64x8m81_3/b[1] saout_m2_3v64x8m81_3/ypass[3] saout_m2_3v64x8m81
Xsaout_R_m2_3v64x8m81_1 saout_m2_3v64x8m81_3/ypass[1] saout_m2_3v64x8m81_3/ypass[3]
+ saout_m2_3v64x8m81_3/ypass[4] saout_m2_3v64x8m81_3/ypass[5] saout_m2_3v64x8m81_3/ypass[0]
+ saout_m2_3v64x8m81_3/GWEN din[7] saout_R_m2_3v64x8m81_1/b[4] saout_R_m2_3v64x8m81_1/b[0]
+ saout_R_m2_3v64x8m81_1/bb[7] q[7] saout_R_m2_3v64x8m81_1/pcb saout_R_m2_3v64x8m81_1/vss_uq6
+ VDD saout_R_m2_3v64x8m81_1/pcb_uq0 saout_R_m2_3v64x8m81_1/datain_uq0 saout_R_m2_3v64x8m81_1/b[2]
+ saout_R_m2_3v64x8m81_1/b[5] saout_R_m2_3v64x8m81_1/bb[1] saout_R_m2_3v64x8m81_1/bb[6]
+ saout_R_m2_3v64x8m81_1/b[1] saout_R_m2_3v64x8m81_1/b[7] GWE saout_R_m2_3v64x8m81_1/bb[5]
+ saout_R_m2_3v64x8m81_1/bb[2] saout_m2_3v64x8m81_3/ypass[7] saout_m2_3v64x8m81_3/ypass[6]
+ saout_R_m2_3v64x8m81_1/bb[3] saout_R_m2_3v64x8m81_1/b[3] WEN[4] VDD_uq4 VDD_uq3
+ VDD_uq0 saout_R_m2_3v64x8m81_3/men saout_m2_3v64x8m81_3/ypass[2] pcb[4] VDD_uq2
+ VDD_uq6 VDD_uq1 VDD_uq5 saout_R_m2_3v64x8m81_1/bb[4] saout_R_m2_3v64x8m81_1/bb[0]
+ saout_R_m2_3v64x8m81_1/b[6] VSS saout_R_m2_3v64x8m81
Xsaout_R_m2_3v64x8m81_3 saout_m2_3v64x8m81_3/ypass[1] saout_m2_3v64x8m81_3/ypass[3]
+ saout_m2_3v64x8m81_3/ypass[4] saout_m2_3v64x8m81_3/ypass[5] saout_m2_3v64x8m81_3/ypass[0]
+ saout_m2_3v64x8m81_3/GWEN din[5] saout_R_m2_3v64x8m81_3/b[4] saout_R_m2_3v64x8m81_3/b[0]
+ saout_R_m2_3v64x8m81_3/bb[7] q[5] saout_R_m2_3v64x8m81_3/pcb saout_R_m2_3v64x8m81_3/vss_uq6
+ VDD saout_R_m2_3v64x8m81_3/pcb_uq0 saout_R_m2_3v64x8m81_3/datain_uq0 saout_R_m2_3v64x8m81_3/b[2]
+ saout_R_m2_3v64x8m81_3/b[5] saout_R_m2_3v64x8m81_3/bb[1] saout_R_m2_3v64x8m81_3/bb[6]
+ saout_R_m2_3v64x8m81_3/b[1] saout_R_m2_3v64x8m81_3/b[7] GWE saout_R_m2_3v64x8m81_3/bb[5]
+ saout_R_m2_3v64x8m81_3/bb[2] saout_m2_3v64x8m81_3/ypass[7] saout_m2_3v64x8m81_3/ypass[6]
+ saout_R_m2_3v64x8m81_3/bb[3] saout_R_m2_3v64x8m81_3/b[3] WEN[6] VDD_uq4 VDD_uq3
+ VDD_uq0 saout_R_m2_3v64x8m81_3/men saout_m2_3v64x8m81_3/ypass[2] pcb[6] VDD_uq2
+ VDD_uq6 VDD_uq1 VDD_uq5 saout_R_m2_3v64x8m81_3/bb[4] saout_R_m2_3v64x8m81_3/bb[0]
+ saout_R_m2_3v64x8m81_3/b[6] VSS saout_R_m2_3v64x8m81
Xrdummy_3v64x4_3v64x8m81_0 saout_R_m2_3v64x8m81_3/b[7] saout_R_m2_3v64x8m81_3/bb[7]
+ WL[5] tblhl saout_m2_3v64x8m81_2/b[7] saout_R_m2_3v64x8m81_1/b[5] VSS saout_m2_3v64x8m81_3/ypass[6]
+ VDD_uq6 WL[4] saout_m2_3v64x8m81_2/bb[7] saout_R_m2_3v64x8m81_1/bb[5] VSS saout_R_m2_3v64x8m81_3/b[1]
+ saout_R_m2_3v64x8m81_1/b[1] saout_R_m2_3v64x8m81_1/bb[1] saout_R_m2_3v64x8m81_3/bb[1]
+ saout_m2_3v64x8m81_2/b[7] saout_m2_3v64x8m81_2/bb[7] saout_R_m2_3v64x8m81_3/b[7]
+ VDD_uq3 saout_R_m2_3v64x8m81_3/bb[7] saout_R_m2_3v64x8m81_3/bb[0] saout_R_m2_3v64x8m81_3/b[0]
+ rdummy_3v64x4_3v64x8m81_0/ypass_gate_3v64x8m81_0_0/pcb WL[7] VSS saout_R_m2_3v64x8m81_1/b[3]
+ saout_m2_3v64x8m81_2/bb[6] VDD_uq6 saout_m2_3v64x8m81_2/b[6] saout_R_m2_3v64x8m81_1/bb[3]
+ WL[2] VSS saout_R_m2_3v64x8m81_1/bb[4] saout_R_m2_3v64x8m81_3/bb[0] saout_R_m2_3v64x8m81_1/b[4]
+ saout_R_m2_3v64x8m81_3/b[0] rdummy_3v64x4_3v64x8m81_0/ypass_gate_3v64x8m81_0_0/b
+ saout_R_m2_3v64x8m81_1/b[7] saout_R_m2_3v64x8m81_1/bb[7] tblhl saout_m2_3v64x8m81_3/b[3]
+ saout_m2_3v64x8m81_3/bb[3] saout_R_m2_3v64x8m81_3/bb[6] saout_R_m2_3v64x8m81_3/b[6]
+ VDD_uq6 saout_m2_3v64x8m81_2/bb[0] saout_R_m2_3v64x8m81_1/bb[2] saout_R_m2_3v64x8m81_1/b[2]
+ saout_m2_3v64x8m81_2/b[0] saout_R_m2_3v64x8m81_1/bb[0] saout_m2_3v64x8m81_3/bb[0]
+ saout_R_m2_3v64x8m81_1/b[0] saout_m2_3v64x8m81_3/b[0] saout_R_m2_3v64x8m81_1/bb[6]
+ saout_R_m2_3v64x8m81_1/b[6] saout_m2_3v64x8m81_3/b[5] saout_m2_3v64x8m81_3/bb[5]
+ saout_R_m2_3v64x8m81_3/bb[4] saout_R_m2_3v64x8m81_3/b[4] saout_m2_3v64x8m81_2/bb[4]
+ saout_R_m2_3v64x8m81_1/b[1] saout_R_m2_3v64x8m81_1/bb[1] saout_m2_3v64x8m81_2/b[4]
+ saout_m2_3v64x8m81_3/b[1] saout_R_m2_3v64x8m81_1/b[7] saout_m2_3v64x8m81_3/bb[1]
+ saout_R_m2_3v64x8m81_1/bb[7] saout_m2_3v64x8m81_3/bb[4] VSS saout_m2_3v64x8m81_3/b[4]
+ saout_R_m2_3v64x8m81_3/b[5] saout_m2_3v64x8m81_3/ypass[7] VDD_uq6 saout_R_m2_3v64x8m81_3/bb[5]
+ WL[3] VSS saout_m2_3v64x8m81_2/b[3] saout_R_m2_3v64x8m81_1/bb[0] saout_m2_3v64x8m81_2/bb[3]
+ saout_R_m2_3v64x8m81_1/b[0] VSS WL[4] saout_R_m2_3v64x8m81_1/b[2] saout_m2_3v64x8m81_3/bb[2]
+ saout_R_m2_3v64x8m81_1/bb[2] saout_m2_3v64x8m81_2/bb[0] saout_m2_3v64x8m81_3/b[2]
+ saout_m2_3v64x8m81_2/b[0] saout_m2_3v64x8m81_3/b[6] saout_m2_3v64x8m81_3/bb[6] saout_m2_3v64x8m81_3/ypass[3]
+ saout_R_m2_3v64x8m81_3/b[3] saout_R_m2_3v64x8m81_3/bb[3] VDD_uq6 VDD_uq6 saout_R_m2_3v64x8m81_3/bb[6]
+ saout_m2_3v64x8m81_2/bb[2] saout_m2_3v64x8m81_2/b[2] VDD_uq6 saout_R_m2_3v64x8m81_3/b[6]
+ saout_m2_3v64x8m81_3/ypass[4] saout_m2_3v64x8m81_3/b[3] WL[5] VDD_uq6 VSS saout_m2_3v64x8m81_3/bb[3]
+ saout_m2_3v64x8m81_2/b[1] saout_m2_3v64x8m81_2/bb[1] saout_m2_3v64x8m81_3/b[7] VDD_uq6
+ saout_m2_3v64x8m81_3/bb[7] VDD_uq6 saout_R_m2_3v64x8m81_3/bb[2] saout_R_m2_3v64x8m81_3/b[2]
+ rdummy_3v64x4_3v64x8m81_0/ypass_gate_3v64x8m81_0_0/b saout_R_m2_3v64x8m81_1/b[5]
+ VSS saout_R_m2_3v64x8m81_3/bb[4] saout_R_m2_3v64x8m81_3/b[4] saout_R_m2_3v64x8m81_1/bb[5]
+ saout_m2_3v64x8m81_3/b[5] saout_m2_3v64x8m81_3/ypass[0] saout_m2_3v64x8m81_3/bb[5]
+ saout_m2_3v64x8m81_2/bb[2] VDD_uq5 saout_m2_3v64x8m81_2/b[2] saout_m2_3v64x8m81_3/b[1]
+ saout_m2_3v64x8m81_3/bb[1] VSS WL[2] saout_m2_3v64x8m81_3/bb[0] saout_m2_3v64x8m81_3/b[0]
+ saout_R_m2_3v64x8m81_3/b[5] saout_R_m2_3v64x8m81_1/bb[6] saout_R_m2_3v64x8m81_1/b[6]
+ rarray4_64_3v64x8m81_0/m3_n1397_3931# WL[0] saout_R_m2_3v64x8m81_3/bb[5] VSS VSS
+ saout_m2_3v64x8m81_3/bb[4] saout_m2_3v64x8m81_3/b[4] saout_m2_3v64x8m81_2/b[3] saout_m2_3v64x8m81_2/bb[3]
+ saout_m2_3v64x8m81_3/b[2] VDD_uq3 saout_m2_3v64x8m81_3/bb[2] WL[3] WL[0] saout_m2_3v64x8m81_2/b[5]
+ VSS VSS saout_m2_3v64x8m81_2/bb[5] VDD_uq3 WL[1] saout_R_m2_3v64x8m81_3/b[3] VSS
+ VDD_uq6 saout_R_m2_3v64x8m81_3/bb[3] WL[7] VDD_uq6 VSS saout_m2_3v64x8m81_3/bb[6]
+ saout_m2_3v64x8m81_2/b[5] saout_m2_3v64x8m81_3/b[6] saout_m2_3v64x8m81_2/bb[5] saout_R_m2_3v64x8m81_3/b[1]
+ saout_R_m2_3v64x8m81_3/bb[1] WL[1] VSS saout_m2_3v64x8m81_2/b[1] saout_m2_3v64x8m81_2/bb[1]
+ saout_R_m2_3v64x8m81_1/b[3] VDD_uq6 saout_m2_3v64x8m81_3/ypass[5] rarray4_64_3v64x8m81_0/m3_n1397_3931#
+ VSS saout_R_m2_3v64x8m81_1/bb[3] VDD_uq6 saout_m2_3v64x8m81_2/bb[4] rdummy_3v64x4_3v64x8m81_0/m2_16574_21#
+ saout_m2_3v64x8m81_2/b[4] saout_R_m2_3v64x8m81_1/bb[4] saout_R_m2_3v64x8m81_1/b[4]
+ VDD_uq4 rdummy_3v64x4_3v64x8m81_0/m2_16574_4850# saout_m2_3v64x8m81_3/ypass[1] saout_R_m2_3v64x8m81_3/b[2]
+ saout_m2_3v64x8m81_2/bb[6] VSS saout_R_m2_3v64x8m81_3/bb[2] saout_m2_3v64x8m81_2/b[6]
+ saout_m2_3v64x8m81_3/b[7] VSS VSS VDD_uq6 saout_m2_3v64x8m81_3/bb[7] saout_m2_3v64x8m81_3/ypass[2]
+ rdummy_3v64x4_3v64x8m81
Xdcap_103_novia_3v64x8m81_0[0] VDD_uq6 VSS VDD_uq6 dcap_103_novia_3v64x8m81
Xdcap_103_novia_3v64x8m81_0[1] VDD_uq6 VSS VDD_uq6 dcap_103_novia_3v64x8m81
Xdcap_103_novia_3v64x8m81_0[2] VDD_uq6 VSS VDD_uq6 dcap_103_novia_3v64x8m81
Xdcap_103_novia_3v64x8m81_0[3] VDD_uq6 VSS VDD_uq6 dcap_103_novia_3v64x8m81
Xdcap_103_novia_3v64x8m81_0[4] VDD_uq6 VSS VDD_uq6 dcap_103_novia_3v64x8m81
Xdcap_103_novia_3v64x8m81_0[5] VDD_uq6 VSS VDD_uq6 dcap_103_novia_3v64x8m81
Xdcap_103_novia_3v64x8m81_0[6] VDD_uq6 VSS VDD_uq6 dcap_103_novia_3v64x8m81
Xdcap_103_novia_3v64x8m81_0[7] VDD_uq6 VSS VDD_uq6 dcap_103_novia_3v64x8m81
Xdcap_103_novia_3v64x8m81_0[8] VDD_uq6 VSS VDD_uq6 dcap_103_novia_3v64x8m81
Xdcap_103_novia_3v64x8m81_0[9] VDD_uq6 VSS VDD_uq6 dcap_103_novia_3v64x8m81
Xdcap_103_novia_3v64x8m81_0[10] VDD_uq6 VSS VDD_uq6 dcap_103_novia_3v64x8m81
Xdcap_103_novia_3v64x8m81_0[11] VDD_uq6 VSS VDD_uq6 dcap_103_novia_3v64x8m81
Xdcap_103_novia_3v64x8m81_0[12] VDD_uq6 VSS VDD_uq6 dcap_103_novia_3v64x8m81
Xdcap_103_novia_3v64x8m81_0[13] VDD_uq6 VSS VDD_uq6 dcap_103_novia_3v64x8m81
Xdcap_103_novia_3v64x8m81_0[14] VDD_uq6 VSS VDD_uq6 dcap_103_novia_3v64x8m81
Xdcap_103_novia_3v64x8m81_0[15] VDD_uq6 VSS VDD_uq6 dcap_103_novia_3v64x8m81
Xdcap_103_novia_3v64x8m81_0[16] VDD_uq6 VSS VDD_uq6 dcap_103_novia_3v64x8m81
Xdcap_103_novia_3v64x8m81_0[17] VDD_uq6 VSS VDD_uq6 dcap_103_novia_3v64x8m81
Xdcap_103_novia_3v64x8m81_0[18] VDD_uq6 VSS VDD_uq6 dcap_103_novia_3v64x8m81
Xdcap_103_novia_3v64x8m81_0[19] VDD_uq6 VSS VDD_uq6 dcap_103_novia_3v64x8m81
Xdcap_103_novia_3v64x8m81_0[20] VDD_uq6 VSS VDD_uq6 dcap_103_novia_3v64x8m81
Xdcap_103_novia_3v64x8m81_0[21] VDD_uq6 VSS VDD_uq6 dcap_103_novia_3v64x8m81
Xdcap_103_novia_3v64x8m81_0[22] VDD_uq6 VSS VDD_uq6 dcap_103_novia_3v64x8m81
Xdcap_103_novia_3v64x8m81_0[23] VDD_uq6 VSS VDD_uq6 dcap_103_novia_3v64x8m81
Xdcap_103_novia_3v64x8m81_0[24] VDD_uq6 VSS VDD_uq6 dcap_103_novia_3v64x8m81
Xdcap_103_novia_3v64x8m81_0[25] VDD_uq6 VSS VDD_uq6 dcap_103_novia_3v64x8m81
Xdcap_103_novia_3v64x8m81_0[26] VDD_uq6 VSS VDD_uq6 dcap_103_novia_3v64x8m81
Xdcap_103_novia_3v64x8m81_0[27] VDD_uq6 VSS VDD_uq6 dcap_103_novia_3v64x8m81
Xdcap_103_novia_3v64x8m81_0[28] VDD_uq6 VSS VDD_uq6 dcap_103_novia_3v64x8m81
Xdcap_103_novia_3v64x8m81_0[29] VDD_uq6 VSS VDD_uq6 dcap_103_novia_3v64x8m81
Xdcap_103_novia_3v64x8m81_0[30] VDD_uq6 VSS VDD_uq6 dcap_103_novia_3v64x8m81
Xdcap_103_novia_3v64x8m81_0[31] VDD_uq6 VSS VDD_uq6 dcap_103_novia_3v64x8m81
Xdcap_103_novia_3v64x8m81_0[32] VDD_uq6 VSS VDD_uq6 dcap_103_novia_3v64x8m81
Xdcap_103_novia_3v64x8m81_0[33] VDD_uq6 VSS VDD_uq6 dcap_103_novia_3v64x8m81
Xdcap_103_novia_3v64x8m81_0[34] VDD_uq6 VSS VDD_uq6 dcap_103_novia_3v64x8m81
Xdcap_103_novia_3v64x8m81_0[35] VDD_uq6 VSS VDD_uq6 dcap_103_novia_3v64x8m81
.ends

.subckt nmos_5p043105913020111_3v64x8m81 D a_0_n44# S VSUBS
X0 D a_0_n44# S VSUBS nfet_03v3 ad=0.5412p pd=3.34u as=0.5412p ps=3.34u w=1.23u l=0.28u
.ends

.subckt pmoscap_L1_W2_R270_3v64x8m81 m3_307_0# m3_600_0# M2_M1$04_R270_3v64x8m81_0/VSUBS
+ a_597_236# a_8_236# m1_38_36#
X0 a_597_236# M2_M1$04_R270_3v64x8m81_0/VSUBS a_8_236# m1_38_36# pfet_03v3 ad=1.1286p pd=6.01u as=1.1286p ps=6.01u w=2.565u l=2.505u
.ends

.subckt pmoscap_R270_3v64x8m81 m3_770_16# a_n126_928# a_n140_236# m3_152_0# w_n226_n219#
X0 a_n140_236# a_n126_928# a_n140_236# w_n226_n219# pfet_03v3 ad=1.20555p pd=6.07u as=0 ps=0 w=2.565u l=2.505u
X1 a_n140_236# a_n126_928# a_n140_236# w_n226_n219# pfet_03v3 ad=0.6733p pd=3.09u as=0 ps=0 w=2.565u l=2.505u
.ends

.subckt pmos_5p043105913020101_3v64x8m81 D a_0_n44# w_n174_n86# S
X0 D a_0_n44# S w_n174_n86# pfet_03v3 ad=1.353p pd=7.03u as=1.353p ps=7.03u w=3.075u l=0.28u
.ends

.subckt nmos_1p2_02_R270_3v64x8m81 nmos_5p04310591302044_3v64x8m81_0/S a_n14_n33#
+ nmos_5p04310591302044_3v64x8m81_0/D VSUBS
Xnmos_5p04310591302044_3v64x8m81_0 nmos_5p04310591302044_3v64x8m81_0/D a_n14_n33#
+ nmos_5p04310591302044_3v64x8m81_0/S VSUBS nmos_5p04310591302044_3v64x8m81
.ends

.subckt pmos_5p043105913020103_3v64x8m81 D_uq0 D a_265_n44# S_uq0 S a_n56_n44# a_104_n44#
+ w_n230_n86#
X0 D_uq0 a_265_n44# S_uq0 w_n230_n86# pfet_03v3 ad=2.0526p pd=10.21u as=1.22455p ps=5.19u w=4.665u l=0.28u
X1 D a_n56_n44# S w_n230_n86# pfet_03v3 ad=1.2129p pd=5.185u as=2.0526p ps=10.21u w=4.665u l=0.28u
X2 S_uq0 a_104_n44# D w_n230_n86# pfet_03v3 ad=1.22455p pd=5.19u as=1.2129p ps=5.185u w=4.665u l=0.28u
.ends

.subckt pmos_1p2_03_R270_3v64x8m81 pmos_5p043105913020103_3v64x8m81_0/S a_n69_n138#
+ pmos_5p043105913020103_3v64x8m81_0/S_uq0 a_90_n138# pmos_5p043105913020103_3v64x8m81_0/D
+ w_n138_n63# pmos_5p043105913020103_3v64x8m81_0/D_uq0 a_251_n138#
Xpmos_5p043105913020103_3v64x8m81_0 pmos_5p043105913020103_3v64x8m81_0/D_uq0 pmos_5p043105913020103_3v64x8m81_0/D
+ a_251_n138# pmos_5p043105913020103_3v64x8m81_0/S_uq0 pmos_5p043105913020103_3v64x8m81_0/S
+ a_n69_n138# a_90_n138# w_n138_n63# pmos_5p043105913020103_3v64x8m81
.ends

.subckt pmos_5p043105913020105_3v64x8m81 D a_0_n44# w_n174_n86# S
X0 D a_0_n44# S w_n174_n86# pfet_03v3 ad=0.5368p pd=3.32u as=0.5368p ps=3.32u w=1.22u l=0.28u
.ends

.subckt pmos_5p043105913020108_3v64x8m81 D a_n28_n44# a_132_n44# w_n202_n86# S_uq0
+ S
X0 D a_n28_n44# S w_n202_n86# pfet_03v3 ad=0.6669p pd=3.085u as=1.1286p ps=6.01u w=2.565u l=0.28u
X1 S_uq0 a_132_n44# D w_n202_n86# pfet_03v3 ad=1.1286p pd=6.01u as=0.6669p ps=3.085u w=2.565u l=0.28u
.ends

.subckt pmos_1p2_01_R270_3v64x8m81 pmos_5p043105913020108_3v64x8m81_0/S w_n246_n93#
+ pmos_5p043105913020108_3v64x8m81_0/S_uq0 pmos_5p043105913020108_3v64x8m81_0/D a_118_n33#
+ a_n41_n33#
Xpmos_5p043105913020108_3v64x8m81_0 pmos_5p043105913020108_3v64x8m81_0/D a_n41_n33#
+ a_118_n33# w_n246_n93# pmos_5p043105913020108_3v64x8m81_0/S_uq0 pmos_5p043105913020108_3v64x8m81_0/S
+ pmos_5p043105913020108_3v64x8m81
.ends

.subckt pmos_5p043105913020110_3v64x8m81 D a_0_n44# w_n174_n86# S
X0 D a_0_n44# S w_n174_n86# pfet_03v3 ad=0.3256p pd=2.36u as=0.3256p ps=2.36u w=0.74u l=0.28u
.ends

.subckt pmos_5p043105913020104_3v64x8m81 D a_n28_n44# a_132_n44# w_n202_n86# S_uq0
+ S
X0 D a_n28_n44# S w_n202_n86# pfet_03v3 ad=0.4004p pd=2.06u as=0.6776p ps=3.96u w=1.54u l=0.28u
X1 S_uq0 a_132_n44# D w_n202_n86# pfet_03v3 ad=0.6776p pd=3.96u as=0.4004p ps=2.06u w=1.54u l=0.28u
.ends

.subckt pmos_1p2_02_R270_3v64x8m81 pmos_5p043105913020104_3v64x8m81_0/S_uq0 pmos_5p043105913020104_3v64x8m81_0/D
+ a_118_n33# a_n41_n33# w_n138_n63# pmos_5p043105913020104_3v64x8m81_0/S
Xpmos_5p043105913020104_3v64x8m81_0 pmos_5p043105913020104_3v64x8m81_0/D a_n41_n33#
+ a_118_n33# w_n138_n63# pmos_5p043105913020104_3v64x8m81_0/S_uq0 pmos_5p043105913020104_3v64x8m81_0/S
+ pmos_5p043105913020104_3v64x8m81
.ends

.subckt nmos_5p043105913020109_3v64x8m81 D a_n28_n44# a_132_n44# S_uq0 S VSUBS
X0 D a_n28_n44# S VSUBS nfet_03v3 ad=0.4004p pd=2.06u as=0.6776p ps=3.96u w=1.54u l=0.28u
X1 S_uq0 a_132_n44# D VSUBS nfet_03v3 ad=0.6776p pd=3.96u as=0.4004p ps=2.06u w=1.54u l=0.28u
.ends

.subckt nmos_5p043105913020107_3v64x8m81 D a_n28_n44# a_132_n44# S_uq0 S VSUBS
X0 D a_n28_n44# S VSUBS nfet_03v3 ad=0.6058p pd=2.85u as=1.0252p ps=5.54u w=2.33u l=0.28u
X1 S_uq0 a_132_n44# D VSUBS nfet_03v3 ad=1.0252p pd=5.54u as=0.6058p ps=2.85u w=2.33u l=0.28u
.ends

.subckt nmos_5p043105913020106_3v64x8m81 D a_0_n44# S VSUBS
X0 D a_0_n44# S VSUBS nfet_03v3 ad=0.1601p pd=1.64u as=0.1601p ps=1.64u w=0.305u l=0.28u
.ends

.subckt xdec_3v64x8m81 RWL LWL men xc xb xa m2_11898_n156# m2_9070_n156# m2_7748_n156#
+ m2_8806_n156# m2_10577_n156# m2_10840_n156# m2_7219_n156# m2_7483_n156# m2_11634_n156#
+ m2_8277_n156# m2_12427_n156# m2_8541_n156# m2_11105_n156# m2_11370_n156# m2_8012_n156#
+ m2_12163_n156# vss vdd
Xnmos_1p2_02_R270_3v64x8m81_0 nmos_5p043105913020109_3v64x8m81_0/S pmos_5p043105913020105_3v64x8m81_3/S
+ vss vss nmos_1p2_02_R270_3v64x8m81
Xpmos_1p2_03_R270_3v64x8m81_0 LWL pmos_1p2_01_R270_3v64x8m81_1/pmos_5p043105913020108_3v64x8m81_0/D
+ LWL pmos_1p2_01_R270_3v64x8m81_1/pmos_5p043105913020108_3v64x8m81_0/D vdd vdd vdd
+ pmos_1p2_01_R270_3v64x8m81_1/pmos_5p043105913020108_3v64x8m81_0/D pmos_1p2_03_R270_3v64x8m81
Xpmos_5p043105913020103_3v64x8m81_0 vdd vdd pmos_1p2_01_R270_3v64x8m81_0/pmos_5p043105913020108_3v64x8m81_0/D
+ RWL RWL pmos_1p2_01_R270_3v64x8m81_0/pmos_5p043105913020108_3v64x8m81_0/D pmos_1p2_01_R270_3v64x8m81_0/pmos_5p043105913020108_3v64x8m81_0/D
+ vdd pmos_5p043105913020103_3v64x8m81
Xpmos_5p043105913020105_3v64x8m81_1 pmos_5p043105913020105_3v64x8m81_3/S xb vdd vdd
+ pmos_5p043105913020105_3v64x8m81
Xpmos_1p2_01_R270_3v64x8m81_0 vdd vdd vdd pmos_1p2_01_R270_3v64x8m81_0/pmos_5p043105913020108_3v64x8m81_0/D
+ nmos_5p043105913020109_3v64x8m81_0/S nmos_5p043105913020109_3v64x8m81_0/S pmos_1p2_01_R270_3v64x8m81
Xpmos_1p2_01_R270_3v64x8m81_1 vdd vdd vdd pmos_1p2_01_R270_3v64x8m81_1/pmos_5p043105913020108_3v64x8m81_0/D
+ nmos_5p043105913020109_3v64x8m81_0/S nmos_5p043105913020109_3v64x8m81_0/S pmos_1p2_01_R270_3v64x8m81
Xpmos_5p043105913020105_3v64x8m81_2 vdd xa vdd pmos_5p043105913020105_3v64x8m81_3/S
+ pmos_5p043105913020105_3v64x8m81
Xpmos_5p043105913020105_3v64x8m81_3 vdd xc vdd pmos_5p043105913020105_3v64x8m81_3/S
+ pmos_5p043105913020105_3v64x8m81
Xpmos_5p043105913020110_3v64x8m81_0 vdd pmos_5p043105913020105_3v64x8m81_3/S vdd pmos_5p043105913020110_3v64x8m81_0/S
+ pmos_5p043105913020110_3v64x8m81
Xpmos_1p2_02_R270_3v64x8m81_0 nmos_5p043105913020109_3v64x8m81_0/S men pmos_5p043105913020105_3v64x8m81_3/S
+ pmos_5p043105913020105_3v64x8m81_3/S vdd nmos_5p043105913020109_3v64x8m81_0/S pmos_1p2_02_R270_3v64x8m81
Xnmos_5p043105913020109_3v64x8m81_0 men pmos_5p043105913020110_3v64x8m81_0/S pmos_5p043105913020110_3v64x8m81_0/S
+ nmos_5p043105913020109_3v64x8m81_0/S nmos_5p043105913020109_3v64x8m81_0/S vss nmos_5p043105913020109_3v64x8m81
Xnmos_5p043105913020107_3v64x8m81_0 LWL pmos_1p2_01_R270_3v64x8m81_1/pmos_5p043105913020108_3v64x8m81_0/D
+ pmos_1p2_01_R270_3v64x8m81_1/pmos_5p043105913020108_3v64x8m81_0/D vss vss vss nmos_5p043105913020107_3v64x8m81
Xnmos_5p043105913020106_3v64x8m81_0 vss pmos_5p043105913020105_3v64x8m81_3/S pmos_5p043105913020110_3v64x8m81_0/S
+ vss nmos_5p043105913020106_3v64x8m81
Xnmos_5p043105913020107_3v64x8m81_1 RWL pmos_1p2_01_R270_3v64x8m81_0/pmos_5p043105913020108_3v64x8m81_0/D
+ pmos_1p2_01_R270_3v64x8m81_0/pmos_5p043105913020108_3v64x8m81_0/D vss vss vss nmos_5p043105913020107_3v64x8m81
X0 vss xc a_9450_422# vss nfet_03v3 ad=0.88935p pd=4.15u as=0.29032p ps=1.865u w=1.47u l=0.28u
X1 vss nmos_5p043105913020109_3v64x8m81_0/S pmos_1p2_01_R270_3v64x8m81_1/pmos_5p043105913020108_3v64x8m81_0/D vss nfet_03v3 ad=0.2796p pd=4.9u as=1.0252p ps=5.54u w=2.33u l=0.28u
X2 a_9450_280# xa pmos_5p043105913020105_3v64x8m81_3/S vss nfet_03v3 ad=0.31605p pd=1.9u as=0.74235p ps=3.95u w=1.47u l=0.28u
X3 a_9450_422# xb a_9450_280# vss nfet_03v3 ad=0.29032p pd=1.865u as=0.31605p ps=1.9u w=1.47u l=0.28u
X4 vss nmos_5p043105913020109_3v64x8m81_0/S pmos_1p2_01_R270_3v64x8m81_0/pmos_5p043105913020108_3v64x8m81_0/D vss nfet_03v3 ad=1.15335p pd=5.65u as=1.0718p ps=5.58u w=2.33u l=0.28u
.ends

.subckt xdec8_3v64x8m81 LWL[5] LWL[4] LWL[2] RWL[5] RWL[4] RWL[2] RWL[1] RWL[7] LWL[1]
+ LWL[7] LWL[6] LWL[0] LWL[3] xc xb xa[5] xa[7] xa[2] xb_uq1 xb_uq4 xc_uq1 xc_uq3
+ xc_uq4 xc_uq6 xdec_3v64x8m81_7/m2_11634_n156# xdec_3v64x8m81_7/m2_10577_n156# xdec_3v64x8m81_7/m2_12427_n156#
+ xb_uq6 xa[1] xb_uq3 xa[4] xdec_3v64x8m81_7/m2_11105_n156# xdec_3v64x8m81_7/m2_7219_n156#
+ xdec_3v64x8m81_7/m2_8806_n156# xdec_3v64x8m81_7/m2_10840_n156# xdec_3v64x8m81_7/m2_7483_n156#
+ xdec_3v64x8m81_7/m2_11370_n156# RWL[3] xc_uq2 xdec_3v64x8m81_7/m2_12163_n156# xc_uq0
+ xb_uq2 RWL[0] xc_uq5 xdec_3v64x8m81_7/m2_8012_n156# xb_uq0 xa[3] xb_uq5 xa[0] xa[6]
+ RWL[6] xdec_3v64x8m81_7/m2_8277_n156# xdec_3v64x8m81_7/m2_11898_n156# men vdd xdec_3v64x8m81_7/m2_9070_n156#
+ xdec_3v64x8m81_7/m2_7748_n156# vss xdec_3v64x8m81_7/m2_8541_n156#
Xxdec_3v64x8m81_0 RWL[6] LWL[6] men xc_uq5 xb_uq5 xa[6] xdec_3v64x8m81_7/m2_11898_n156#
+ xdec_3v64x8m81_7/m2_9070_n156# xdec_3v64x8m81_7/m2_7748_n156# xdec_3v64x8m81_7/m2_8806_n156#
+ xdec_3v64x8m81_7/m2_10577_n156# xdec_3v64x8m81_7/m2_10840_n156# xdec_3v64x8m81_7/m2_7219_n156#
+ xdec_3v64x8m81_7/m2_7483_n156# xdec_3v64x8m81_7/m2_11634_n156# xdec_3v64x8m81_7/m2_8277_n156#
+ xdec_3v64x8m81_7/m2_12427_n156# xdec_3v64x8m81_7/m2_8541_n156# xdec_3v64x8m81_7/m2_11105_n156#
+ xdec_3v64x8m81_7/m2_11370_n156# xdec_3v64x8m81_7/m2_8012_n156# xdec_3v64x8m81_7/m2_12163_n156#
+ vss vdd xdec_3v64x8m81
Xxdec_3v64x8m81_1 RWL[4] LWL[4] men xc_uq3 xb_uq3 xa[4] xdec_3v64x8m81_7/m2_11898_n156#
+ xdec_3v64x8m81_7/m2_9070_n156# xdec_3v64x8m81_7/m2_7748_n156# xdec_3v64x8m81_7/m2_8806_n156#
+ xdec_3v64x8m81_7/m2_10577_n156# xdec_3v64x8m81_7/m2_10840_n156# xdec_3v64x8m81_7/m2_7219_n156#
+ xdec_3v64x8m81_7/m2_7483_n156# xdec_3v64x8m81_7/m2_11634_n156# xdec_3v64x8m81_7/m2_8277_n156#
+ xdec_3v64x8m81_7/m2_12427_n156# xdec_3v64x8m81_7/m2_8541_n156# xdec_3v64x8m81_7/m2_11105_n156#
+ xdec_3v64x8m81_7/m2_11370_n156# xdec_3v64x8m81_7/m2_8012_n156# xdec_3v64x8m81_7/m2_12163_n156#
+ vss vdd xdec_3v64x8m81
Xxdec_3v64x8m81_2 RWL[2] LWL[2] men xc_uq1 xb_uq1 xa[2] xdec_3v64x8m81_7/m2_11898_n156#
+ xdec_3v64x8m81_7/m2_9070_n156# xdec_3v64x8m81_7/m2_7748_n156# xdec_3v64x8m81_7/m2_8806_n156#
+ xdec_3v64x8m81_7/m2_10577_n156# xdec_3v64x8m81_7/m2_10840_n156# xdec_3v64x8m81_7/m2_7219_n156#
+ xdec_3v64x8m81_7/m2_7483_n156# xdec_3v64x8m81_7/m2_11634_n156# xdec_3v64x8m81_7/m2_8277_n156#
+ xdec_3v64x8m81_7/m2_12427_n156# xdec_3v64x8m81_7/m2_8541_n156# xdec_3v64x8m81_7/m2_11105_n156#
+ xdec_3v64x8m81_7/m2_11370_n156# xdec_3v64x8m81_7/m2_8012_n156# xdec_3v64x8m81_7/m2_12163_n156#
+ vss vdd xdec_3v64x8m81
Xxdec_3v64x8m81_3 RWL[0] LWL[0] men xc_uq0 xb_uq0 xa[0] xdec_3v64x8m81_7/m2_11898_n156#
+ xdec_3v64x8m81_7/m2_9070_n156# xdec_3v64x8m81_7/m2_7748_n156# xdec_3v64x8m81_7/m2_8806_n156#
+ xdec_3v64x8m81_7/m2_10577_n156# xdec_3v64x8m81_7/m2_10840_n156# xdec_3v64x8m81_7/m2_7219_n156#
+ xdec_3v64x8m81_7/m2_7483_n156# xdec_3v64x8m81_7/m2_11634_n156# xdec_3v64x8m81_7/m2_8277_n156#
+ xdec_3v64x8m81_7/m2_12427_n156# xdec_3v64x8m81_7/m2_8541_n156# xdec_3v64x8m81_7/m2_11105_n156#
+ xdec_3v64x8m81_7/m2_11370_n156# xdec_3v64x8m81_7/m2_8012_n156# xdec_3v64x8m81_7/m2_12163_n156#
+ vss vdd xdec_3v64x8m81
Xxdec_3v64x8m81_4 RWL[7] LWL[7] men xc_uq6 xb_uq6 xa[7] xdec_3v64x8m81_7/m2_11898_n156#
+ xdec_3v64x8m81_7/m2_9070_n156# xdec_3v64x8m81_7/m2_7748_n156# xdec_3v64x8m81_7/m2_8806_n156#
+ xdec_3v64x8m81_7/m2_10577_n156# xdec_3v64x8m81_7/m2_10840_n156# xdec_3v64x8m81_7/m2_7219_n156#
+ xdec_3v64x8m81_7/m2_7483_n156# xdec_3v64x8m81_7/m2_11634_n156# xdec_3v64x8m81_7/m2_8277_n156#
+ xdec_3v64x8m81_7/m2_12427_n156# xdec_3v64x8m81_7/m2_8541_n156# xdec_3v64x8m81_7/m2_11105_n156#
+ xdec_3v64x8m81_7/m2_11370_n156# xdec_3v64x8m81_7/m2_8012_n156# xdec_3v64x8m81_7/m2_12163_n156#
+ vss vdd xdec_3v64x8m81
Xxdec_3v64x8m81_5 RWL[5] LWL[5] men xc_uq4 xb_uq4 xa[5] xdec_3v64x8m81_7/m2_11898_n156#
+ xdec_3v64x8m81_7/m2_9070_n156# xdec_3v64x8m81_7/m2_7748_n156# xdec_3v64x8m81_7/m2_8806_n156#
+ xdec_3v64x8m81_7/m2_10577_n156# xdec_3v64x8m81_7/m2_10840_n156# xdec_3v64x8m81_7/m2_7219_n156#
+ xdec_3v64x8m81_7/m2_7483_n156# xdec_3v64x8m81_7/m2_11634_n156# xdec_3v64x8m81_7/m2_8277_n156#
+ xdec_3v64x8m81_7/m2_12427_n156# xdec_3v64x8m81_7/m2_8541_n156# xdec_3v64x8m81_7/m2_11105_n156#
+ xdec_3v64x8m81_7/m2_11370_n156# xdec_3v64x8m81_7/m2_8012_n156# xdec_3v64x8m81_7/m2_12163_n156#
+ vss vdd xdec_3v64x8m81
Xxdec_3v64x8m81_6 RWL[3] LWL[3] men xc_uq2 xb_uq2 xa[3] xdec_3v64x8m81_7/m2_11898_n156#
+ xdec_3v64x8m81_7/m2_9070_n156# xdec_3v64x8m81_7/m2_7748_n156# xdec_3v64x8m81_7/m2_8806_n156#
+ xdec_3v64x8m81_7/m2_10577_n156# xdec_3v64x8m81_7/m2_10840_n156# xdec_3v64x8m81_7/m2_7219_n156#
+ xdec_3v64x8m81_7/m2_7483_n156# xdec_3v64x8m81_7/m2_11634_n156# xdec_3v64x8m81_7/m2_8277_n156#
+ xdec_3v64x8m81_7/m2_12427_n156# xdec_3v64x8m81_7/m2_8541_n156# xdec_3v64x8m81_7/m2_11105_n156#
+ xdec_3v64x8m81_7/m2_11370_n156# xdec_3v64x8m81_7/m2_8012_n156# xdec_3v64x8m81_7/m2_12163_n156#
+ vss vdd xdec_3v64x8m81
Xxdec_3v64x8m81_7 RWL[1] LWL[1] men xc xb xa[1] xdec_3v64x8m81_7/m2_11898_n156# xdec_3v64x8m81_7/m2_9070_n156#
+ xdec_3v64x8m81_7/m2_7748_n156# xdec_3v64x8m81_7/m2_8806_n156# xdec_3v64x8m81_7/m2_10577_n156#
+ xdec_3v64x8m81_7/m2_10840_n156# xdec_3v64x8m81_7/m2_7219_n156# xdec_3v64x8m81_7/m2_7483_n156#
+ xdec_3v64x8m81_7/m2_11634_n156# xdec_3v64x8m81_7/m2_8277_n156# xdec_3v64x8m81_7/m2_12427_n156#
+ xdec_3v64x8m81_7/m2_8541_n156# xdec_3v64x8m81_7/m2_11105_n156# xdec_3v64x8m81_7/m2_11370_n156#
+ xdec_3v64x8m81_7/m2_8012_n156# xdec_3v64x8m81_7/m2_12163_n156# vss vdd xdec_3v64x8m81
.ends

.subckt xdec32_3v64x8m81 LWL[6] LWL[7] LWL[0] LWL[1] LWL[2] LWL[3] LWL[4] LWL[5] RWL[7]
+ RWL[5] RWL[1] RWL[2] RWL[4] xa[0] xa[3] xb[3] xb[2] xb[1] xc xdec8_3v64x8m81_1/xdec_3v64x8m81_7/m2_7219_n156#
+ xdec8_3v64x8m81_1/xdec_3v64x8m81_7/m2_7483_n156# xa[5] xa[4] xa[1] xdec8_3v64x8m81_1/xdec_3v64x8m81_7/m2_7748_n156#
+ xa[2] RWL[3] vdd RWL[0] RWL[6] xa[7] men xa[6] vss xb[0]
Xxdec8_3v64x8m81_1 LWL[5] LWL[4] LWL[2] RWL[5] RWL[4] RWL[2] RWL[1] RWL[7] LWL[1]
+ LWL[7] LWL[6] LWL[0] LWL[3] xc xb[0] xa[5] xa[7] xa[2] xb[0] xb[0] xc xc xc xc xa[3]
+ xa[7] xa[0] xb[0] xa[1] xb[0] xa[4] xa[5] xdec8_3v64x8m81_1/xdec_3v64x8m81_7/m2_7219_n156#
+ xb[1] xa[6] xdec8_3v64x8m81_1/xdec_3v64x8m81_7/m2_7483_n156# xa[4] RWL[3] xc xa[1]
+ xc xb[0] RWL[0] xc xc xb[0] xa[3] xb[0] xa[0] xa[6] RWL[6] xb[3] xa[2] men vdd xb[0]
+ xdec8_3v64x8m81_1/xdec_3v64x8m81_7/m2_7748_n156# vss xb[2] xdec8_3v64x8m81
.ends

.subckt nmos_5p04310591302099_3v64x8m81 D a_0_n44# S VSUBS
X0 D a_0_n44# S VSUBS nfet_03v3 ad=2.0746p pd=10.31u as=2.0746p ps=10.31u w=4.715u l=0.28u
.ends

.subckt nmos_1p2_02_R90_3v64x8m81 nmos_5p04310591302099_3v64x8m81_0/S a_n14_n33# nmos_5p04310591302099_3v64x8m81_0/D
+ VSUBS
Xnmos_5p04310591302099_3v64x8m81_0 nmos_5p04310591302099_3v64x8m81_0/D a_n14_n33#
+ nmos_5p04310591302099_3v64x8m81_0/S VSUBS nmos_5p04310591302099_3v64x8m81
.ends

.subckt nmos_5p043105913020102_3v64x8m81 D a_0_n44# S VSUBS
X0 D a_0_n44# S VSUBS nfet_03v3 ad=1.353p pd=7.03u as=1.353p ps=7.03u w=3.075u l=0.28u
.ends

.subckt nmos_1p2_01_R270_3v64x8m81 nmos_5p043105913020102_3v64x8m81_0/D a_n14_n33#
+ nmos_5p043105913020102_3v64x8m81_0/S VSUBS
Xnmos_5p043105913020102_3v64x8m81_0 nmos_5p043105913020102_3v64x8m81_0/D a_n14_n33#
+ nmos_5p043105913020102_3v64x8m81_0/S VSUBS nmos_5p043105913020102_3v64x8m81
.ends

.subckt pmos_1p2_01_R90_3v64x8m81 w_n137_n63# a_n14_n33# pmos_5p043105913020101_3v64x8m81_0/S
+ pmos_5p043105913020101_3v64x8m81_0/D
Xpmos_5p043105913020101_3v64x8m81_0 pmos_5p043105913020101_3v64x8m81_0/D a_n14_n33#
+ w_n137_n63# pmos_5p043105913020101_3v64x8m81_0/S pmos_5p043105913020101_3v64x8m81
.ends

.subckt pmos_5p043105913020100_3v64x8m81 D a_n28_n44# a_132_n44# w_n202_n86# S_uq0
+ S
X0 D a_n28_n44# S w_n202_n86# pfet_03v3 ad=1.5314p pd=6.41u as=2.5916p ps=12.66u w=5.89u l=0.28u
X1 S_uq0 a_132_n44# D w_n202_n86# pfet_03v3 ad=2.5916p pd=12.66u as=1.5314p ps=6.41u w=5.89u l=0.28u
.ends

.subckt pmos_1p2_02_R90_3v64x8m81 pmos_5p043105913020100_3v64x8m81_0/S w_n138_n63#
+ pmos_5p043105913020100_3v64x8m81_0/S_uq0 pmos_5p043105913020100_3v64x8m81_0/D a_118_n33#
+ a_n41_n33#
Xpmos_5p043105913020100_3v64x8m81_0 pmos_5p043105913020100_3v64x8m81_0/D a_n41_n33#
+ a_118_n33# w_n138_n63# pmos_5p043105913020100_3v64x8m81_0/S_uq0 pmos_5p043105913020100_3v64x8m81_0/S
+ pmos_5p043105913020100_3v64x8m81
.ends

.subckt xdec64_3v64x8m81 DRWL DLWL LWL[5] LWL[4] LWL[3] LWL[2] LWL[0] LWL[6] LWL[7]
+ RWL[6] RWL[4] RWL[1] RWL[3] RWL[7] xb[0] xb[1] xb[2] xb[3] xa[7] xa[6] xa[5] xa[4]
+ xa[0] xa[3] xa[2] xa[1] RWL[2] men RWL[0] LWL[1] xc[0] xc[1] RWL[5] vdd vss
Xnmos_5p043105913020111_3v64x8m81_0 vss pmos_5p043105913020101_3v64x8m81_1/D nmos_5p043105913020111_3v64x8m81_0/S
+ vss nmos_5p043105913020111_3v64x8m81
Xnmos_5p043105913020111_3v64x8m81_1 vss pmos_5p043105913020101_3v64x8m81_1/D pmos_5p043105913020101_3v64x8m81_0/S
+ vss nmos_5p043105913020111_3v64x8m81
Xpmoscap_L1_W2_R270_3v64x8m81_0 DLWL vdd vss vdd vdd vdd pmoscap_L1_W2_R270_3v64x8m81
Xpmoscap_L1_W2_R270_3v64x8m81_1 DRWL vdd vss vdd vdd vdd pmoscap_L1_W2_R270_3v64x8m81
Xpmoscap_R270_3v64x8m81_21 LWL[6] vss vdd LWL[7] vdd pmoscap_R270_3v64x8m81
Xpmos_5p043105913020101_3v64x8m81_0 vdd pmos_5p043105913020101_3v64x8m81_1/D vdd pmos_5p043105913020101_3v64x8m81_0/S
+ pmos_5p043105913020101_3v64x8m81
Xpmoscap_R270_3v64x8m81_22 LWL[4] vss vdd LWL[5] vdd pmoscap_R270_3v64x8m81
Xxdec32_3v64x8m81_0 LWL[6] LWL[7] LWL[0] LWL[1] LWL[2] LWL[3] LWL[4] LWL[5] RWL[7]
+ RWL[5] RWL[1] RWL[2] RWL[4] xa[0] xa[3] xb[3] xb[2] xb[1] xc[0] vdd vdd xa[5] xa[4]
+ xa[1] xc[1] xa[2] RWL[3] vdd RWL[0] RWL[6] xa[7] men xa[6] vss xb[0] xdec32_3v64x8m81
Xpmos_5p043105913020101_3v64x8m81_1 pmos_5p043105913020101_3v64x8m81_1/D vss vdd men
+ pmos_5p043105913020101_3v64x8m81
Xpmoscap_R270_3v64x8m81_23 LWL[2] vss vdd LWL[3] vdd pmoscap_R270_3v64x8m81
Xpmoscap_R270_3v64x8m81_24 LWL[0] vss vdd LWL[1] vdd pmoscap_R270_3v64x8m81
Xnmos_1p2_02_R90_3v64x8m81_0 DLWL nmos_5p043105913020111_3v64x8m81_0/S vss vss nmos_1p2_02_R90_3v64x8m81
Xnmos_1p2_01_R270_3v64x8m81_0 men vdd pmos_5p043105913020101_3v64x8m81_1/D vss nmos_1p2_01_R270_3v64x8m81
Xpmoscap_R270_3v64x8m81_5 RWL[6] vss vdd RWL[7] vdd pmoscap_R270_3v64x8m81
Xpmos_1p2_01_R90_3v64x8m81_0 vdd pmos_5p043105913020101_3v64x8m81_1/D nmos_5p043105913020111_3v64x8m81_0/S
+ vdd pmos_1p2_01_R90_3v64x8m81
Xnmos_5p04310591302099_3v64x8m81_0 vss pmos_5p043105913020101_3v64x8m81_0/S DRWL vss
+ nmos_5p04310591302099_3v64x8m81
Xpmoscap_R270_3v64x8m81_6 RWL[4] vss vdd RWL[5] vdd pmoscap_R270_3v64x8m81
Xpmoscap_R270_3v64x8m81_7 RWL[2] vss vdd RWL[3] vdd pmoscap_R270_3v64x8m81
Xpmoscap_R270_3v64x8m81_8 RWL[0] vss vdd RWL[1] vdd pmoscap_R270_3v64x8m81
Xpmos_1p2_02_R90_3v64x8m81_0 vdd vdd vdd DLWL nmos_5p043105913020111_3v64x8m81_0/S
+ nmos_5p043105913020111_3v64x8m81_0/S pmos_1p2_02_R90_3v64x8m81
Xpmos_1p2_02_R90_3v64x8m81_1 vdd vdd vdd DRWL pmos_5p043105913020101_3v64x8m81_0/S
+ pmos_5p043105913020101_3v64x8m81_0/S pmos_1p2_02_R90_3v64x8m81
.ends

.subckt gf180mcu_ocd_ip_sram__sram64x8m8wm1 A[5] A[4] A[3] A[2] A[1] A[0] CEN CLK
+ D[7] D[6] D[5] D[4] D[3] D[2] D[1] D[0] GWEN Q[7] Q[6] Q[5] Q[4] Q[3] Q[2] Q[1]
+ Q[0] WEN[7] WEN[6] WEN[5] WEN[4] WEN[3] WEN[2] WEN[1] WEN[0] VSS VDD
Xcontrol_3v64x8_3v64x8m81_0 control_3v64x8_3v64x8m81_0/RYS[7] control_3v64x8_3v64x8m81_0/RYS[6]
+ control_3v64x8_3v64x8m81_0/RYS[5] control_3v64x8_3v64x8m81_0/RYS[4] control_3v64x8_3v64x8m81_0/RYS[3]
+ control_3v64x8_3v64x8m81_0/RYS[2] control_3v64x8_3v64x8m81_0/RYS[1] control_3v64x8_3v64x8m81_0/RYS[0]
+ control_3v64x8_3v64x8m81_0/LYS[0] control_3v64x8_3v64x8m81_0/LYS[1] control_3v64x8_3v64x8m81_0/LYS[2]
+ control_3v64x8_3v64x8m81_0/LYS[3] control_3v64x8_3v64x8m81_0/LYS[6] control_3v64x8_3v64x8m81_0/LYS[5]
+ control_3v64x8_3v64x8m81_0/LYS[4] control_3v64x8_3v64x8m81_0/LYS[7] rcol4_64_3v64x8m81_0/tblhl
+ control_3v64x8_3v64x8m81_0/IGWEN control_3v64x8_3v64x8m81_0/xb[3] control_3v64x8_3v64x8m81_0/xb[2]
+ control_3v64x8_3v64x8m81_0/xb[0] A[0] control_3v64x8_3v64x8m81_0/xb[1] control_3v64x8_3v64x8m81_0/xc[3]
+ control_3v64x8_3v64x8m81_0/xc[1] control_3v64x8_3v64x8m81_0/xc[2] control_3v64x8_3v64x8m81_0/xc[0]
+ VSS VSS CLK A[2] A[1] VSS A[3] A[4] A[5] VSS GWEN VDD CEN VDD xdec64_3v64x8m81_0/men
+ VDD xdec64_3v64x8m81_0/xa[3] xdec64_3v64x8m81_0/xa[4] xdec64_3v64x8m81_0/xa[5] xdec64_3v64x8m81_0/xa[6]
+ rcol4_64_3v64x8m81_0/GWE xdec64_3v64x8m81_0/xa[7] xdec64_3v64x8m81_0/xa[0] VDD xdec64_3v64x8m81_0/xa[1]
+ VDD VDD xdec64_3v64x8m81_0/xa[2] VSS VDD control_3v64x8_3v64x8m81
Xlcol4_64_3v64x8m81_0 lcol4_64_3v64x8m81_0/WL[8] lcol4_64_3v64x8m81_0/WL[6] D[3] Q[1]
+ Q[2] Q[3] lcol4_64_3v64x8m81_0/pcb[2] lcol4_64_3v64x8m81_0/pcb[3] lcol4_64_3v64x8m81_0/pcb[0]
+ lcol4_64_3v64x8m81_0/pcb[1] WEN[0] WEN[1] WEN[2] WEN[3] D[0] Q[0] control_3v64x8_3v64x8m81_0/LYS[0]
+ D[1] control_3v64x8_3v64x8m81_0/LYS[1] control_3v64x8_3v64x8m81_0/IGWEN D[2] control_3v64x8_3v64x8m81_0/LYS[2]
+ control_3v64x8_3v64x8m81_0/LYS[3] control_3v64x8_3v64x8m81_0/LYS[4] control_3v64x8_3v64x8m81_0/LYS[5]
+ control_3v64x8_3v64x8m81_0/LYS[6] xdec64_3v64x8m81_0/LWL[0] control_3v64x8_3v64x8m81_0/LYS[7]
+ xdec64_3v64x8m81_0/LWL[1] xdec64_3v64x8m81_0/LWL[2] xdec64_3v64x8m81_0/men xdec64_3v64x8m81_0/LWL[3]
+ xdec64_3v64x8m81_0/LWL[4] xdec64_3v64x8m81_0/LWL[5] xdec64_3v64x8m81_0/LWL[6] xdec64_3v64x8m81_0/LWL[7]
+ VDD VDD VDD VDD VDD VDD VDD VSS VDD rcol4_64_3v64x8m81_0/GWE lcol4_64_3v64x8m81
Xrcol4_64_3v64x8m81_0 rcol4_64_3v64x8m81_0/WL[8] xdec64_3v64x8m81_0/RWL[1] rcol4_64_3v64x8m81_0/WL[6]
+ rcol4_64_3v64x8m81_0/tblhl D[7] Q[5] Q[6] Q[7] D[5] D[6] Q[4] rcol4_64_3v64x8m81_0/pcb[6]
+ rcol4_64_3v64x8m81_0/pcb[7] WEN[7] WEN[4] rcol4_64_3v64x8m81_0/pcb[5] WEN[6] WEN[5]
+ D[4] xdec64_3v64x8m81_0/RWL[6] control_3v64x8_3v64x8m81_0/IGWEN control_3v64x8_3v64x8m81_0/RYS[0]
+ control_3v64x8_3v64x8m81_0/RYS[1] control_3v64x8_3v64x8m81_0/RYS[2] xdec64_3v64x8m81_0/RWL[2]
+ control_3v64x8_3v64x8m81_0/RYS[3] control_3v64x8_3v64x8m81_0/RYS[4] rcol4_64_3v64x8m81_0/pcb[4]
+ control_3v64x8_3v64x8m81_0/RYS[5] control_3v64x8_3v64x8m81_0/RYS[6] control_3v64x8_3v64x8m81_0/RYS[7]
+ xdec64_3v64x8m81_0/RWL[0] xdec64_3v64x8m81_0/RWL[4] xdec64_3v64x8m81_0/RWL[3] xdec64_3v64x8m81_0/DRWL
+ VSS rcol4_64_3v64x8m81_0/pcb[4] xdec64_3v64x8m81_0/RWL[5] VDD VDD xdec64_3v64x8m81_0/men
+ VDD VDD rcol4_64_3v64x8m81_0/GWE VDD xdec64_3v64x8m81_0/RWL[7] VDD VDD VSS VDD rcol4_64_3v64x8m81
Xxdec64_3v64x8m81_0 xdec64_3v64x8m81_0/DRWL xdec64_3v64x8m81_0/DLWL xdec64_3v64x8m81_0/LWL[5]
+ xdec64_3v64x8m81_0/LWL[4] xdec64_3v64x8m81_0/LWL[3] xdec64_3v64x8m81_0/LWL[2] xdec64_3v64x8m81_0/LWL[0]
+ xdec64_3v64x8m81_0/LWL[6] xdec64_3v64x8m81_0/LWL[7] xdec64_3v64x8m81_0/RWL[6] xdec64_3v64x8m81_0/RWL[4]
+ xdec64_3v64x8m81_0/RWL[1] xdec64_3v64x8m81_0/RWL[3] xdec64_3v64x8m81_0/RWL[7] VDD
+ VDD VDD VDD xdec64_3v64x8m81_0/xa[7] xdec64_3v64x8m81_0/xa[6] xdec64_3v64x8m81_0/xa[5]
+ xdec64_3v64x8m81_0/xa[4] xdec64_3v64x8m81_0/xa[0] xdec64_3v64x8m81_0/xa[3] xdec64_3v64x8m81_0/xa[2]
+ xdec64_3v64x8m81_0/xa[1] xdec64_3v64x8m81_0/RWL[2] xdec64_3v64x8m81_0/men xdec64_3v64x8m81_0/RWL[0]
+ xdec64_3v64x8m81_0/LWL[1] VDD VDD xdec64_3v64x8m81_0/RWL[5] VDD VSS xdec64_3v64x8m81
.ends
